** sch_path: /foss/designs/lit_compac_sky/verification/porting/sky_gilbert/tb/tb_gilbert_cell_mult.sch
**.subckt tb_gilbert_cell_mult
Vdd vdd GND {{vdd}}
.save i(vdd)
Vcmi vcmi GND {{vincm}}
Vref vref GND {{vref}}
I0 ibias GND {{ibias*power_m}}
I1 vdd ibias_ota {{ibias*power_m*fast_scale}}
Vd1 vdin1 GND {{vd1}}
E1 in1p vcmi VOL=' v(vdin1)/2 '
E2 in1n vcmi VOL=' -v(vdin1)/2 '
Vd2 vdin2 GND {{vd2}}
E4 in2p vcmi VOL=' v(vdin2)/2 '
E5 in2n vcmi VOL=' -v(vdin2)/2 '
x1 vdd vbias outp outn in1n in1p in2p in2n GND ibias vdd GND vcm_sense gt0 gt1 gt2 gt3 gt4 gilbert_cell
Cloadp outp GND {{c_load}}
Cloadn outn GND {{c_load}}
Vstb vbias vbias_ota dc 0 ac 0
Istb GND vbias dc 0 ac 0
x2 vdd vbias_ota vref vcm_sense GND ibias_ota vdd GND ota
Vgcode gcode GND {{gcode}}
Egt0 gt0 GND VOL=' v(vdd)*(1-(floor((v(gcode)+0.5)/1)-2*floor((v(gcode)+0.5)/2))) '
Egt1 gt1 GND VOL=' v(vdd)*(1-(floor((v(gcode)+0.5)/2)-2*floor((v(gcode)+0.5)/4))) '
Egt2 gt2 GND VOL=' v(vdd)*(1-(floor((v(gcode)+0.5)/4)-2*floor((v(gcode)+0.5)/8))) '
Egt3 gt3 GND VOL=' v(vdd)*(1-(floor((v(gcode)+0.5)/8)-2*floor((v(gcode)+0.5)/16))) '
Egt4 gt4 GND VOL=' v(vdd)*(1-(floor((v(gcode)+0.5)/16)-2*floor((v(gcode)+0.5)/32))) '
**** begin user architecture code

.temp {{ temp }}
.option SEED = {{ (seed|int) + 1 }}
.option method=gear

.control
save all
op
let idd_dc=-i(vdd)
let vb_dc = v(vbias)
let vocm_dc = (v(outp)+v(outn))/2
let vsense_dc = v(vcm_sense)

* run 1: voltage injection
alter vstb acmag=1
alter istb acmag=0
ac dec 40 0.1 10G
let tv = -v(vbias_ota)/v(vbias)

* run 2: current injection, i(vstb) flows from vbias into the OTA output
alter vstb acmag=0
alter istb acmag=1
ac dec 40 0.1 10G
let ii = i(vstb)
let ti = ii/(1-ii)
let tloop = (ac1.tv*ti - 1)/(ac1.tv + ti + 2)

* margins: worst PM over every unity crossing, GM at the first -180 deg crossing
let f = real(frequency)
let tdb = db(tloop)
let tph = 180/pi*cph(tloop)
let npts = length(tdb)
let t0_db = tdb[0]
let t0_re = real(tloop[0])
let ncross = 0
let pm = 999
let fu = 0
let gm_db = 999
let f180 = 0
let k = 1
while k < npts
  let a = tdb[k-1]
  let b = tdb[k]
  if (a >= 0 and b < 0) or (a < 0 and b >= 0)
    let fr = a/(a-b)
    let fc = f[k-1]*(f[k]/f[k-1])^fr
    let pc = tph[k-1] + fr*(tph[k]-tph[k-1])
    let ncross = ncross + 1
    if 180 + pc < pm
      let pm = 180 + pc
      let fu = fc
    end
  end
  if f180 = 0
    if tph[k-1] > -180 and tph[k] <= -180
      let fr = (tph[k-1]+180)/(tph[k-1]-tph[k])
      let f180 = f[k-1]*(f[k]/f[k-1])^fr
      let gm_db = -(tdb[k-1] + fr*(tdb[k]-tdb[k-1]))
    end
  end
  let k = k + 1
end
* no crossing while |T| > 1 at DC, or positive feedback at DC: flag as unstable
if ncross = 0 and t0_db > 0
  let pm = -999
end
if t0_re < 0
  let pm = -999
end

* operating point copied into the current plot for the capture
let vbias_dc = op1.vb_dc
let voutcm_dc = op1.vocm_dc
let vsense = op1.vsense_dc
let idd_dc=op1.idd_dc
quit
.endc

.lib /foss/pdks/sky130A/libs.tech/ngspice/sky130.lib.spice {{ corner_mos }}

**** end user architecture code
**.ends

* expanding   symbol:  lit_compac_sky/macros/gilbert_cell/schematic/xschem/gilbert_cell.sym # of pins=18
** sym_path: /foss/designs/lit_compac_sky/macros/gilbert_cell/schematic/xschem/gilbert_cell.sym
** sch_path: /foss/designs/lit_compac_sky/macros/gilbert_cell/schematic/xschem/gilbert_cell.sch
.subckt gilbert_cell vdd vbias outp outn in1n in1p in2p in2n vss ibias ntap ptap vcm gt0 gt1 gt2 gt3 gt4
*.iopin vdd
*.ipin in1n
*.opin outp
*.opin outn
*.iopin vss
*.ipin in1p
*.ipin in2n
*.ipin in2p
*.ipin vbias
*.ipin ibias
*.iopin ptap
*.opin vcm
*.iopin ntap
*.ipin gt0
*.ipin gt1
*.ipin gt2
*.ipin gt3
*.ipin gt4
XM5 qs1 net2 vss ptap sky130_fd_pr__nfet_01v8_lvt L={{mirror_l}} W={{20.0*mirror_scale}} nf={{(4*mirror_scale)|int}} ad={{(((4*mirror_scale+1)/2)|int)*5.0*0.29}} as={{(((4*mirror_scale+2)/2)|int)*5.0*0.29}} pd={{2*(((4*mirror_scale+1)/2)|int)*(5.0+0.29)}} ps={{2*(((4*mirror_scale+2)/2)|int)*(5.0+0.29)}} nrd={{0.29/(20.0*mirror_scale)}} nrs={{0.29/(20.0*mirror_scale)}} sa=0
+ sb=0 sd=0 mult={{1.0*power_m}} m={{1*power_m}}
XM6 qs2 net1 vss ptap sky130_fd_pr__nfet_01v8_lvt L={{mirror_l}} W={{20.0*mirror_scale}} nf={{(4*mirror_scale)|int}} ad={{(((4*mirror_scale+1)/2)|int)*5.0*0.29}} as={{(((4*mirror_scale+2)/2)|int)*5.0*0.29}} pd={{2*(((4*mirror_scale+1)/2)|int)*(5.0+0.29)}} ps={{2*(((4*mirror_scale+2)/2)|int)*(5.0+0.29)}} nrd={{0.29/(20.0*mirror_scale)}} nrs={{0.29/(20.0*mirror_scale)}} sa=0
+ sb=0 sd=0 mult={{1.0*power_m}} m={{1*power_m}}
XM7 outp in2n qd7 {{'qs1' if body_tied else 'ptap'}} sky130_fd_pr__{{quad_model}} L={{quad_l}} W={{(4*native_nf) if quad_model=='nfet_03v3_nvt' else (20.0*quad_scale)}} nf={{(native_nf) if quad_model=='nfet_03v3_nvt' else ((4*quad_scale)|int)}} ad={{((((native_nf+1)/2)|int)*4*0.29) if quad_model=='nfet_03v3_nvt' else ((((4*quad_scale+1)/2)|int)*5.0*0.29)}} as={{((((native_nf+2)/2)|int)*4*0.29) if quad_model=='nfet_03v3_nvt' else ((((4*quad_scale+2)/2)|int)*5.0*0.29)}} pd={{(2*(((native_nf+1)/2)|int)*4.29) if quad_model=='nfet_03v3_nvt' else (2*(((4*quad_scale+1)/2)|int)*(5.0+0.29))}} ps={{(2*(((native_nf+2)/2)|int)*4.29) if quad_model=='nfet_03v3_nvt' else (2*(((4*quad_scale+2)/2)|int)*(5.0+0.29))}} nrd={{0.29/((4*native_nf) if quad_model=='nfet_03v3_nvt' else (20.0*quad_scale))}} nrs={{0.29/((4*native_nf) if quad_model=='nfet_03v3_nvt' else (20.0*quad_scale))}} sa=0
+ sb=0 sd=0 mult={{1.0*power_m}} m={{1*power_m}}
XM9 outp in2p qd9 {{'qs2' if body_tied else 'ptap'}} sky130_fd_pr__{{quad_model}} L={{quad_l}} W={{(4*native_nf) if quad_model=='nfet_03v3_nvt' else (20.0*quad_scale)}} nf={{(native_nf) if quad_model=='nfet_03v3_nvt' else ((4*quad_scale)|int)}} ad={{((((native_nf+1)/2)|int)*4*0.29) if quad_model=='nfet_03v3_nvt' else ((((4*quad_scale+1)/2)|int)*5.0*0.29)}} as={{((((native_nf+2)/2)|int)*4*0.29) if quad_model=='nfet_03v3_nvt' else ((((4*quad_scale+2)/2)|int)*5.0*0.29)}} pd={{(2*(((native_nf+1)/2)|int)*4.29) if quad_model=='nfet_03v3_nvt' else (2*(((4*quad_scale+1)/2)|int)*(5.0+0.29))}} ps={{(2*(((native_nf+2)/2)|int)*4.29) if quad_model=='nfet_03v3_nvt' else (2*(((4*quad_scale+2)/2)|int)*(5.0+0.29))}} nrd={{0.29/((4*native_nf) if quad_model=='nfet_03v3_nvt' else (20.0*quad_scale))}} nrs={{0.29/((4*native_nf) if quad_model=='nfet_03v3_nvt' else (20.0*quad_scale))}} sa=0
+ sb=0 sd=0 mult={{1.0*power_m}} m={{1*power_m}}
XM10 outn in2n qd10 {{'qs2' if body_tied else 'ptap'}} sky130_fd_pr__{{quad_model}} L={{quad_l}} W={{(4*native_nf) if quad_model=='nfet_03v3_nvt' else (20.0*quad_scale)}} nf={{(native_nf) if quad_model=='nfet_03v3_nvt' else ((4*quad_scale)|int)}} ad={{((((native_nf+1)/2)|int)*4*0.29) if quad_model=='nfet_03v3_nvt' else ((((4*quad_scale+1)/2)|int)*5.0*0.29)}} as={{((((native_nf+2)/2)|int)*4*0.29) if quad_model=='nfet_03v3_nvt' else ((((4*quad_scale+2)/2)|int)*5.0*0.29)}} pd={{(2*(((native_nf+1)/2)|int)*4.29) if quad_model=='nfet_03v3_nvt' else (2*(((4*quad_scale+1)/2)|int)*(5.0+0.29))}} ps={{(2*(((native_nf+2)/2)|int)*4.29) if quad_model=='nfet_03v3_nvt' else (2*(((4*quad_scale+2)/2)|int)*(5.0+0.29))}} nrd={{0.29/((4*native_nf) if quad_model=='nfet_03v3_nvt' else (20.0*quad_scale))}} nrs={{0.29/((4*native_nf) if quad_model=='nfet_03v3_nvt' else (20.0*quad_scale))}} sa=0
+ sb=0 sd=0 mult={{1.0*power_m}} m={{1*power_m}}
XM8 outn in2p qd8 {{'qs1' if body_tied else 'ptap'}} sky130_fd_pr__{{quad_model}} L={{quad_l}} W={{(4*native_nf) if quad_model=='nfet_03v3_nvt' else (20.0*quad_scale)}} nf={{(native_nf) if quad_model=='nfet_03v3_nvt' else ((4*quad_scale)|int)}} ad={{((((native_nf+1)/2)|int)*4*0.29) if quad_model=='nfet_03v3_nvt' else ((((4*quad_scale+1)/2)|int)*5.0*0.29)}} as={{((((native_nf+2)/2)|int)*4*0.29) if quad_model=='nfet_03v3_nvt' else ((((4*quad_scale+2)/2)|int)*5.0*0.29)}} pd={{(2*(((native_nf+1)/2)|int)*4.29) if quad_model=='nfet_03v3_nvt' else (2*(((4*quad_scale+1)/2)|int)*(5.0+0.29))}} ps={{(2*(((native_nf+2)/2)|int)*4.29) if quad_model=='nfet_03v3_nvt' else (2*(((4*quad_scale+2)/2)|int)*(5.0+0.29))}} nrd={{0.29/((4*native_nf) if quad_model=='nfet_03v3_nvt' else (20.0*quad_scale))}} nrs={{0.29/((4*native_nf) if quad_model=='nfet_03v3_nvt' else (20.0*quad_scale))}} sa=0
+ sb=0 sd=0 mult={{1.0*power_m}} m={{1*power_m}}
XM11 outp vbias vdd ntap sky130_fd_pr__pfet_01v8_lvt L=1 W=32 nf=8 ad=4.64 as=5.8 pd=34.32 ps=42.9 nrd={{0.29/(32)}} nrs={{0.29/(32)}}
+ sa=0 sb=0 sd=0 mult={{1.0*power_m}} m={{1*power_m}}
XM12 outn vbias vdd ntap sky130_fd_pr__pfet_01v8_lvt L=1 W=32 nf=8 ad=4.64 as=5.8 pd=34.32 ps=42.9 nrd={{0.29/(32)}} nrs={{0.29/(32)}}
+ sa=0 sb=0 sd=0 mult={{1.0*power_m}} m={{1*power_m}}
XM1 net1 in1n vcm1 ntap sky130_fd_pr__pfet_01v8_lvt L={{pair_l}} W={{74.625*pair_scale}} nf={{(12*pair_scale)|int}} ad={{(((12*pair_scale+1)/2)|int)*6.21875*0.29}} as={{(((12*pair_scale+2)/2)|int)*6.21875*0.29}} pd={{2*(((12*pair_scale+1)/2)|int)*(6.21875+0.29)}} ps={{2*(((12*pair_scale+2)/2)|int)*(6.21875+0.29)}}
+ nrd={{0.29/(74.625*pair_scale)}} nrs={{0.29/(74.625*pair_scale)}} sa=0 sb=0 sd=0 mult={{1.0*power_m}} m={{1*power_m}}
XM13 vcm1 ibias vdd ntap sky130_fd_pr__pfet_01v8_lvt L=0.65 W={{40.0*tail_width}} nf={{(4*tail_width)|int}} ad={{(((4*tail_width+1)/2)|int)*10.0*0.29}} as={{(((4*tail_width+2)/2)|int)*10.0*0.29}} pd={{2*(((4*tail_width+1)/2)|int)*(10.0+0.29)}} ps={{2*(((4*tail_width+2)/2)|int)*(10.0+0.29)}} nrd={{0.29/(40.0*tail_width)}} nrs={{0.29/(40.0*tail_width)}} sa=0
+ sb=0 sd=0 mult={{8.0*power_m}} m={{8.0*power_m}}
XM3 net1 net1 vss ptap sky130_fd_pr__nfet_01v8_lvt L={{mirror_l}} W={{20.0*mirror_scale}} nf={{(4*mirror_scale)|int}} ad={{(((4*mirror_scale+1)/2)|int)*5.0*0.29}} as={{(((4*mirror_scale+2)/2)|int)*5.0*0.29}} pd={{2*(((4*mirror_scale+1)/2)|int)*(5.0+0.29)}} ps={{2*(((4*mirror_scale+2)/2)|int)*(5.0+0.29)}} nrd={{0.29/(20.0*mirror_scale)}} nrs={{0.29/(20.0*mirror_scale)}} sa=0
+ sb=0 sd=0 mult={{1.0*power_m}} m={{1*power_m}}
XM4 net2 net2 vss ptap sky130_fd_pr__nfet_01v8_lvt L={{mirror_l}} W={{20.0*mirror_scale}} nf={{(4*mirror_scale)|int}} ad={{(((4*mirror_scale+1)/2)|int)*5.0*0.29}} as={{(((4*mirror_scale+2)/2)|int)*5.0*0.29}} pd={{2*(((4*mirror_scale+1)/2)|int)*(5.0+0.29)}} ps={{2*(((4*mirror_scale+2)/2)|int)*(5.0+0.29)}} nrd={{0.29/(20.0*mirror_scale)}} nrs={{0.29/(20.0*mirror_scale)}} sa=0
+ sb=0 sd=0 mult={{1.0*power_m}} m={{1*power_m}}
XM2 net2 in1p vcm1 ntap sky130_fd_pr__pfet_01v8_lvt L={{pair_l}} W={{74.625*pair_scale}} nf={{(12*pair_scale)|int}} ad={{(((12*pair_scale+1)/2)|int)*6.21875*0.29}} as={{(((12*pair_scale+2)/2)|int)*6.21875*0.29}} pd={{2*(((12*pair_scale+1)/2)|int)*(6.21875+0.29)}} ps={{2*(((12*pair_scale+2)/2)|int)*(6.21875+0.29)}}
+ nrd={{0.29/(74.625*pair_scale)}} nrs={{0.29/(74.625*pair_scale)}} sa=0 sb=0 sd=0 mult={{1.0*power_m}} m={{1*power_m}}
XM14 ibias ibias vdd ntap sky130_fd_pr__pfet_01v8_lvt L=0.65 W={{40.0*tail_width}} nf={{(4*tail_width)|int}} ad={{(((4*tail_width+1)/2)|int)*10.0*0.29}} as={{(((4*tail_width+2)/2)|int)*10.0*0.29}} pd={{2*(((4*tail_width+1)/2)|int)*(10.0+0.29)}} ps={{2*(((4*tail_width+2)/2)|int)*(10.0+0.29)}} nrd={{0.29/(40.0*tail_width)}} nrs={{0.29/(40.0*tail_width)}}
+ sa=0 sb=0 sd=0 mult={{1.0*power_m}} m={{1*power_m}}
Rtap_R1 vss ptap 1m
XR7 t4p outp ptap sky130_fd_pr__res_high_po_5p73 L={{((68.05+56.46*13.035)*rscale-68.05)/56.46}} mult={{1.0*power_m}} m={{1*power_m}}
XR5 outn t4n ptap sky130_fd_pr__res_high_po_5p73 L={{((68.05+56.46*13.035)*rscale-68.05)/56.46}} mult={{1.0*power_m}} m={{1*power_m}}
Rtap_R2 vdd ntap 1m
xtrim t4p t4n vcm gt0 gt1 gt2 gt3 gt4 ptap gain_trim
XMDP vcm1 vcm1 vcm1 ntap sky130_fd_pr__pfet_01v8_lvt L={{pair_l}} W={{24.875*pair_scale}} nf={{(4*pair_scale)|int}} ad={{(((4*pair_scale+1)/2)|int)*6.21875*0.29}} as={{(((4*pair_scale+2)/2)|int)*6.21875*0.29}} pd={{2*(((4*pair_scale+1)/2)|int)*(6.21875+0.29)}} ps={{2*(((4*pair_scale+2)/2)|int)*(6.21875+0.29)}}
+ nrd={{0.29/(24.875*pair_scale)}} nrs={{0.29/(24.875*pair_scale)}} sa=0 sb=0 sd=0 mult={{1.0*power_m}} m={{1*power_m}}
XMDM vss vss vss ptap sky130_fd_pr__nfet_01v8_lvt L={{mirror_l}} W={{10.0*mirror_scale}} nf={{(2*mirror_scale)|int}} ad={{(((2*mirror_scale+1)/2)|int)*5.0*0.29}} as={{(((2*mirror_scale+2)/2)|int)*5.0*0.29}} pd={{2*(((2*mirror_scale+1)/2)|int)*(5.0+0.29)}} ps={{2*(((2*mirror_scale+2)/2)|int)*(5.0+0.29)}} nrd={{0.29/(10.0*mirror_scale)}} nrs={{0.29/(10.0*mirror_scale)}} sa=0 sb=0
+ sd=0 mult={{1.0*power_m}} m={{1*power_m}}
XMDQ1 qs1 qs1 qs1 {{'qs1' if body_tied else 'ptap'}} sky130_fd_pr__{{quad_model}} L={{quad_l}} W={{(4*native_nf) if quad_model=='nfet_03v3_nvt' else (20.0*quad_scale)}} nf={{(native_nf) if quad_model=='nfet_03v3_nvt' else ((4*quad_scale)|int)}} ad={{((((native_nf+1)/2)|int)*4*0.29) if quad_model=='nfet_03v3_nvt' else ((((4*quad_scale+1)/2)|int)*5.0*0.29)}} as={{((((native_nf+2)/2)|int)*4*0.29) if quad_model=='nfet_03v3_nvt' else ((((4*quad_scale+2)/2)|int)*5.0*0.29)}} pd={{(2*(((native_nf+1)/2)|int)*4.29) if quad_model=='nfet_03v3_nvt' else (2*(((4*quad_scale+1)/2)|int)*(5.0+0.29))}} ps={{(2*(((native_nf+2)/2)|int)*4.29) if quad_model=='nfet_03v3_nvt' else (2*(((4*quad_scale+2)/2)|int)*(5.0+0.29))}} nrd={{0.29/((4*native_nf) if quad_model=='nfet_03v3_nvt' else (20.0*quad_scale))}} nrs={{0.29/((4*native_nf) if quad_model=='nfet_03v3_nvt' else (20.0*quad_scale))}} sa=0
+ sb=0 sd=0 mult={{1.0*power_m}} m={{1*power_m}}
XMDQ2 qs2 qs2 qs2 {{'qs2' if body_tied else 'ptap'}} sky130_fd_pr__{{quad_model}} L={{quad_l}} W={{(4*native_nf) if quad_model=='nfet_03v3_nvt' else (20.0*quad_scale)}} nf={{(native_nf) if quad_model=='nfet_03v3_nvt' else ((4*quad_scale)|int)}} ad={{((((native_nf+1)/2)|int)*4*0.29) if quad_model=='nfet_03v3_nvt' else ((((4*quad_scale+1)/2)|int)*5.0*0.29)}} as={{((((native_nf+2)/2)|int)*4*0.29) if quad_model=='nfet_03v3_nvt' else ((((4*quad_scale+2)/2)|int)*5.0*0.29)}} pd={{(2*(((native_nf+1)/2)|int)*4.29) if quad_model=='nfet_03v3_nvt' else (2*(((4*quad_scale+1)/2)|int)*(5.0+0.29))}} ps={{(2*(((native_nf+2)/2)|int)*4.29) if quad_model=='nfet_03v3_nvt' else (2*(((4*quad_scale+2)/2)|int)*(5.0+0.29))}} nrd={{0.29/((4*native_nf) if quad_model=='nfet_03v3_nvt' else (20.0*quad_scale))}} nrs={{0.29/((4*native_nf) if quad_model=='nfet_03v3_nvt' else (20.0*quad_scale))}} sa=0
+ sb=0 sd=0 mult={{1.0*power_m}} m={{1*power_m}}
XMDL vdd vdd vdd ntap sky130_fd_pr__pfet_01v8_lvt L=1 W=16 nf=4 ad=2.32 as=3.48 pd=17.16 ps=25.74 nrd={{0.29/(16)}} nrs={{0.29/(16)}} sa=0
+ sb=0 sd=0 mult={{1.0*power_m}} m={{1*power_m}}
XMDT vdd vdd vdd ntap sky130_fd_pr__pfet_01v8_lvt L=0.65 W={{20.0*tail_width}} nf={{(2*tail_width)|int}} ad={{(((2*tail_width+1)/2)|int)*10.0*0.29}} as={{(((2*tail_width+2)/2)|int)*10.0*0.29}} pd={{2*(((2*tail_width+1)/2)|int)*(10.0+0.29)}} ps={{2*(((2*tail_width+2)/2)|int)*(10.0+0.29)}} nrd={{0.29/(20.0*tail_width)}} nrs={{0.29/(20.0*tail_width)}} sa=0 sb=0
+ sd=0 mult={{1.0*power_m}} m={{1*power_m}}
XRD1 ntap ntap ptap sky130_fd_pr__res_high_po_5p73 L={{((68.05+56.46*13.035)*rscale-68.05)/56.46}} mult={{1.0*power_m}} m={{1*power_m}}
XRD2 ntap ntap ptap sky130_fd_pr__res_high_po_5p73 L={{((68.05+56.46*13.035)*rscale-68.05)/56.46}} mult={{1.0*power_m}} m={{1*power_m}}

XRdegen7 qd7 qs1 ptap sky130_fd_pr__res_high_po_5p73 L={{(rquad-68.05)/56.46}} mult={{power_m}} m={{power_m}}
XRdegen8 qd8 qs1 ptap sky130_fd_pr__res_high_po_5p73 L={{(rquad-68.05)/56.46}} mult={{power_m}} m={{power_m}}
XRdegen9 qd9 qs2 ptap sky130_fd_pr__res_high_po_5p73 L={{(rquad-68.05)/56.46}} mult={{power_m}} m={{power_m}}
XRdegen10 qd10 qs2 ptap sky130_fd_pr__res_high_po_5p73 L={{(rquad-68.05)/56.46}} mult={{power_m}} m={{power_m}}
.ends

* expanding   symbol:  lit_compac_sky/macros/ota/schematic/xschem/ota.sym # of pins=8
** sym_path: /foss/designs/lit_compac_sky/macros/ota/schematic/xschem/ota.sym
** sch_path: /foss/designs/lit_compac_sky/macros/ota/schematic/xschem/ota.sch
.subckt ota vdd out inn inp vss ibias1 ntap ptap
*.opin out
*.ipin inp
*.ipin ibias1
*.ipin inn
*.iopin ntap
*.iopin ptap
*.iopin vdd
*.iopin vss
XM5 vd_m5 vd_m5 vdd ntap sky130_fd_pr__pfet_01v8_lvt L=1 W=4.4 nf=2 ad=0.638 as=1.276 pd=4.98 ps=9.96 nrd={{0.29/(4.4)}}
+ nrs={{0.29/(4.4)}} sa=0 sb=0 sd=0 mult={{fast_scale*power_m}} m={{fast_scale*power_m}}
XM6 out out vdd ntap sky130_fd_pr__pfet_01v8_lvt L=1 W=4.4 nf=2 ad=0.638 as=1.276 pd=4.98 ps=9.96 nrd={{0.29/(4.4)}}
+ nrs={{0.29/(4.4)}} sa=0 sb=0 sd=0 mult={{fast_scale*power_m}} m={{fast_scale*power_m}}
XM1 vd_m5 inp sa ptap sky130_fd_pr__nfet_01v8_lvt L=1 W=16 nf=4 ad=2.32 as=3.48 pd=17.16 ps=25.74 nrd={{0.29/(16)}} nrs={{0.29/(16)}} sa=0
+ sb=0 sd=0 mult={{fast_scale*power_m}} m={{fast_scale*power_m}}
XM2 out vref_int sb ptap sky130_fd_pr__nfet_01v8_lvt L=1 W=16 nf=4 ad=2.32 as=3.48 pd=17.16 ps=25.74 nrd={{0.29/(16)}} nrs={{0.29/(16)}}
+ sa=0 sb=0 sd=0 mult={{fast_scale*power_m}} m={{fast_scale*power_m}}
XRS1 rs1 sa ptap sky130_fd_pr__res_high_po_1p41 L={{22.705*cmfb_rscale}} mult={{fast_scale*power_m}} m={{fast_scale*power_m}}
XRS2 rs2 rs1 ptap sky130_fd_pr__res_high_po_1p41 L={{22.705*cmfb_rscale}} mult={{fast_scale*power_m}} m={{fast_scale*power_m}}
XRS3 rs3 rs2 ptap sky130_fd_pr__res_high_po_1p41 L={{22.705*cmfb_rscale}} mult={{fast_scale*power_m}} m={{fast_scale*power_m}}
XRS4 rs4 rs3 ptap sky130_fd_pr__res_high_po_1p41 L={{22.705*cmfb_rscale}} mult={{fast_scale*power_m}} m={{fast_scale*power_m}}
XRS5 rs5 rs4 ptap sky130_fd_pr__res_high_po_1p41 L={{22.705*cmfb_rscale}} mult={{fast_scale*power_m}} m={{fast_scale*power_m}}
XRS6 rs6 rs5 ptap sky130_fd_pr__res_high_po_1p41 L={{22.705*cmfb_rscale}} mult={{fast_scale*power_m}} m={{fast_scale*power_m}}
XRS7 rs7 rs6 ptap sky130_fd_pr__res_high_po_1p41 L={{22.705*cmfb_rscale}} mult={{fast_scale*power_m}} m={{fast_scale*power_m}}
XRS8 rs8 rs7 ptap sky130_fd_pr__res_high_po_1p41 L={{22.705*cmfb_rscale}} mult={{fast_scale*power_m}} m={{fast_scale*power_m}}
XRS9 rs9 rs8 ptap sky130_fd_pr__res_high_po_1p41 L={{22.705*cmfb_rscale}} mult={{fast_scale*power_m}} m={{fast_scale*power_m}}
XRS10 rs10 rs9 ptap sky130_fd_pr__res_high_po_1p41 L={{22.705*cmfb_rscale}} mult={{fast_scale*power_m}} m={{fast_scale*power_m}}
XRS11 rs11 rs10 ptap sky130_fd_pr__res_high_po_1p41 L={{22.705*cmfb_rscale}} mult={{fast_scale*power_m}} m={{fast_scale*power_m}}
XRS12 sb rs11 ptap sky130_fd_pr__res_high_po_1p41 L={{22.705*cmfb_rscale}} mult={{fast_scale*power_m}} m={{fast_scale*power_m}}
XM3 sa ibias1 vss ptap sky130_fd_pr__nfet_01v8_lvt L=2 W=16 nf=4 ad=2.32 as=3.48 pd=17.16 ps=25.74 nrd={{0.29/(16)}} nrs={{0.29/(16)}} sa=0
+ sb=0 sd=0 mult={{1.0*power_m}} m={{1*power_m}}
XM3B sb ibias1 vss ptap sky130_fd_pr__nfet_01v8_lvt L=2 W=16 nf=4 ad=2.32 as=3.48 pd=17.16 ps=25.74 nrd={{0.29/(16)}} nrs={{0.29/(16)}} sa=0
+ sb=0 sd=0 mult={{fast_scale*power_m}} m={{fast_scale*power_m}}
XM4 ibias1 ibias1 vss ptap sky130_fd_pr__nfet_01v8_lvt L=2 W=32 nf=8 ad=4.64 as=5.8 pd=34.32 ps=42.9 nrd={{0.29/(32)}} nrs={{0.29/(32)}}
+ sa=0 sb=0 sd=0 mult={{fast_scale*power_m}} m={{fast_scale*power_m}}
XM10 vd_m10 vd_m10 vdd ntap sky130_fd_pr__pfet_01v8_lvt L=4 W=1 nf=1 ad=0.29 as=0.29 pd=2.58 ps=2.58 nrd={{0.29/(1)}} nrs={{0.29/(1)}} sa=0 sb=0
+ sd=0 mult={{1.0*power_m}} m={{1*power_m}}
XM11 vref_int vd_m10 vdd ntap sky130_fd_pr__pfet_01v8_lvt L=4 W=1 nf=1 ad=0.29 as=0.29 pd=2.58 ps=2.58 nrd={{0.29/(1)}} nrs={{0.29/(1)}} sa=0 sb=0
+ sd=0 mult={{1.0*power_m}} m={{1*power_m}}
XM7 vd_m10 inn vtail_slow ptap sky130_fd_pr__nfet_01v8_lvt L=2 W=2 nf=2 ad=0.29 as=0.58 pd=2.58 ps=5.16 nrd={{0.29/(2)}} nrs={{0.29/(2)}} sa=0
+ sb=0 sd=0 mult={{1.0*power_m}} m={{1*power_m}}
XM8 vref_int inp vtail_slow ptap sky130_fd_pr__nfet_01v8_lvt L=2 W=2 nf=2 ad=0.29 as=0.58 pd=2.58 ps=5.16 nrd={{0.29/(2)}} nrs={{0.29/(2)}} sa=0
+ sb=0 sd=0 mult={{1.0*power_m}} m={{1*power_m}}
XM9 vtail_slow ibias1 vss ptap sky130_fd_pr__nfet_01v8_lvt L=5 W=1 nf=1 ad=0.29 as=0.29 pd=2.58 ps=2.58 nrd={{0.29/(1)}} nrs={{0.29/(1)}} sa=0
+ sb=0 sd=0 mult={{1.0*power_m}} m={{1*power_m}}
XMC vss vref_int vss ptap sky130_fd_pr__nfet_01v8_lvt L=6 W=6 nf=1 ad=1.74 as=1.74 pd=12.58 ps=12.58 nrd={{0.29/(6)}}
+ nrs={{0.29/(6)}} sa=0 sb=0 sd=0 mult={{cmfb_cscale*power_m}} m={{cmfb_cscale*power_m}}
Rtap_R2 vdd ntap 1m
Rtap_R7 vss ptap 1m
XMDA sa sa sa ptap sky130_fd_pr__nfet_01v8_lvt L=1 W=16 nf=4 ad=2.32 as=3.48 pd=17.16 ps=25.74 nrd={{0.29/(16)}} nrs={{0.29/(16)}} sa=0 sb=0
+ sd=0 mult={{fast_scale*power_m}} m={{fast_scale*power_m}}
XMDB sb sb sb ptap sky130_fd_pr__nfet_01v8_lvt L=1 W=16 nf=4 ad=2.32 as=3.48 pd=17.16 ps=25.74 nrd={{0.29/(16)}} nrs={{0.29/(16)}} sa=0 sb=0
+ sd=0 mult={{fast_scale*power_m}} m={{fast_scale*power_m}}
XMD3 vss vss vss ptap sky130_fd_pr__nfet_01v8_lvt L=2 W=16 nf=4 ad=2.32 as=3.48 pd=17.16 ps=25.74 nrd={{0.29/(16)}} nrs={{0.29/(16)}} sa=0
+ sb=0 sd=0 mult={{fast_scale*power_m}} m={{fast_scale*power_m}}
XMD5 vd_m5 vdd vd_m5 ntap sky130_fd_pr__pfet_01v8_lvt L=1 W=4.4 nf=2 ad=0.638 as=1.276 pd=4.98 ps=9.96 nrd={{0.29/(4.4)}}
+ nrs={{0.29/(4.4)}} sa=0 sb=0 sd=0 mult={{fast_scale*power_m}} m={{fast_scale*power_m}}
XMD7 vd_m10 vd_m10 vd_m10 ptap sky130_fd_pr__nfet_01v8_lvt L=2 W=2 nf=2 ad=0.29 as=0.58 pd=2.58 ps=5.16 nrd={{0.29/(2)}} nrs={{0.29/(2)}} sa=0
+ sb=0 sd=0 mult={{1.0*power_m}} m={{1*power_m}}
XMD10 vd_m10 vdd vd_m10 ntap sky130_fd_pr__pfet_01v8_lvt L=4 W=1 nf=1 ad=0.29 as=0.29 pd=2.58 ps=2.58 nrd={{0.29/(1)}} nrs={{0.29/(1)}} sa=0 sb=0
+ sd=0 mult={{1.0*power_m}} m={{1*power_m}}
XMD11 vref_int vdd vref_int ntap sky130_fd_pr__pfet_01v8_lvt L=4 W=1 nf=1 ad=0.29 as=0.29 pd=2.58 ps=2.58 nrd={{0.29/(1)}} nrs={{0.29/(1)}} sa=0
+ sb=0 sd=0 mult={{1.0*power_m}} m={{1*power_m}}
XMD8 vref_int vss vref_int ptap sky130_fd_pr__nfet_01v8_lvt L=2 W=2 nf=2 ad=0.29 as=0.58 pd=2.58 ps=5.16 nrd={{0.29/(2)}} nrs={{0.29/(2)}} sa=0
+ sb=0 sd=0 mult={{1.0*power_m}} m={{1*power_m}}
.ends

* expanding   symbol:  lit_compac_sky/macros/gilbert_cell/schematic/xschem/gain_trim.sym # of pins=9
** sym_path: /foss/designs/lit_compac_sky/macros/gilbert_cell/schematic/xschem/gain_trim.sym
** sch_path: /foss/designs/lit_compac_sky/macros/gilbert_cell/schematic/xschem/gain_trim.sch
.subckt gain_trim t4p t4n vcm gt0 gt1 gt2 gt3 gt4 ptap
*.iopin t4p
*.iopin t4n
*.iopin vcm
*.ipin gt0
*.ipin gt1
*.ipin gt2
*.ipin gt3
*.ipin gt4
*.iopin ptap
XRS4P0 net1 t4p ptap sky130_fd_pr__res_high_po_5p73 L={{((68.05+56.46*0.875)*rscale-68.05)/56.46}} mult={{2.0*power_m}} m={{2.0*power_m}}
XRS4P1 net2 net1 ptap sky130_fd_pr__res_high_po_5p73 L={{((68.05+56.46*0.875)*rscale-68.05)/56.46}} mult={{2.0*power_m}} m={{2.0*power_m}}
XRS4P2 net3 net2 ptap sky130_fd_pr__res_high_po_5p73 L={{((68.05+56.46*0.875)*rscale-68.05)/56.46}} mult={{2.0*power_m}} m={{2.0*power_m}}
XRS4P3 net4 net3 ptap sky130_fd_pr__res_high_po_5p73 L={{((68.05+56.46*0.875)*rscale-68.05)/56.46}} mult={{2.0*power_m}} m={{2.0*power_m}}
XRS4P4 net5 net4 ptap sky130_fd_pr__res_high_po_5p73 L={{((68.05+56.46*0.875)*rscale-68.05)/56.46}} mult={{2.0*power_m}} m={{2.0*power_m}}
XRS4P5 net6 net5 ptap sky130_fd_pr__res_high_po_5p73 L={{((68.05+56.46*0.875)*rscale-68.05)/56.46}} mult={{2.0*power_m}} m={{2.0*power_m}}
XRS4P6 net7 net6 ptap sky130_fd_pr__res_high_po_5p73 L={{((68.05+56.46*0.875)*rscale-68.05)/56.46}} mult={{2.0*power_m}} m={{2.0*power_m}}
XRS4P7 t3p net7 ptap sky130_fd_pr__res_high_po_5p73 L={{((68.05+56.46*0.875)*rscale-68.05)/56.46}} mult={{2.0*power_m}} m={{2.0*power_m}}
XRS3P0 net8 t3p ptap sky130_fd_pr__res_high_po_5p73 L={{((68.05+56.46*0.875)*rscale-68.05)/56.46}} mult={{2.0*power_m}} m={{2.0*power_m}}
XRS3P1 net9 net8 ptap sky130_fd_pr__res_high_po_5p73 L={{((68.05+56.46*0.875)*rscale-68.05)/56.46}} mult={{2.0*power_m}} m={{2.0*power_m}}
XRS3P2 net10 net9 ptap sky130_fd_pr__res_high_po_5p73 L={{((68.05+56.46*0.875)*rscale-68.05)/56.46}} mult={{2.0*power_m}} m={{2.0*power_m}}
XRS3P3 t2p net10 ptap sky130_fd_pr__res_high_po_5p73 L={{((68.05+56.46*0.875)*rscale-68.05)/56.46}} mult={{2.0*power_m}} m={{2.0*power_m}}
XRS2P0 net11 t2p ptap sky130_fd_pr__res_high_po_5p73 L={{((68.05+56.46*0.875)*rscale-68.05)/56.46}} mult={{2.0*power_m}} m={{2.0*power_m}}
XRS2P1 t1p net11 ptap sky130_fd_pr__res_high_po_5p73 L={{((68.05+56.46*0.875)*rscale-68.05)/56.46}} mult={{2.0*power_m}} m={{2.0*power_m}}
XRS1P0 t0p t1p ptap sky130_fd_pr__res_high_po_5p73 L={{((68.05+56.46*0.875)*rscale-68.05)/56.46}} mult={{2.0*power_m}} m={{2.0*power_m}}
XRS0P vcm t0p ptap sky130_fd_pr__res_high_po_5p73 L={{((68.05+56.46*0.875)*rscale-68.05)/56.46}} mult={{4.0*power_m}} m={{4.0*power_m}}
XMSW4P t3p gt4 t4p ptap sky130_fd_pr__nfet_01v8_lvt L=0.35 W=7.365 nf=1 ad=2.13585 as=2.13585 pd=15.31 ps=15.31
+ nrd={{0.29/(7.365)}} nrs={{0.29/(7.365)}} sa=0 sb=0 sd=0 mult={{1.0*power_m}} m={{1*power_m}}
XMSW3P t2p gt3 t3p ptap sky130_fd_pr__nfet_01v8_lvt L=0.35 W=14.73 nf=2 ad=2.13585 as=4.2717 pd=15.31 ps=30.62
+ nrd={{0.29/(14.73)}} nrs={{0.29/(14.73)}} sa=0 sb=0 sd=0 mult={{1.0*power_m}} m={{1*power_m}}
XMSW2P t1p gt2 t2p ptap sky130_fd_pr__nfet_01v8_lvt L=0.35 W=29.46 nf=4 ad=4.2717 as=6.40755 pd=30.62 ps=45.93
+ nrd={{0.29/(29.46)}} nrs={{0.29/(29.46)}} sa=0 sb=0 sd=0 mult={{1.0*power_m}} m={{1*power_m}}
XMSW1P t0p gt1 t1p ptap sky130_fd_pr__nfet_01v8_lvt L=0.35 W=58.92 nf=8 ad=8.5434 as=10.67925 pd=61.24 ps=76.55
+ nrd={{0.29/(58.92)}} nrs={{0.29/(58.92)}} sa=0 sb=0 sd=0 mult={{1.0*power_m}} m={{1*power_m}}
XRS4N0 net12 t4n ptap sky130_fd_pr__res_high_po_5p73 L={{((68.05+56.46*0.875)*rscale-68.05)/56.46}} mult={{2.0*power_m}} m={{2.0*power_m}}
XRS4N1 net13 net12 ptap sky130_fd_pr__res_high_po_5p73 L={{((68.05+56.46*0.875)*rscale-68.05)/56.46}} mult={{2.0*power_m}} m={{2.0*power_m}}
XRS4N2 net14 net13 ptap sky130_fd_pr__res_high_po_5p73 L={{((68.05+56.46*0.875)*rscale-68.05)/56.46}} mult={{2.0*power_m}} m={{2.0*power_m}}
XRS4N3 net15 net14 ptap sky130_fd_pr__res_high_po_5p73 L={{((68.05+56.46*0.875)*rscale-68.05)/56.46}} mult={{2.0*power_m}} m={{2.0*power_m}}
XRS4N4 net16 net15 ptap sky130_fd_pr__res_high_po_5p73 L={{((68.05+56.46*0.875)*rscale-68.05)/56.46}} mult={{2.0*power_m}} m={{2.0*power_m}}
XRS4N5 net17 net16 ptap sky130_fd_pr__res_high_po_5p73 L={{((68.05+56.46*0.875)*rscale-68.05)/56.46}} mult={{2.0*power_m}} m={{2.0*power_m}}
XRS4N6 net18 net17 ptap sky130_fd_pr__res_high_po_5p73 L={{((68.05+56.46*0.875)*rscale-68.05)/56.46}} mult={{2.0*power_m}} m={{2.0*power_m}}
XRS4N7 t3n net18 ptap sky130_fd_pr__res_high_po_5p73 L={{((68.05+56.46*0.875)*rscale-68.05)/56.46}} mult={{2.0*power_m}} m={{2.0*power_m}}
XRS3N0 net19 t3n ptap sky130_fd_pr__res_high_po_5p73 L={{((68.05+56.46*0.875)*rscale-68.05)/56.46}} mult={{2.0*power_m}} m={{2.0*power_m}}
XRS3N1 net20 net19 ptap sky130_fd_pr__res_high_po_5p73 L={{((68.05+56.46*0.875)*rscale-68.05)/56.46}} mult={{2.0*power_m}} m={{2.0*power_m}}
XRS3N2 net21 net20 ptap sky130_fd_pr__res_high_po_5p73 L={{((68.05+56.46*0.875)*rscale-68.05)/56.46}} mult={{2.0*power_m}} m={{2.0*power_m}}
XRS3N3 t2n net21 ptap sky130_fd_pr__res_high_po_5p73 L={{((68.05+56.46*0.875)*rscale-68.05)/56.46}} mult={{2.0*power_m}} m={{2.0*power_m}}
XRS2N0 net22 t2n ptap sky130_fd_pr__res_high_po_5p73 L={{((68.05+56.46*0.875)*rscale-68.05)/56.46}} mult={{2.0*power_m}} m={{2.0*power_m}}
XRS2N1 t1n net22 ptap sky130_fd_pr__res_high_po_5p73 L={{((68.05+56.46*0.875)*rscale-68.05)/56.46}} mult={{2.0*power_m}} m={{2.0*power_m}}
XRS1N0 t0n t1n ptap sky130_fd_pr__res_high_po_5p73 L={{((68.05+56.46*0.875)*rscale-68.05)/56.46}} mult={{2.0*power_m}} m={{2.0*power_m}}
XRS0N vcm t0n ptap sky130_fd_pr__res_high_po_5p73 L={{((68.05+56.46*0.875)*rscale-68.05)/56.46}} mult={{4.0*power_m}} m={{4.0*power_m}}
XMSW4N t4n gt4 t3n ptap sky130_fd_pr__nfet_01v8_lvt L=0.35 W=7.365 nf=1 ad=2.13585 as=2.13585 pd=15.31 ps=15.31
+ nrd={{0.29/(7.365)}} nrs={{0.29/(7.365)}} sa=0 sb=0 sd=0 mult={{1.0*power_m}} m={{1*power_m}}
XMSW3N t3n gt3 t2n ptap sky130_fd_pr__nfet_01v8_lvt L=0.35 W=14.73 nf=2 ad=2.13585 as=4.2717 pd=15.31 ps=30.62
+ nrd={{0.29/(14.73)}} nrs={{0.29/(14.73)}} sa=0 sb=0 sd=0 mult={{1.0*power_m}} m={{1*power_m}}
XMSW2N t2n gt2 t1n ptap sky130_fd_pr__nfet_01v8_lvt L=0.35 W=29.46 nf=4 ad=4.2717 as=6.40755 pd=30.62 ps=45.93
+ nrd={{0.29/(29.46)}} nrs={{0.29/(29.46)}} sa=0 sb=0 sd=0 mult={{1.0*power_m}} m={{1*power_m}}
XMSW1N t1n gt1 t0n ptap sky130_fd_pr__nfet_01v8_lvt L=0.35 W=58.92 nf=8 ad=8.5434 as=10.67925 pd=61.24 ps=76.55
+ nrd={{0.29/(58.92)}} nrs={{0.29/(58.92)}} sa=0 sb=0 sd=0 mult={{1.0*power_m}} m={{1*power_m}}
XMSW0 t0p gt0 t0n ptap sky130_fd_pr__nfet_01v8_lvt L=0.35 W=58.92 nf=8 ad=8.5434 as=10.67925 pd=61.24 ps=76.55
+ nrd={{0.29/(58.92)}} nrs={{0.29/(58.92)}} sa=0 sb=0 sd=0 mult={{1.0*power_m}} m={{1*power_m}}
XRDP ptap ptap ptap sky130_fd_pr__res_high_po_5p73 L={{((68.05+56.46*0.875)*rscale-68.05)/56.46}} mult={{6.0*power_m}} m={{6.0*power_m}}
XRDN ptap ptap ptap sky130_fd_pr__res_high_po_5p73 L={{((68.05+56.46*0.875)*rscale-68.05)/56.46}} mult={{6.0*power_m}} m={{6.0*power_m}}
XRDS ptap ptap ptap sky130_fd_pr__res_high_po_5p73 L={{((68.05+56.46*10.76)*rscale-68.05)/56.46}} mult={{8.0*power_m}} m={{8.0*power_m}}
XMDSP t4p t4p t4p ptap sky130_fd_pr__nfet_01v8_lvt L=0.35 W=7.365 nf=1 ad=2.13585 as=2.13585 pd=15.31 ps=15.31
+ nrd={{0.29/(7.365)}} nrs={{0.29/(7.365)}} sa=0 sb=0 sd=0 mult={{1.0*power_m}} m={{1*power_m}}
XMDSN t4n t4n t4n ptap sky130_fd_pr__nfet_01v8_lvt L=0.35 W=7.365 nf=1 ad=2.13585 as=2.13585 pd=15.31 ps=15.31
+ nrd={{0.29/(7.365)}} nrs={{0.29/(7.365)}} sa=0 sb=0 sd=0 mult={{1.0*power_m}} m={{1*power_m}}
.ends

.GLOBAL GND
.end

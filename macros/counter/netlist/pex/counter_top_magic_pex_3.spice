* PEX produced on Fri Sep 18 09:07:17 AM CEST 2026 using /foss/tools/sak/sak-pex.sh with m=3 and s=1 (extresist threshold=10000 mOhm, minres=1000 mOhm, mindelay=1 ps)
* NGSPICE file created from counter_top_pex.ext - technology: sky130A

.subckt counter_top_pex VDD VSS clock_i reset_n_i enable_i counter_value_o[0]
+ counter_value_o[1] counter_value_o[2] counter_value_o[3] counter_value_o[4]
+ counter_value_o[5] counter_value_o[6] counter_value_o[7]
X0 VSS.t493 VDD VSS.t493 VSS.t492 sky130_fd_pr__nfet_01v8 ad=0.143 pd=1.62 as=0 ps=0 w=0.55 l=0.59
X1 a_23408_15279# a_23009_15279# a_23282_15645# VSS.t122 sky130_fd_pr__special_nfet_01v8 ad=0.0696 pd=0.765 as=0.0621 ps=0.705 w=0.36 l=0.15
X2 VSS.t357 VDD VSS.t356 VSS.t355 sky130_fd_pr__nfet_01v8 ad=0.143 pd=1.62 as=0 ps=0 w=0.55 l=0.59
X3 VDD VSS.t3476 VDD VDD sky130_fd_pr__pfet_01v8_hvt ad=0.2262 pd=2.26 as=519.8822 ps=5.15022k w=0.87 l=4.73
X4 VDD VSS.t3901 VDD VDD sky130_fd_pr__pfet_01v8_hvt ad=0.2262 pd=2.26 as=0 ps=0 w=0.87 l=4.73
X5 VDD VSS.t4185 VDD VDD sky130_fd_pr__pfet_01v8_hvt ad=0.2262 pd=2.26 as=0 ps=0 w=0.87 l=4.73
X6 VDD VSS.t4394 VDD VDD sky130_fd_pr__pfet_01v8_hvt ad=0.2262 pd=2.26 as=0 ps=0 w=0.87 l=2.89
X7 VSS.t587 VDD VSS.t586 VSS.t585 sky130_fd_pr__nfet_01v8 ad=0.143 pd=1.62 as=0 ps=0 w=0.55 l=4.73
X8 VDD VSS.t4088 VDD VDD sky130_fd_pr__pfet_01v8_hvt ad=0.2262 pd=2.26 as=0 ps=0 w=0.87 l=4.73
X9 _57_.Y _36_.B.t14 VSS.t3280 VSS.t3340 sky130_fd_pr__nfet_01v8 ad=0.08775 pd=0.92 as=0.08775 ps=0.92 w=0.65 l=0.15
X10 VDD VSS.t4072 VDD VDD sky130_fd_pr__pfet_01v8_hvt ad=0.2262 pd=2.26 as=0 ps=0 w=0.87 l=4.73
X11 VDD VSS.t4348 VDD VDD sky130_fd_pr__pfet_01v8_hvt ad=0.2262 pd=2.26 as=0 ps=0 w=0.87 l=4.73
X12 VSS.t1433 VDD VSS.t1432 VSS.t1431 sky130_fd_pr__nfet_01v8 ad=0.143 pd=1.62 as=0 ps=0 w=0.55 l=4.73
X13 VSS.t2201 VDD VSS.t2200 VSS.t2199 sky130_fd_pr__nfet_01v8 ad=0.143 pd=1.62 as=0 ps=0 w=0.55 l=4.73
X14 VSS.t2147 VDD VSS.t2146 VSS.t2145 sky130_fd_pr__nfet_01v8 ad=0.143 pd=1.62 as=0 ps=0 w=0.55 l=4.73
X15 VDD VSS.t3446 VDD VDD sky130_fd_pr__pfet_01v8_hvt ad=0.2262 pd=2.26 as=0 ps=0 w=0.87 l=4.73
X16 VDD VSS.t3954 VDD VDD sky130_fd_pr__pfet_01v8_hvt ad=0.2262 pd=2.26 as=0 ps=0 w=0.87 l=4.73
X17 VDD VSS.t3503 VDD VDD sky130_fd_pr__pfet_01v8_hvt ad=0.2262 pd=2.26 as=0 ps=0 w=0.87 l=1.97
X18 VSS.t2105 VDD VSS.t2104 VSS.t2103 sky130_fd_pr__nfet_01v8 ad=0.143 pd=1.62 as=0 ps=0 w=0.55 l=4.73
X19 VSS.t1409 VDD VSS.t1408 VSS.t1407 sky130_fd_pr__nfet_01v8 ad=0.143 pd=1.62 as=0 ps=0 w=0.55 l=4.73
X20 VSS.t1320 VDD VSS.t1319 VSS.t1318 sky130_fd_pr__nfet_01v8 ad=0.143 pd=1.62 as=0 ps=0 w=0.55 l=1.97
X21 clkbuf_0_clock_i.X a_16762_15823.t19 VDD VDD sky130_fd_pr__pfet_01v8_hvt ad=0.14 pd=1.28 as=0.14 ps=1.28 w=1 l=0.15
X22 VDD VSS.t4220 VDD VDD sky130_fd_pr__pfet_01v8_hvt ad=0.2262 pd=2.26 as=0 ps=0 w=0.87 l=4.73
X23 VSS.t3373 _70_.Q a_27535_16919# VSS.t3435 sky130_fd_pr__nfet_01v8 ad=0.097 pd=0.975 as=0.1092 ps=1.36 w=0.42 l=0.15
X24 VSS.t3405 a_21914_15823.t29 _77_.CLK VSS.t3406 sky130_fd_pr__nfet_01v8 ad=0.0588 pd=0.7 as=0.0588 ps=0.7 w=0.42 l=0.15
X25 VDD VSS.t4304 VDD VDD sky130_fd_pr__pfet_01v8_hvt ad=0.2262 pd=2.26 as=0 ps=0 w=0.87 l=1.97
X26 VDD VSS.t4274 VDD VDD sky130_fd_pr__pfet_01v8_hvt ad=0.2262 pd=2.26 as=0 ps=0 w=0.87 l=4.73
X27 VSS.t1586 VDD VSS.t1585 VSS.t1584 sky130_fd_pr__nfet_01v8 ad=0.143 pd=1.62 as=0 ps=0 w=0.55 l=4.73
X28 VSS.t1296 VDD VSS.t1295 VSS.t1294 sky130_fd_pr__nfet_01v8 ad=0.143 pd=1.62 as=0 ps=0 w=0.55 l=4.73
X29 VSS.t297 VDD VSS.t296 VSS.t295 sky130_fd_pr__nfet_01v8 ad=0.143 pd=1.62 as=0 ps=0 w=0.55 l=1.05
X30 VDD VSS.t3803 VDD VDD sky130_fd_pr__pfet_01v8_hvt ad=0.2262 pd=2.26 as=0 ps=0 w=0.87 l=1.97
X31 VDD VSS.t3653 VDD VDD sky130_fd_pr__pfet_01v8_hvt ad=0.2262 pd=2.26 as=0 ps=0 w=0.87 l=1.97
X32 VDD VSS.t4368 VDD VDD sky130_fd_pr__pfet_01v8_hvt ad=0.2262 pd=2.26 as=0 ps=0 w=0.87 l=4.73
X33 VDD a_37471_16919# counter_value_o[7] VDD sky130_fd_pr__pfet_01v8_hvt ad=0.265 pd=2.53 as=0.135 ps=1.27 w=1 l=0.15
X34 a_28985_16367# a_27995_16367# a_28859_16733# VSS.t16 sky130_fd_pr__special_nfet_01v8 ad=0.066 pd=0.745 as=0.0684 ps=0.74 w=0.36 l=0.15
X35 VDD a_7699_16733# a_7867_16635# VDD sky130_fd_pr__pfet_01v8_hvt ad=0.135 pd=1.27 as=0.27 ps=2.54 w=1 l=0.15
X36 VDD VSS.t3656 VDD VDD sky130_fd_pr__pfet_01v8_hvt ad=0.2262 pd=2.26 as=0 ps=0 w=0.87 l=4.73
X37 a_8573_16367# output3.A.t6 VSS.t485 VSS.t3354 sky130_fd_pr__nfet_01v8 ad=0.08775 pd=0.92 as=0.169 ps=1.82 w=0.65 l=0.15
X38 VDD VSS.t3746 VDD VDD sky130_fd_pr__pfet_01v8_hvt ad=0.2262 pd=2.26 as=0 ps=0 w=0.87 l=4.73
X39 VDD VSS.t3584 VDD VDD sky130_fd_pr__pfet_01v8_hvt ad=0.2262 pd=2.26 as=0 ps=0 w=0.87 l=4.73
X40 VSS.t2553 VDD VSS.t2552 VSS.t2551 sky130_fd_pr__nfet_01v8 ad=0.143 pd=1.62 as=0 ps=0 w=0.55 l=4.73
X41 VSS.t410 VDD VSS.t409 VSS.t408 sky130_fd_pr__nfet_01v8 ad=0.143 pd=1.62 as=0 ps=0 w=0.55 l=2.89
X42 VSS.t2678 VDD VSS.t2678 VSS.t2677 sky130_fd_pr__nfet_01v8 ad=0.143 pd=1.62 as=0 ps=0 w=0.55 l=0.59
X43 VDD VSS.t2786 VDD VDD sky130_fd_pr__pfet_01v8_hvt ad=0.2262 pd=2.26 as=0 ps=0 w=0.87 l=0.59
X44 VSS.t2876 VDD VSS.t2875 VSS.t2874 sky130_fd_pr__nfet_01v8 ad=0.143 pd=1.62 as=0 ps=0 w=0.55 l=4.73
X45 a_27133_16617# a_26799_16367# VDD VDD sky130_fd_pr__pfet_01v8_hvt ad=0.135 pd=1.27 as=0.135 ps=1.27 w=1 l=0.15
X46 VDD VSS.t3500 VDD VDD sky130_fd_pr__pfet_01v8_hvt ad=0.2262 pd=2.26 as=0 ps=0 w=0.87 l=4.73
X47 VDD VSS.t2471 VDD VDD sky130_fd_pr__pfet_01v8_hvt ad=0.2262 pd=2.26 as=0 ps=0 w=0.87 l=4.73
X48 VSS.t2048 VDD VSS.t2047 VSS.t2046 sky130_fd_pr__nfet_01v8 ad=0.143 pd=1.62 as=0 ps=0 w=0.55 l=4.73
X49 VDD VSS.t4115 VDD VDD sky130_fd_pr__pfet_01v8_hvt ad=0.2262 pd=2.26 as=0 ps=0 w=0.87 l=4.73
X50 VSS.t291 VDD VSS.t290 VSS.t289 sky130_fd_pr__nfet_01v8 ad=0.143 pd=1.62 as=0 ps=0 w=0.55 l=0.59
X51 VSS.t782 VDD VSS.t781 VSS.t780 sky130_fd_pr__nfet_01v8 ad=0.143 pd=1.62 as=0 ps=0 w=0.55 l=4.73
X52 VSS.t342 VDD VSS.t341 VSS.t340 sky130_fd_pr__nfet_01v8 ad=0.143 pd=1.62 as=0 ps=0 w=0.55 l=0.59
X53 VSS.t572 VDD VSS.t571 VSS.t570 sky130_fd_pr__nfet_01v8 ad=0.143 pd=1.62 as=0 ps=0 w=0.55 l=4.73
X54 VSS.t737 VDD VSS.t736 VSS.t633 sky130_fd_pr__nfet_01v8 ad=0.143 pd=1.62 as=0 ps=0 w=0.55 l=4.73
X55 VSS.t2416 VDD VSS.t2415 VSS.t2414 sky130_fd_pr__nfet_01v8 ad=0.143 pd=1.62 as=0 ps=0 w=0.55 l=4.73
X56 VSS.t2362 VDD VSS.t2361 VSS.t2360 sky130_fd_pr__nfet_01v8 ad=0.143 pd=1.62 as=0 ps=0 w=0.55 l=4.73
X57 VDD VSS.t3782 VDD VDD sky130_fd_pr__pfet_01v8_hvt ad=0.2262 pd=2.26 as=0 ps=0 w=0.87 l=4.73
X58 VDD VSS.t3800 VDD VDD sky130_fd_pr__pfet_01v8_hvt ad=0.2262 pd=2.26 as=0 ps=0 w=0.87 l=4.73
X59 VSS.t961 VDD VSS.t960 VSS.t959 sky130_fd_pr__nfet_01v8 ad=0.143 pd=1.62 as=0 ps=0 w=0.55 l=4.73
X60 a_27839_15645# a_27057_15279# a_27755_15645# VDD sky130_fd_pr__pfet_01v8_hvt ad=0.0882 pd=0.84 as=0.0567 ps=0.69 w=0.42 l=0.15
X61 VSS.t1054 VDD VSS.t1053 VSS.t1052 sky130_fd_pr__nfet_01v8 ad=0.143 pd=1.62 as=0 ps=0 w=0.55 l=4.73
X62 VSS.t896 VDD VSS.t895 VSS.t894 sky130_fd_pr__nfet_01v8 ad=0.143 pd=1.62 as=0 ps=0 w=0.55 l=4.73
X63 _40_.A1 _36_.A.t9 VDD VDD sky130_fd_pr__pfet_01v8_hvt ad=0.26 pd=2.52 as=0.26 ps=2.52 w=1 l=0.15
X64 a_16762_15823.t1 clock_i VSS.t3360 VSS.t3361 sky130_fd_pr__nfet_01v8 ad=0.0588 pd=0.7 as=0.0588 ps=0.7 w=0.42 l=0.15
X65 VDD VSS.t3578 VDD VDD sky130_fd_pr__pfet_01v8_hvt ad=0.2262 pd=2.26 as=0 ps=0 w=0.87 l=1.97
X66 VSS.t1418 VDD VSS.t1417 VSS.t1416 sky130_fd_pr__nfet_01v8 ad=0.143 pd=1.62 as=0 ps=0 w=0.55 l=4.73
X67 clkbuf_0_clock_i.X a_16762_15823.t29 VSS.t79 VSS.t78 sky130_fd_pr__nfet_01v8 ad=0.0588 pd=0.7 as=0.05775 ps=0.695 w=0.42 l=0.15
X68 VDD VSS.t3974 VDD VDD sky130_fd_pr__pfet_01v8_hvt ad=0.2262 pd=2.26 as=0 ps=0 w=0.87 l=4.73
X69 a_25460_15797# input2.X.t7 VSS.t149 VSS.t148 sky130_fd_pr__nfet_01v8 ad=0.1113 pd=1.37 as=0.10187 ps=0.99 w=0.42 l=0.15
X70 VSS.t2562 VDD VSS.t2561 VSS.t2560 sky130_fd_pr__nfet_01v8 ad=0.143 pd=1.62 as=0 ps=0 w=0.55 l=4.73
X71 a_10547_16395# input2.X.t15 VDD VDD sky130_fd_pr__pfet_01v8_hvt ad=0.0567 pd=0.69 as=0.1176 ps=1.4 w=0.42 l=0.15
X72 VDD VSS.t3959 VDD VDD sky130_fd_pr__pfet_01v8_hvt ad=0.2262 pd=2.26 as=0 ps=0 w=0.87 l=4.73
X73 VSS.t1305 VDD VSS.t1304 VSS.t1303 sky130_fd_pr__nfet_01v8 ad=0.143 pd=1.62 as=0 ps=0 w=0.55 l=1.97
X74 a_17857_16367# a_17691_16367# VSS.t189 VSS.t3381 sky130_fd_pr__nfet_01v8 ad=0.1092 pd=1.36 as=0.0567 ps=0.69 w=0.42 l=0.15
X75 VDD VSS.t3733 VDD VDD sky130_fd_pr__pfet_01v8_hvt ad=0.2262 pd=2.26 as=0 ps=0 w=0.87 l=1.97
X76 VDD VSS.t3829 VDD VDD sky130_fd_pr__pfet_01v8_hvt ad=0.2262 pd=2.26 as=0 ps=0 w=0.87 l=4.73
X77 VDD VSS.t3557 VDD VDD sky130_fd_pr__pfet_01v8_hvt ad=0.2262 pd=2.26 as=0 ps=0 w=0.87 l=4.73
X78 a_21914_15823.t3 clkbuf_0_clock_i.X VDD VDD sky130_fd_pr__pfet_01v8_hvt ad=0.14 pd=1.28 as=0.265 ps=2.53 w=1 l=0.15
X79 VDD VSS.t3695 VDD VDD sky130_fd_pr__pfet_01v8_hvt ad=0.2262 pd=2.26 as=0 ps=0 w=0.87 l=4.73
X80 VSS.t699 VDD VSS.t698 VSS.t697 sky130_fd_pr__nfet_01v8 ad=0.143 pd=1.62 as=0 ps=0 w=0.55 l=4.73
X81 VDD VSS.t4231 VDD VDD sky130_fd_pr__pfet_01v8_hvt ad=0.2262 pd=2.26 as=0 ps=0 w=0.87 l=4.73
X82 VDD VSS.t3542 VDD VDD sky130_fd_pr__pfet_01v8_hvt ad=0.2262 pd=2.26 as=0 ps=0 w=0.87 l=1.97
X83 VDD VSS.t4373 VDD VDD sky130_fd_pr__pfet_01v8_hvt ad=0.2262 pd=2.26 as=0 ps=0 w=0.87 l=4.73
X84 VSS.t1712 VDD VSS.t1711 VSS.t1710 sky130_fd_pr__nfet_01v8 ad=0.143 pd=1.62 as=0 ps=0 w=0.55 l=4.73
X85 VDD VSS.t3804 VDD VDD sky130_fd_pr__pfet_01v8_hvt ad=0.2262 pd=2.26 as=0 ps=0 w=0.87 l=4.73
X86 VSS.t2962 VDD VSS.t2961 VSS.t2960 sky130_fd_pr__nfet_01v8 ad=0.143 pd=1.62 as=0 ps=0 w=0.55 l=4.73
X87 VDD VSS.t4311 VDD VDD sky130_fd_pr__pfet_01v8_hvt ad=0.2262 pd=2.26 as=0 ps=0 w=0.87 l=1.97
X88 VSS.t1795 VDD VSS.t1794 VSS.t1793 sky130_fd_pr__nfet_01v8 ad=0.143 pd=1.62 as=0 ps=0 w=0.55 l=4.73
X89 VSS.t2717 VDD VSS.t2716 VSS.t2715 sky130_fd_pr__nfet_01v8 ad=0.143 pd=1.62 as=0 ps=0 w=0.55 l=4.73
X90 VSS.t2219 VDD VSS.t2218 VSS.t2217 sky130_fd_pr__nfet_01v8 ad=0.143 pd=1.62 as=0 ps=0 w=0.55 l=4.73
X91 VSS.t168 clock_i a_16762_15823.t1 VSS.t3362 sky130_fd_pr__nfet_01v8 ad=0.0588 pd=0.7 as=0.0588 ps=0.7 w=0.42 l=0.15
X92 VDD VSS.t4366 VDD VDD sky130_fd_pr__pfet_01v8_hvt ad=0.2262 pd=2.26 as=0 ps=0 w=0.87 l=2.89
X93 VSS.t671 VDD VSS.t670 VSS.t669 sky130_fd_pr__nfet_01v8 ad=0.143 pd=1.62 as=0 ps=0 w=0.55 l=4.73
X94 VSS.t3055 VDD VSS.t3054 VSS.t3053 sky130_fd_pr__nfet_01v8 ad=0.143 pd=1.62 as=0 ps=0 w=0.55 l=4.73
X95 VSS.t3121 VDD VSS.t3120 VSS.t3119 sky130_fd_pr__nfet_01v8 ad=0.143 pd=1.62 as=0 ps=0 w=0.55 l=4.73
X96 VDD a_11413_16341.t28 _75_.CLK VDD sky130_fd_pr__pfet_01v8_hvt ad=0.14 pd=1.28 as=0.14 ps=1.28 w=1 l=0.15
X97 VDD VSS.t3671 VDD VDD sky130_fd_pr__pfet_01v8_hvt ad=0.2262 pd=2.26 as=0 ps=0 w=0.87 l=4.73
X98 _50_.Y _50_.A2 a_25236_15601# VDD sky130_fd_pr__pfet_01v8_hvt ad=0.0896 pd=0.92 as=0.0768 ps=0.88 w=0.64 l=0.15
X99 VSS.t3396 a_23875_15547# a_23833_15279# VSS.t3395 sky130_fd_pr__nfet_01v8 ad=0.1092 pd=1.36 as=0.066 ps=0.745 w=0.42 l=0.15
X100 VSS.t1759 VDD VSS.t1758 VSS.t1757 sky130_fd_pr__nfet_01v8 ad=0.143 pd=1.62 as=0 ps=0 w=0.55 l=4.73
X101 VSS.t767 VDD VSS.t766 VSS.t765 sky130_fd_pr__nfet_01v8 ad=0.143 pd=1.62 as=0 ps=0 w=0.55 l=4.73
X102 VDD VSS.t3712 VDD VDD sky130_fd_pr__pfet_01v8_hvt ad=0.2262 pd=2.26 as=0 ps=0 w=0.87 l=4.73
X103 VDD VSS.t3730 VDD VDD sky130_fd_pr__pfet_01v8_hvt ad=0.2262 pd=2.26 as=0 ps=0 w=0.87 l=4.73
X104 VSS.t1532 VDD VSS.t1531 VSS.t1530 sky130_fd_pr__nfet_01v8 ad=0.143 pd=1.62 as=0 ps=0 w=0.55 l=4.73
X105 VDD VSS.t4151 VDD VDD sky130_fd_pr__pfet_01v8_hvt ad=0.2262 pd=2.26 as=0 ps=0 w=0.87 l=4.73
X106 VDD VSS.t4206 VDD VDD sky130_fd_pr__pfet_01v8_hvt ad=0.2262 pd=2.26 as=0 ps=0 w=0.87 l=4.73
X107 VDD VSS.t3519 VDD VDD sky130_fd_pr__pfet_01v8_hvt ad=0.2262 pd=2.26 as=0 ps=0 w=0.87 l=4.73
X108 VSS.t2045 VDD VSS.t2044 VSS.t2043 sky130_fd_pr__nfet_01v8 ad=0.143 pd=1.62 as=0 ps=0 w=0.55 l=4.73
X109 a_27133_16617# _55_.Y hold12.A VDD sky130_fd_pr__pfet_01v8_hvt ad=0.1375 pd=1.275 as=0.155 ps=1.31 w=1 l=0.15
X110 VSS.t3100 VDD VSS.t3099 VSS.t3098 sky130_fd_pr__nfet_01v8 ad=0.143 pd=1.62 as=0 ps=0 w=0.55 l=4.73
X111 VDD _63_.A.t13 _36_.B.t0 VDD sky130_fd_pr__pfet_01v8_hvt ad=0.135 pd=1.27 as=0.135 ps=1.27 w=1 l=0.15
X112 a_27881_15279# a_26891_15279# a_27755_15645# VSS.t3347 sky130_fd_pr__special_nfet_01v8 ad=0.066 pd=0.745 as=0.0684 ps=0.74 w=0.36 l=0.15
X113 VDD VSS.t3759 VDD VDD sky130_fd_pr__pfet_01v8_hvt ad=0.2262 pd=2.26 as=0 ps=0 w=0.87 l=4.73
X114 VSS.t300 VDD VSS.t299 VSS.t298 sky130_fd_pr__nfet_01v8 ad=0.143 pd=1.62 as=0 ps=0 w=0.55 l=2.89
X115 VSS.t1804 VDD VSS.t1803 VSS.t1802 sky130_fd_pr__nfet_01v8 ad=0.143 pd=1.62 as=0 ps=0 w=0.55 l=4.73
X116 VDD VSS.t1393 VDD VDD sky130_fd_pr__pfet_01v8_hvt ad=0.2262 pd=2.26 as=0 ps=0 w=0.87 l=4.73
X117 a_2748_16885# output3.A.t19 VSS.t243 VSS.t3271 sky130_fd_pr__nfet_01v8 ad=0.1092 pd=1.36 as=0.097 ps=0.975 w=0.42 l=0.15
X118 VDD VSS.t4243 VDD VDD sky130_fd_pr__pfet_01v8_hvt ad=0.2262 pd=2.26 as=0 ps=0 w=0.87 l=4.73
X119 VSS.t3000 VDD VSS.t2999 VSS.t2996 sky130_fd_pr__nfet_01v8 ad=0.143 pd=1.62 as=0 ps=0 w=0.55 l=1.97
X120 VDD VSS.t3687 VDD VDD sky130_fd_pr__pfet_01v8_hvt ad=0.2262 pd=2.26 as=0 ps=0 w=0.87 l=1.97
X121 VSS.t2025 VDD VSS.t2024 VSS.t2023 sky130_fd_pr__nfet_01v8 ad=0.143 pd=1.62 as=0 ps=0 w=0.55 l=4.73
X122 VDD VSS.t4271 VDD VDD sky130_fd_pr__pfet_01v8_hvt ad=0.2262 pd=2.26 as=0 ps=0 w=0.87 l=4.73
X123 VDD VSS.t4019 VDD VDD sky130_fd_pr__pfet_01v8_hvt ad=0.2262 pd=2.26 as=0 ps=0 w=0.87 l=4.73
X124 VSS.t3118 VDD VSS.t3117 VSS.t3116 sky130_fd_pr__nfet_01v8 ad=0.143 pd=1.62 as=0 ps=0 w=0.55 l=4.73
X125 _75_.CLK a_11413_16341.t37 VDD VDD sky130_fd_pr__pfet_01v8_hvt ad=0.14 pd=1.28 as=0.14 ps=1.28 w=1 l=0.15
X126 VDD VSS.t4251 VDD VDD sky130_fd_pr__pfet_01v8_hvt ad=0.2262 pd=2.26 as=0 ps=0 w=0.87 l=4.73
X127 VSS.t48 _63_.B a_6925_16143# VSS.t47 sky130_fd_pr__nfet_01v8 ad=0.169 pd=1.82 as=0.08775 ps=0.92 w=0.65 l=0.15
X128 VDD VSS.t3734 VDD VDD sky130_fd_pr__pfet_01v8_hvt ad=0.2262 pd=2.26 as=0 ps=0 w=0.87 l=4.73
X129 VSS.t1633 VDD VSS.t1632 VSS.t1631 sky130_fd_pr__nfet_01v8 ad=0.143 pd=1.62 as=0 ps=0 w=0.55 l=4.73
X130 a_25460_15797# input2.X.t5 VDD VDD sky130_fd_pr__pfet_01v8_hvt ad=0.1113 pd=1.37 as=0.1113 ps=1.37 w=0.42 l=0.15
X131 VSS.t3336 hold12.A a_28017_15823# VSS.t3335 sky130_fd_pr__nfet_01v8 ad=0.0567 pd=0.69 as=0.1092 ps=1.36 w=0.42 l=0.15
X132 VSS.t689 VDD VSS.t688 VSS.t687 sky130_fd_pr__nfet_01v8 ad=0.143 pd=1.62 as=0 ps=0 w=0.55 l=4.73
X133 VSS.t2434 VDD VSS.t2433 VSS.t2432 sky130_fd_pr__nfet_01v8 ad=0.143 pd=1.62 as=0 ps=0 w=0.55 l=4.73
X134 VSS.t1624 VDD VSS.t1623 VSS.t1622 sky130_fd_pr__nfet_01v8 ad=0.143 pd=1.62 as=0 ps=0 w=0.55 l=4.73
X135 VDD VSS.t3776 VDD VDD sky130_fd_pr__pfet_01v8_hvt ad=0.2262 pd=2.26 as=0 ps=0 w=0.87 l=4.73
X136 VSS.t1206 VDD VSS.t1205 VSS.t1204 sky130_fd_pr__nfet_01v8 ad=0.143 pd=1.62 as=0 ps=0 w=0.55 l=1.97
X137 VSS.t387 VDD VSS.t386 VSS.t385 sky130_fd_pr__nfet_01v8 ad=0.143 pd=1.62 as=0 ps=0 w=0.55 l=4.73
X138 VSS.t2598 VDD VSS.t2597 VSS.t2596 sky130_fd_pr__nfet_01v8 ad=0.143 pd=1.62 as=0 ps=0 w=0.55 l=1.97
X139 VSS.t605 VDD VSS.t604 VSS.t603 sky130_fd_pr__nfet_01v8 ad=0.143 pd=1.62 as=0 ps=0 w=0.55 l=2.89
X140 VSS.t1108 VDD VSS.t1107 VSS.t1106 sky130_fd_pr__nfet_01v8 ad=0.143 pd=1.62 as=0 ps=0 w=0.55 l=4.73
X141 VSS.t3211 VDD VSS.t3210 VSS.t3209 sky130_fd_pr__nfet_01v8 ad=0.143 pd=1.62 as=0 ps=0 w=0.55 l=4.73
X142 VSS.t2589 VDD VSS.t2588 VSS.t2587 sky130_fd_pr__nfet_01v8 ad=0.143 pd=1.62 as=0 ps=0 w=0.55 l=4.73
X143 _44_.Y _36_.A.t2 VDD VDD sky130_fd_pr__pfet_01v8_hvt ad=0.135 pd=1.27 as=0.26 ps=2.52 w=1 l=0.15
X144 VDD VSS.t4081 VDD VDD sky130_fd_pr__pfet_01v8_hvt ad=0.2262 pd=2.26 as=0 ps=0 w=0.87 l=4.73
X145 VDD VSS.t3684 VDD VDD sky130_fd_pr__pfet_01v8_hvt ad=0.2262 pd=2.26 as=0 ps=0 w=0.87 l=4.73
X146 VSS.t2744 VDD VSS.t2743 VSS.t2742 sky130_fd_pr__nfet_01v8 ad=0.143 pd=1.62 as=0 ps=0 w=0.55 l=1.97
X147 VSS.t2810 VDD VSS.t2809 VSS.t2808 sky130_fd_pr__nfet_01v8 ad=0.143 pd=1.62 as=0 ps=0 w=0.55 l=4.73
X148 VSS.t1460 VDD VSS.t1459 VSS.t1458 sky130_fd_pr__nfet_01v8 ad=0.143 pd=1.62 as=0 ps=0 w=0.55 l=4.73
X149 VSS.t2786 VDD VSS.t2786 VSS.t2781 sky130_fd_pr__nfet_01v8 ad=0.143 pd=1.62 as=0 ps=0 w=0.55 l=0.59
X150 VDD VSS.t3945 VDD VDD sky130_fd_pr__pfet_01v8_hvt ad=0.2262 pd=2.26 as=0 ps=0 w=0.87 l=4.73
X151 VDD VSS.t3610 VDD VDD sky130_fd_pr__pfet_01v8_hvt ad=0.2262 pd=2.26 as=0 ps=0 w=0.87 l=4.73
X152 VSS.t2923 VDD VSS.t2922 VSS.t2921 sky130_fd_pr__nfet_01v8 ad=0.143 pd=1.62 as=0 ps=0 w=0.55 l=4.73
X153 VDD VSS.t4046 VDD VDD sky130_fd_pr__pfet_01v8_hvt ad=0.2262 pd=2.26 as=0 ps=0 w=0.87 l=4.73
X154 VSS.t134 a_18298_16479# a_18256_16367# VSS.t133 sky130_fd_pr__nfet_01v8 ad=0.12095 pd=1.085 as=0.0696 ps=0.765 w=0.42 l=0.15
X155 VDD VSS.t3839 VDD VDD sky130_fd_pr__pfet_01v8_hvt ad=0.2262 pd=2.26 as=0 ps=0 w=0.87 l=4.73
X156 VDD VSS.t3538 VDD VDD sky130_fd_pr__pfet_01v8_hvt ad=0.2262 pd=2.26 as=0 ps=0 w=0.87 l=4.73
X157 VDD a_21914_15823.t7 _77_.CLK VDD sky130_fd_pr__pfet_01v8_hvt ad=0.265 pd=2.53 as=0.14 ps=1.28 w=1 l=0.15
X158 a_20407_15431# a_20503_15253# VSS.t121 VSS.t120 sky130_fd_pr__nfet_01v8 ad=0.169 pd=1.82 as=0.08775 ps=0.92 w=0.65 l=0.15
X159 VDD VSS.t4248 VDD VDD sky130_fd_pr__pfet_01v8_hvt ad=0.2262 pd=2.26 as=0 ps=0 w=0.87 l=4.73
X160 VSS.t2828 VDD VSS.t2827 VSS.t2826 sky130_fd_pr__nfet_01v8 ad=0.143 pd=1.62 as=0 ps=0 w=0.55 l=1.97
X161 VSS.t1851 VDD VSS.t1850 VSS.t1849 sky130_fd_pr__nfet_01v8 ad=0.143 pd=1.62 as=0 ps=0 w=0.55 l=4.73
X162 VDD VSS.t4017 VDD VDD sky130_fd_pr__pfet_01v8_hvt ad=0.2262 pd=2.26 as=0 ps=0 w=0.87 l=1.97
X163 VSS.t72 a_26339_15279# _53_.X VSS.t71 sky130_fd_pr__nfet_01v8 ad=0.169 pd=1.82 as=0.08775 ps=0.92 w=0.65 l=0.15
X164 VSS.t2998 VDD VSS.t2997 VSS.t2996 sky130_fd_pr__nfet_01v8 ad=0.143 pd=1.62 as=0 ps=0 w=0.55 l=4.73
X165 VDD VSS.t3661 VDD VDD sky130_fd_pr__pfet_01v8_hvt ad=0.2262 pd=2.26 as=0 ps=0 w=0.87 l=4.73
X166 VSS.t1842 VDD VSS.t1841 VSS.t1840 sky130_fd_pr__nfet_01v8 ad=0.143 pd=1.62 as=0 ps=0 w=0.55 l=4.73
X167 VDD VSS.t3924 VDD VDD sky130_fd_pr__pfet_01v8_hvt ad=0.2262 pd=2.26 as=0 ps=0 w=0.87 l=4.73
X168 clkbuf_0_clock_i.X a_16762_15823.t21 VDD VDD sky130_fd_pr__pfet_01v8_hvt ad=0.14 pd=1.28 as=0.14 ps=1.28 w=1 l=0.15
X169 VDD VSS.t3571 VDD VDD sky130_fd_pr__pfet_01v8_hvt ad=0.2262 pd=2.26 as=0 ps=0 w=0.87 l=4.73
X170 VDD VSS.t3633 VDD VDD sky130_fd_pr__pfet_01v8_hvt ad=0.2262 pd=2.26 as=0 ps=0 w=0.87 l=1.97
X171 VDD VSS.t3706 VDD VDD sky130_fd_pr__pfet_01v8_hvt ad=0.2262 pd=2.26 as=0 ps=0 w=0.87 l=4.73
X172 VSS.t2890 VDD VSS.t2889 VSS.t2781 sky130_fd_pr__nfet_01v8 ad=0.143 pd=1.62 as=0 ps=0 w=0.55 l=4.73
X173 VDD VSS.t3495 VDD VDD sky130_fd_pr__pfet_01v8_hvt ad=0.2262 pd=2.26 as=0 ps=0 w=0.87 l=4.73
X174 VSS.t1006 VDD VSS.t1005 VSS.t1004 sky130_fd_pr__nfet_01v8 ad=0.143 pd=1.62 as=0 ps=0 w=0.55 l=1.97
X175 VSS.t809 VDD VSS.t808 VSS.t807 sky130_fd_pr__nfet_01v8 ad=0.143 pd=1.62 as=0 ps=0 w=0.55 l=4.73
X176 a_18555_16733# a_17691_16367# a_18298_16479# VDD sky130_fd_pr__pfet_01v8_hvt ad=0.0567 pd=0.69 as=0.1095 ps=1.075 w=0.42 l=0.15
X177 VDD VSS.t4137 VDD VDD sky130_fd_pr__pfet_01v8_hvt ad=0.2262 pd=2.26 as=0 ps=0 w=0.87 l=4.73
X178 VSS.t369 VDD VSS.t368 VSS.t367 sky130_fd_pr__nfet_01v8 ad=0.143 pd=1.62 as=0 ps=0 w=0.55 l=4.73
X179 counter_value_o[7] a_37471_16919# VDD VDD sky130_fd_pr__pfet_01v8_hvt ad=0.135 pd=1.27 as=0.149 ps=1.325 w=1 l=0.15
X180 a_6493_16395# input2.X.t16 a_6407_16395# VSS.t42 sky130_fd_pr__nfet_01v8 ad=0.0567 pd=0.69 as=0.1176 ps=1.4 w=0.42 l=0.15
X181 VDD VSS.t3535 VDD VDD sky130_fd_pr__pfet_01v8_hvt ad=0.2262 pd=2.26 as=0 ps=0 w=0.87 l=4.73
X182 VSS.t3163 VDD VSS.t3162 VSS.t3161 sky130_fd_pr__nfet_01v8 ad=0.143 pd=1.62 as=0 ps=0 w=0.55 l=0.59
X183 VSS.t1400 VDD VSS.t1399 VSS.t1398 sky130_fd_pr__nfet_01v8 ad=0.143 pd=1.62 as=0 ps=0 w=0.55 l=4.73
X184 a_27133_16367# _54_.Y hold12.A VSS.t3287 sky130_fd_pr__nfet_01v8 ad=0.08775 pd=0.92 as=0.169 ps=1.82 w=0.65 l=0.15
X185 _77_.CLK a_21914_15823.t16 VDD VDD sky130_fd_pr__pfet_01v8_hvt ad=0.14 pd=1.28 as=0.14 ps=1.28 w=1 l=0.15
X186 VSS.t2177 VDD VSS.t2176 VSS.t2175 sky130_fd_pr__nfet_01v8 ad=0.143 pd=1.62 as=0 ps=0 w=0.55 l=4.73
X187 VSS.t1445 VDD VSS.t1444 VSS.t1443 sky130_fd_pr__nfet_01v8 ad=0.143 pd=1.62 as=0 ps=0 w=0.55 l=4.73
X188 VDD _77_.Q _50_.A2 VDD sky130_fd_pr__pfet_01v8_hvt ad=0.165 pd=1.33 as=0.135 ps=1.27 w=1 l=0.15
X189 VSS.t3202 VDD VSS.t3201 VSS.t3200 sky130_fd_pr__nfet_01v8 ad=0.143 pd=1.62 as=0 ps=0 w=0.55 l=4.73
X190 VDD VSS.t4174 VDD VDD sky130_fd_pr__pfet_01v8_hvt ad=0.2262 pd=2.26 as=0 ps=0 w=0.87 l=4.73
X191 VDD VSS.t3943 VDD VDD sky130_fd_pr__pfet_01v8_hvt ad=0.2262 pd=2.26 as=0 ps=0 w=0.87 l=1.97
X192 VSS.t393 VDD VSS.t392 VSS.t391 sky130_fd_pr__nfet_01v8 ad=0.143 pd=1.62 as=0 ps=0 w=0.55 l=2.89
X193 VSS.t2081 VDD VSS.t2080 VSS.t2079 sky130_fd_pr__nfet_01v8 ad=0.143 pd=1.62 as=0 ps=0 w=0.55 l=4.73
X194 VDD VSS.t3950 VDD VDD sky130_fd_pr__pfet_01v8_hvt ad=0.2262 pd=2.26 as=0 ps=0 w=0.87 l=4.73
X195 a_12391_15823# a_11693_15829# a_12134_15797# VSS.t34 sky130_fd_pr__special_nfet_01v8 ad=0.0684 pd=0.74 as=0.0989 ps=0.995 w=0.36 l=0.15
X196 VSS.t2696 VDD VSS.t2695 VSS.t2694 sky130_fd_pr__nfet_01v8 ad=0.143 pd=1.62 as=0 ps=0 w=0.55 l=4.73
X197 a_7825_16367# a_6835_16367# a_7699_16733# VSS.t3419 sky130_fd_pr__special_nfet_01v8 ad=0.066 pd=0.745 as=0.0684 ps=0.74 w=0.36 l=0.15
X198 VDD VSS.t4401 VDD VDD sky130_fd_pr__pfet_01v8_hvt ad=0.2262 pd=2.26 as=0 ps=0 w=0.87 l=0.59
X199 VDD _57_.Y a_26965_16617# VDD sky130_fd_pr__pfet_01v8_hvt ad=0.135 pd=1.27 as=0.135 ps=1.27 w=1 l=0.15
X200 VSS.t1388 VDD VSS.t1387 VSS.t1386 sky130_fd_pr__nfet_01v8 ad=0.143 pd=1.62 as=0 ps=0 w=0.55 l=4.73
X201 VSS.t2308 VDD VSS.t2307 VSS.t2306 sky130_fd_pr__nfet_01v8 ad=0.143 pd=1.62 as=0 ps=0 w=0.55 l=4.73
X202 a_16762_15823.t0 clock_i VSS.t3358 VSS.t3357 sky130_fd_pr__nfet_01v8 ad=0.0588 pd=0.7 as=0.1113 ps=1.37 w=0.42 l=0.15
X203 VSS.t2732 VDD VSS.t2731 VSS.t2730 sky130_fd_pr__nfet_01v8 ad=0.143 pd=1.62 as=0 ps=0 w=0.55 l=4.73
X204 _38_.A a_18183_17249# VSS.t3284 VSS.t3283 sky130_fd_pr__nfet_01v8 ad=0.182 pd=1.86 as=0.1118 ps=1.04 w=0.65 l=0.15
X205 VDD VSS.t4324 VDD VDD sky130_fd_pr__pfet_01v8_hvt ad=0.2262 pd=2.26 as=0 ps=0 w=0.87 l=4.73
X206 VDD VSS.t3554 VDD VDD sky130_fd_pr__pfet_01v8_hvt ad=0.2262 pd=2.26 as=0 ps=0 w=0.87 l=4.73
X207 a_20540_16617# _42_.A2 VDD VDD sky130_fd_pr__pfet_01v8_hvt ad=0.265 pd=2.53 as=0.14 ps=1.28 w=1 l=0.15
X208 VSS.t2571 VDD VSS.t2571 VSS.t2566 sky130_fd_pr__nfet_01v8 ad=0.143 pd=1.62 as=0 ps=0 w=0.55 l=0.59
X209 VSS.t696 VDD VSS.t602 VSS.t695 sky130_fd_pr__nfet_01v8 ad=0.143 pd=1.62 as=0 ps=0 w=0.55 l=4.73
X210 a_25148_15279# _50_.A2 VSS.t201 VSS.t3281 sky130_fd_pr__nfet_01v8 ad=0.0588 pd=0.7 as=0.0588 ps=0.7 w=0.42 l=0.15
X211 VDD VSS.t4067 VDD VDD sky130_fd_pr__pfet_01v8_hvt ad=0.2262 pd=2.26 as=0 ps=0 w=0.87 l=4.73
X212 VDD VSS.t407 VDD VDD sky130_fd_pr__pfet_01v8_hvt ad=0.2262 pd=2.26 as=0 ps=0 w=0.87 l=1.05
X213 a_20722_15279# a_20407_15431# VSS.t3430 VSS.t3429 sky130_fd_pr__nfet_01v8 ad=0.066 pd=0.745 as=0.1092 ps=1.36 w=0.42 l=0.15
X214 VSS.t2392 VDD VSS.t2391 VSS.t2390 sky130_fd_pr__nfet_01v8 ad=0.143 pd=1.62 as=0 ps=0 w=0.55 l=4.73
X215 VDD VSS.t3790 VDD VDD sky130_fd_pr__pfet_01v8_hvt ad=0.2262 pd=2.26 as=0 ps=0 w=0.87 l=4.73
X216 VSS.t1153 VDD VSS.t1152 VSS.t1151 sky130_fd_pr__nfet_01v8 ad=0.143 pd=1.62 as=0 ps=0 w=0.55 l=4.73
X217 VSS.t863 VDD VSS.t862 VSS.t861 sky130_fd_pr__nfet_01v8 ad=0.143 pd=1.62 as=0 ps=0 w=0.55 l=4.73
X218 VSS.t929 VDD VSS.t928 VSS.t927 sky130_fd_pr__nfet_01v8 ad=0.143 pd=1.62 as=0 ps=0 w=0.55 l=4.73
X219 VDD VSS.t4104 VDD VDD sky130_fd_pr__pfet_01v8_hvt ad=0.2262 pd=2.26 as=0 ps=0 w=0.87 l=4.73
X220 VDD VSS.t4179 VDD VDD sky130_fd_pr__pfet_01v8_hvt ad=0.2262 pd=2.26 as=0 ps=0 w=0.87 l=4.73
X221 VDD VSS.t3637 VDD VDD sky130_fd_pr__pfet_01v8_hvt ad=0.2262 pd=2.26 as=0 ps=0 w=0.87 l=4.73
X222 VSS.t2538 VDD VSS.t2537 VSS.t2536 sky130_fd_pr__nfet_01v8 ad=0.143 pd=1.62 as=0 ps=0 w=0.55 l=4.73
X223 VDD a_11413_16341.t30 _75_.CLK VDD sky130_fd_pr__pfet_01v8_hvt ad=0.14 pd=1.28 as=0.14 ps=1.28 w=1 l=0.15
X224 VDD VSS.t4234 VDD VDD sky130_fd_pr__pfet_01v8_hvt ad=0.2262 pd=2.26 as=0 ps=0 w=0.87 l=4.73
X225 a_25320_16143# _51_.X.t3 VSS.t159 VSS.t158 sky130_fd_pr__nfet_01v8 ad=0.091 pd=0.93 as=0.17225 ps=1.83 w=0.65 l=0.15
X226 VDD _63_.B a_6883_16055# VDD sky130_fd_pr__pfet_01v8_hvt ad=0.3 pd=2.6 as=0.135 ps=1.27 w=1 l=0.15
X227 VSS.t2765 VDD VSS.t2764 VSS.t2763 sky130_fd_pr__nfet_01v8 ad=0.143 pd=1.62 as=0 ps=0 w=0.55 l=4.73
X228 VDD VSS.t3515 VDD VDD sky130_fd_pr__pfet_01v8_hvt ad=0.2262 pd=2.26 as=0 ps=0 w=0.87 l=4.73
X229 VSS.t1741 VDD VSS.t1740 VSS.t1739 sky130_fd_pr__nfet_01v8 ad=0.143 pd=1.62 as=0 ps=0 w=0.55 l=4.73
X230 VDD VSS.t3667 VDD VDD sky130_fd_pr__pfet_01v8_hvt ad=0.2262 pd=2.26 as=0 ps=0 w=0.87 l=1.97
X231 VDD VSS.t3812 VDD VDD sky130_fd_pr__pfet_01v8_hvt ad=0.2262 pd=2.26 as=0 ps=0 w=0.87 l=1.97
X232 VSS.t1233 VDD VSS.t1232 VSS.t1231 sky130_fd_pr__nfet_01v8 ad=0.143 pd=1.62 as=0 ps=0 w=0.55 l=4.73
X233 _36_.B.t0 _63_.A.t14 VDD VDD sky130_fd_pr__pfet_01v8_hvt ad=0.135 pd=1.27 as=0.135 ps=1.27 w=1 l=0.15
X234 VSS.t30 _38_.A a_18611_15831# VSS.t29 sky130_fd_pr__nfet_01v8 ad=0.097 pd=0.975 as=0.1092 ps=1.36 w=0.42 l=0.15
X235 VDD VSS.t2904 VDD VDD sky130_fd_pr__pfet_01v8_hvt ad=0.2262 pd=2.26 as=0 ps=0 w=0.87 l=4.73
X236 VSS.t2469 VDD VSS.t2468 VSS.t2467 sky130_fd_pr__nfet_01v8 ad=0.143 pd=1.62 as=0 ps=0 w=0.55 l=4.73
X237 VDD VSS.t1818 VDD VDD sky130_fd_pr__pfet_01v8_hvt ad=0.2262 pd=2.26 as=0 ps=0 w=0.87 l=0.59
X238 VSS.t1487 VDD VSS.t1486 VSS.t1485 sky130_fd_pr__nfet_01v8 ad=0.143 pd=1.62 as=0 ps=0 w=0.55 l=4.73
X239 _36_.B.t2 _67_.A.t11 VDD VDD sky130_fd_pr__pfet_01v8_hvt ad=0.135 pd=1.27 as=0.135 ps=1.27 w=1 l=0.15
X240 VSS.t3130 VDD VSS.t3129 VSS.t3128 sky130_fd_pr__nfet_01v8 ad=0.143 pd=1.62 as=0 ps=0 w=0.55 l=4.73
X241 VDD VSS.t3720 VDD VDD sky130_fd_pr__pfet_01v8_hvt ad=0.2262 pd=2.26 as=0 ps=0 w=0.87 l=4.73
X242 VDD VSS.t4122 VDD VDD sky130_fd_pr__pfet_01v8_hvt ad=0.2262 pd=2.26 as=0 ps=0 w=0.87 l=4.73
X243 VDD VSS.t4217 VDD VDD sky130_fd_pr__pfet_01v8_hvt ad=0.2262 pd=2.26 as=0 ps=0 w=0.87 l=4.73
X244 VSS.t2849 VDD VSS.t2848 VSS.t2847 sky130_fd_pr__nfet_01v8 ad=0.143 pd=1.62 as=0 ps=0 w=0.55 l=4.73
X245 VSS.t2658 VDD VSS.t2657 VSS.t2656 sky130_fd_pr__nfet_01v8 ad=0.143 pd=1.62 as=0 ps=0 w=0.55 l=1.97
X246 VDD VSS.t4195 VDD VDD sky130_fd_pr__pfet_01v8_hvt ad=0.2262 pd=2.26 as=0 ps=0 w=0.87 l=4.73
X247 VDD VSS.t3509 VDD VDD sky130_fd_pr__pfet_01v8_hvt ad=0.2262 pd=2.26 as=0 ps=0 w=0.87 l=4.73
X248 VDD VSS.t4109 VDD VDD sky130_fd_pr__pfet_01v8_hvt ad=0.2262 pd=2.26 as=0 ps=0 w=0.87 l=4.73
X249 VDD VSS.t4365 VDD VDD sky130_fd_pr__pfet_01v8_hvt ad=0.2262 pd=2.26 as=0 ps=0 w=0.87 l=0.59
X250 VDD VSS.t441 VDD VDD sky130_fd_pr__pfet_01v8_hvt ad=0.2262 pd=2.26 as=0 ps=0 w=0.87 l=0.59
X251 VSS.t3076 VDD VSS.t3075 VSS.t3074 sky130_fd_pr__nfet_01v8 ad=0.143 pd=1.62 as=0 ps=0 w=0.55 l=1.97
X252 VDD VSS.t4254 VDD VDD sky130_fd_pr__pfet_01v8_hvt ad=0.2262 pd=2.26 as=0 ps=0 w=0.87 l=4.73
X253 VSS.t1780 VDD VSS.t1779 VSS.t1778 sky130_fd_pr__nfet_01v8 ad=0.143 pd=1.62 as=0 ps=0 w=0.55 l=4.73
X254 VDD VSS.t3983 VDD VDD sky130_fd_pr__pfet_01v8_hvt ad=0.2262 pd=2.26 as=0 ps=0 w=0.87 l=1.97
X255 VDD a_29027_16635# a_28943_16733# VDD sky130_fd_pr__pfet_01v8_hvt ad=0.1113 pd=1.37 as=0.0882 ps=0.84 w=0.42 l=0.15
X256 VDD VSS.t4261 VDD VDD sky130_fd_pr__pfet_01v8_hvt ad=0.2262 pd=2.26 as=0 ps=0 w=0.87 l=4.73
X257 VDD VSS.t4239 VDD VDD sky130_fd_pr__pfet_01v8_hvt ad=0.2262 pd=2.26 as=0 ps=0 w=0.87 l=4.73
X258 VDD VSS.t4339 VDD VDD sky130_fd_pr__pfet_01v8_hvt ad=0.2262 pd=2.26 as=0 ps=0 w=0.87 l=4.73
X259 VSS.t3151 VDD VSS.t3150 VSS.t3149 sky130_fd_pr__nfet_01v8 ad=0.143 pd=1.62 as=0 ps=0 w=0.55 l=4.73
X260 VDD VSS.t3628 VDD VDD sky130_fd_pr__pfet_01v8_hvt ad=0.2262 pd=2.26 as=0 ps=0 w=0.87 l=1.97
X261 VDD VSS.t3742 VDD VDD sky130_fd_pr__pfet_01v8_hvt ad=0.2262 pd=2.26 as=0 ps=0 w=0.87 l=1.97
X262 VDD VSS.t3986 VDD VDD sky130_fd_pr__pfet_01v8_hvt ad=0.2262 pd=2.26 as=0 ps=0 w=0.87 l=4.73
X263 VDD VSS.t4387 VDD VDD sky130_fd_pr__pfet_01v8_hvt ad=0.2262 pd=2.26 as=0 ps=0 w=0.87 l=4.73
X264 VSS.t276 VDD VSS.t275 VSS.t274 sky130_fd_pr__nfet_01v8 ad=0.143 pd=1.62 as=0 ps=0 w=0.55 l=0.59
X265 VSS.t967 VDD VSS.t966 VSS.t965 sky130_fd_pr__nfet_01v8 ad=0.143 pd=1.62 as=0 ps=0 w=0.55 l=4.73
X266 VSS.t1099 VDD VSS.t1098 VSS.t1097 sky130_fd_pr__nfet_01v8 ad=0.143 pd=1.62 as=0 ps=0 w=0.55 l=4.73
X267 VSS.t1033 VDD VSS.t1032 VSS.t1031 sky130_fd_pr__nfet_01v8 ad=0.143 pd=1.62 as=0 ps=0 w=0.55 l=4.73
X268 VSS.t2102 VDD VSS.t2101 VSS.t2100 sky130_fd_pr__nfet_01v8 ad=0.143 pd=1.62 as=0 ps=0 w=0.55 l=4.73
X269 VSS.t1517 VDD VSS.t1516 VSS.t1515 sky130_fd_pr__nfet_01v8 ad=0.143 pd=1.62 as=0 ps=0 w=0.55 l=4.73
X270 VDD VSS.t3668 VDD VDD sky130_fd_pr__pfet_01v8_hvt ad=0.2262 pd=2.26 as=0 ps=0 w=0.87 l=4.73
X271 VSS.t1971 VDD VSS.t1970 VSS.t1969 sky130_fd_pr__nfet_01v8 ad=0.143 pd=1.62 as=0 ps=0 w=0.55 l=4.73
X272 VDD a_21914_15823.t9 _77_.CLK VDD sky130_fd_pr__pfet_01v8_hvt ad=0.14 pd=1.28 as=0.14 ps=1.28 w=1 l=0.15
X273 VDD VSS.t3896 VDD VDD sky130_fd_pr__pfet_01v8_hvt ad=0.2262 pd=2.26 as=0 ps=0 w=0.87 l=4.73
X274 VSS.t1606 VDD VSS.t1605 VSS.t1604 sky130_fd_pr__nfet_01v8 ad=0.143 pd=1.62 as=0 ps=0 w=0.55 l=2.89
X275 VDD VSS.t4052 VDD VDD sky130_fd_pr__pfet_01v8_hvt ad=0.2262 pd=2.26 as=0 ps=0 w=0.87 l=4.73
X276 VSS.t121 a_20407_15431# _77_.Q VSS.t3428 sky130_fd_pr__nfet_01v8 ad=0.08775 pd=0.92 as=0.169 ps=1.82 w=0.65 l=0.15
X277 VSS.t2257 VDD VSS.t2256 VSS.t2255 sky130_fd_pr__nfet_01v8 ad=0.143 pd=1.62 as=0 ps=0 w=0.55 l=4.73
X278 VSS.t2192 VDD VSS.t2191 VSS.t2190 sky130_fd_pr__nfet_01v8 ad=0.143 pd=1.62 as=0 ps=0 w=0.55 l=4.73
X279 VSS.t1492 VDD VSS.t1491 VSS.t1488 sky130_fd_pr__nfet_01v8 ad=0.143 pd=1.62 as=0 ps=0 w=0.55 l=1.97
X280 VSS.t534 VDD VSS.t533 VSS.t532 sky130_fd_pr__nfet_01v8 ad=0.143 pd=1.62 as=0 ps=0 w=0.55 l=4.73
X281 _36_.Y a_17987_15279# a_18225_15279# VSS.t3393 sky130_fd_pr__nfet_01v8 ad=0.195 pd=1.9 as=0.08775 ps=0.92 w=0.65 l=0.15
X282 VDD VSS.t1600 VDD VDD sky130_fd_pr__pfet_01v8_hvt ad=0.2262 pd=2.26 as=0 ps=0 w=0.87 l=0.59
X283 VSS.t1472 VDD VSS.t1471 VSS.t1470 sky130_fd_pr__nfet_01v8 ad=0.143 pd=1.62 as=0 ps=0 w=0.55 l=4.73
X284 VDD VSS.t4165 VDD VDD sky130_fd_pr__pfet_01v8_hvt ad=0.2262 pd=2.26 as=0 ps=0 w=0.87 l=4.73
X285 VDD VSS.t3657 VDD VDD sky130_fd_pr__pfet_01v8_hvt ad=0.2262 pd=2.26 as=0 ps=0 w=0.87 l=4.73
X286 VDD VSS.t4358 VDD VDD sky130_fd_pr__pfet_01v8_hvt ad=0.2262 pd=2.26 as=0 ps=0 w=0.87 l=2.89
X287 VSS.t1818 VDD VSS.t1818 VSS.t1817 sky130_fd_pr__nfet_01v8 ad=0.143 pd=1.62 as=0 ps=0 w=0.55 l=0.59
X288 a_27366_16055# _55_.A_N VSS.t89 VSS.t3275 sky130_fd_pr__nfet_01v8 ad=0.1092 pd=1.36 as=0.10025 ps=0.985 w=0.42 l=0.15
X289 _50_.B1.t0 a_27923_15547# VSS.t232 VSS.t3330 sky130_fd_pr__nfet_01v8 ad=0.169 pd=1.82 as=0.08775 ps=0.92 w=0.65 l=0.15
X290 VSS.t230 a_23027_14735# _48_.X VSS.t229 sky130_fd_pr__nfet_01v8 ad=0.169 pd=1.82 as=0.08775 ps=0.92 w=0.65 l=0.15
X291 VSS.t28 a_12684_16885# counter_value_o[2] VSS.t27 sky130_fd_pr__nfet_01v8 ad=0.097 pd=0.975 as=0.08775 ps=0.92 w=0.65 l=0.15
X292 VDD VSS.t3618 VDD VDD sky130_fd_pr__pfet_01v8_hvt ad=0.2262 pd=2.26 as=0 ps=0 w=0.87 l=4.73
X293 VSS.t2237 VDD VSS.t2236 VSS.t2235 sky130_fd_pr__nfet_01v8 ad=0.143 pd=1.62 as=0 ps=0 w=0.55 l=4.73
X294 a_23009_15279# a_22843_15279# VDD VDD sky130_fd_pr__pfet_01v8_hvt ad=0.1664 pd=1.8 as=0.0864 ps=0.91 w=0.64 l=0.15
X295 VDD VSS.t3621 VDD VDD sky130_fd_pr__pfet_01v8_hvt ad=0.2262 pd=2.26 as=0 ps=0 w=0.87 l=4.73
X296 VDD VSS.t553 VDD VDD sky130_fd_pr__pfet_01v8_hvt ad=0.2262 pd=2.26 as=0 ps=0 w=0.87 l=4.73
X297 VSS.t2140 VDD VSS.t2139 VSS.t2136 sky130_fd_pr__nfet_01v8 ad=0.143 pd=1.62 as=0 ps=0 w=0.55 l=1.97
X298 _77_.CLK a_21914_15823.t18 VDD VDD sky130_fd_pr__pfet_01v8_hvt ad=0.14 pd=1.28 as=0.14 ps=1.28 w=1 l=0.15
X299 VSS.t1723 VDD VSS.t1722 VSS.t1721 sky130_fd_pr__nfet_01v8 ad=0.143 pd=1.62 as=0 ps=0 w=0.55 l=1.05
X300 VDD VSS.t4298 VDD VDD sky130_fd_pr__pfet_01v8_hvt ad=0.2262 pd=2.26 as=0 ps=0 w=0.87 l=4.73
X301 VSS.t2974 VDD VSS.t2973 VSS.t2972 sky130_fd_pr__nfet_01v8 ad=0.143 pd=1.62 as=0 ps=0 w=0.55 l=1.97
X302 VDD VSS.t3651 VDD VDD sky130_fd_pr__pfet_01v8_hvt ad=0.2262 pd=2.26 as=0 ps=0 w=0.87 l=4.73
X303 VSS.t2254 VDD VSS.t2253 VSS.t2252 sky130_fd_pr__nfet_01v8 ad=0.143 pd=1.62 as=0 ps=0 w=0.55 l=4.73
X304 VDD VSS.t4035 VDD VDD sky130_fd_pr__pfet_01v8_hvt ad=0.2262 pd=2.26 as=0 ps=0 w=0.87 l=4.73
X305 _48_.X a_23027_14735# VDD VDD sky130_fd_pr__pfet_01v8_hvt ad=0.135 pd=1.27 as=0.135 ps=1.27 w=1 l=0.15
X306 VSS.t2646 VDD VSS.t2645 VSS.t2644 sky130_fd_pr__nfet_01v8 ad=0.143 pd=1.62 as=0 ps=0 w=0.55 l=4.73
X307 _50_.A2 _36_.A.t8 VDD VDD sky130_fd_pr__pfet_01v8_hvt ad=0.135 pd=1.27 as=0.26 ps=2.52 w=1 l=0.15
X308 VSS.t614 VDD VSS.t613 VSS.t612 sky130_fd_pr__nfet_01v8 ad=0.143 pd=1.62 as=0 ps=0 w=0.55 l=4.73
X309 VSS.t2729 VDD VSS.t2728 VSS.t2727 sky130_fd_pr__nfet_01v8 ad=0.143 pd=1.62 as=0 ps=0 w=0.55 l=1.97
X310 VDD VSS.t4140 VDD VDD sky130_fd_pr__pfet_01v8_hvt ad=0.2262 pd=2.26 as=0 ps=0 w=0.87 l=4.73
X311 VSS.t973 VDD VSS.t972 VSS.t971 sky130_fd_pr__nfet_01v8 ad=0.143 pd=1.62 as=0 ps=0 w=0.55 l=4.73
X312 _51_.X.t1 a_24777_15939# VDD VDD sky130_fd_pr__pfet_01v8_hvt ad=0.28 pd=2.56 as=0.14825 ps=1.34 w=1 l=0.15
X313 VDD VSS.t516 VDD VDD sky130_fd_pr__pfet_01v8_hvt ad=0.2262 pd=2.26 as=0 ps=0 w=0.87 l=0.59
X314 a_20787_15253.t1 _77_.CLK VDD VDD sky130_fd_pr__pfet_01v8_hvt ad=0.1664 pd=1.8 as=0.0864 ps=0.91 w=0.64 l=0.15
X315 VDD VSS.t3857 VDD VDD sky130_fd_pr__pfet_01v8_hvt ad=0.2262 pd=2.26 as=0 ps=0 w=0.87 l=4.73
X316 VSS.t860 VDD VSS.t859 VSS.t858 sky130_fd_pr__nfet_01v8 ad=0.143 pd=1.62 as=0 ps=0 w=0.55 l=1.05
X317 VDD VSS.t3830 VDD VDD sky130_fd_pr__pfet_01v8_hvt ad=0.2262 pd=2.26 as=0 ps=0 w=0.87 l=4.73
X318 VDD input2.X.t13 a_20267_16733# VDD sky130_fd_pr__pfet_01v8_hvt ad=0.1113 pd=1.37 as=0.1113 ps=1.37 w=0.42 l=0.15
X319 VSS.t2407 VDD VSS.t2406 VSS.t2405 sky130_fd_pr__nfet_01v8 ad=0.143 pd=1.62 as=0 ps=0 w=0.55 l=4.73
X320 VDD VSS.t3785 VDD VDD sky130_fd_pr__pfet_01v8_hvt ad=0.2262 pd=2.26 as=0 ps=0 w=0.87 l=4.73
X321 VDD _55_.A_N a_37471_16919# VDD sky130_fd_pr__pfet_01v8_hvt ad=0.149 pd=1.325 as=0.1664 ps=1.8 w=0.64 l=0.15
X322 VDD VSS.t3696 VDD VDD sky130_fd_pr__pfet_01v8_hvt ad=0.2262 pd=2.26 as=0 ps=0 w=0.87 l=4.73
X323 VDD clkbuf_0_clock_i.X a_11413_16341.t7 VDD sky130_fd_pr__pfet_01v8_hvt ad=0.265 pd=2.53 as=0.14 ps=1.28 w=1 l=0.15
X324 VDD VSS.t4390 VDD VDD sky130_fd_pr__pfet_01v8_hvt ad=0.2262 pd=2.26 as=0 ps=0 w=0.87 l=4.73
X325 VSS.t596 VDD VSS.t595 VSS.t594 sky130_fd_pr__nfet_01v8 ad=0.143 pd=1.62 as=0 ps=0 w=0.55 l=1.97
X326 VDD VSS.t3543 VDD VDD sky130_fd_pr__pfet_01v8_hvt ad=0.2262 pd=2.26 as=0 ps=0 w=0.87 l=4.73
X327 VSS.t2332 VDD VSS.t2331 VSS.t2330 sky130_fd_pr__nfet_01v8 ad=0.143 pd=1.62 as=0 ps=0 w=0.55 l=4.73
X328 VDD VSS.t4095 VDD VDD sky130_fd_pr__pfet_01v8_hvt ad=0.2262 pd=2.26 as=0 ps=0 w=0.87 l=4.73
X329 a_5262_16341# a_5062_16641# a_5411_16367# VSS.t32 sky130_fd_pr__special_nfet_01v8 ad=0.0621 pd=0.705 as=0.0696 ps=0.765 w=0.36 l=0.15
X330 VDD VSS.t4278 VDD VDD sky130_fd_pr__pfet_01v8_hvt ad=0.2262 pd=2.26 as=0 ps=0 w=0.87 l=4.73
X331 VDD VSS.t1818 VDD VDD sky130_fd_pr__pfet_01v8_hvt ad=0.2262 pd=2.26 as=0 ps=0 w=0.87 l=0.59
X332 a_27253_17231# input2.X.t19 VSS.t41 VSS.t40 sky130_fd_pr__nfet_01v8 ad=0.08775 pd=0.92 as=0.169 ps=1.82 w=0.65 l=0.15
X333 _64_.X.t0 a_6407_16395# VSS.t181 VSS.t3298 sky130_fd_pr__nfet_01v8 ad=0.182 pd=1.86 as=0.1118 ps=1.04 w=0.65 l=0.15
X334 VSS.t611 VDD VSS.t610 VSS.t609 sky130_fd_pr__nfet_01v8 ad=0.143 pd=1.62 as=0 ps=0 w=0.55 l=4.73
X335 VDD VSS.t4170 VDD VDD sky130_fd_pr__pfet_01v8_hvt ad=0.2262 pd=2.26 as=0 ps=0 w=0.87 l=4.73
X336 VSS.t1009 VDD VSS.t1008 VSS.t1007 sky130_fd_pr__nfet_01v8 ad=0.143 pd=1.62 as=0 ps=0 w=0.55 l=4.73
X337 VDD VSS.t3805 VDD VDD sky130_fd_pr__pfet_01v8_hvt ad=0.2262 pd=2.26 as=0 ps=0 w=0.87 l=4.73
X338 VDD VSS.t281 VDD VDD sky130_fd_pr__pfet_01v8_hvt ad=0.2262 pd=2.26 as=0 ps=0 w=0.87 l=1.97
X339 VDD VSS.t4225 VDD VDD sky130_fd_pr__pfet_01v8_hvt ad=0.2262 pd=2.26 as=0 ps=0 w=0.87 l=4.73
X340 VDD VSS.t3887 VDD VDD sky130_fd_pr__pfet_01v8_hvt ad=0.2262 pd=2.26 as=0 ps=0 w=0.87 l=1.97
X341 VSS.t1365 VDD VSS.t1364 VSS.t1363 sky130_fd_pr__nfet_01v8 ad=0.143 pd=1.62 as=0 ps=0 w=0.55 l=1.97
X342 _67_.Y _67_.B a_9853_15823# VDD sky130_fd_pr__pfet_01v8_hvt ad=0.165 pd=1.33 as=0.105 ps=1.21 w=1 l=0.15
X343 VSS.t2452 VDD VSS.t2451 VSS.t2450 sky130_fd_pr__nfet_01v8 ad=0.143 pd=1.62 as=0 ps=0 w=0.55 l=4.73
X344 VDD VSS.t3770 VDD VDD sky130_fd_pr__pfet_01v8_hvt ad=0.2262 pd=2.26 as=0 ps=0 w=0.87 l=4.73
X345 counter_value_o[3] a_17652_16885# VSS.t92 VSS.t91 sky130_fd_pr__nfet_01v8 ad=0.08775 pd=0.92 as=0.17225 ps=1.83 w=0.65 l=0.15
X346 VDD VSS.t3463 VDD VDD sky130_fd_pr__pfet_01v8_hvt ad=0.2262 pd=2.26 as=0 ps=0 w=0.87 l=0.59
X347 VSS.t59 a_12559_15797# a_12517_16201# VSS.t58 sky130_fd_pr__nfet_01v8 ad=0.1092 pd=1.36 as=0.066 ps=0.745 w=0.42 l=0.15
X348 VDD VSS.t3479 VDD VDD sky130_fd_pr__pfet_01v8_hvt ad=0.2262 pd=2.26 as=0 ps=0 w=0.87 l=4.73
X349 a_24931_15939# _36_.B.t10 a_24859_15939# VDD sky130_fd_pr__pfet_01v8_hvt ad=0.0693 pd=0.75 as=0.0441 ps=0.63 w=0.42 l=0.15
X350 VSS.t2063 VDD VSS.t2062 VSS.t2061 sky130_fd_pr__nfet_01v8 ad=0.143 pd=1.62 as=0 ps=0 w=0.55 l=4.73
X351 VDD VSS.t4336 VDD VDD sky130_fd_pr__pfet_01v8_hvt ad=0.2262 pd=2.26 as=0 ps=0 w=0.87 l=4.73
X352 VDD VSS.t4320 VDD VDD sky130_fd_pr__pfet_01v8_hvt ad=0.2262 pd=2.26 as=0 ps=0 w=0.87 l=4.73
X353 VSS.t1179 VDD VSS.t1178 VSS.t1177 sky130_fd_pr__nfet_01v8 ad=0.143 pd=1.62 as=0 ps=0 w=0.55 l=4.73
X354 a_22480_17277# _44_.Y VSS.t63 VSS.t247 sky130_fd_pr__nfet_01v8 ad=0.0588 pd=0.7 as=0.0588 ps=0.7 w=0.42 l=0.15
X355 VSS.t593 VDD VSS.t592 VSS.t591 sky130_fd_pr__nfet_01v8 ad=0.143 pd=1.62 as=0 ps=0 w=0.55 l=1.97
X356 VSS.t2284 VDD VSS.t2283 VSS.t2282 sky130_fd_pr__nfet_01v8 ad=0.143 pd=1.62 as=0 ps=0 w=0.55 l=1.97
X357 VSS.t1356 VDD VSS.t1355 VSS.t1354 sky130_fd_pr__nfet_01v8 ad=0.143 pd=1.62 as=0 ps=0 w=0.55 l=4.73
X358 VSS.t395 VDD VSS.t394 VSS.t391 sky130_fd_pr__nfet_01v8 ad=0.143 pd=1.62 as=0 ps=0 w=0.55 l=0.59
X359 VSS.t824 VDD VSS.t823 VSS.t822 sky130_fd_pr__nfet_01v8 ad=0.143 pd=1.62 as=0 ps=0 w=0.55 l=4.73
X360 VDD VSS.t3502 VDD VDD sky130_fd_pr__pfet_01v8_hvt ad=0.2262 pd=2.26 as=0 ps=0 w=0.87 l=4.73
X361 VSS.t1260 VDD VSS.t1259 VSS.t1258 sky130_fd_pr__nfet_01v8 ad=0.143 pd=1.62 as=0 ps=0 w=0.55 l=4.73
X362 VDD VSS.t4296 VDD VDD sky130_fd_pr__pfet_01v8_hvt ad=0.2262 pd=2.26 as=0 ps=0 w=0.87 l=1.97
X363 VDD VSS.t3520 VDD VDD sky130_fd_pr__pfet_01v8_hvt ad=0.2262 pd=2.26 as=0 ps=0 w=0.87 l=4.73
X364 VDD VSS.t4070 VDD VDD sky130_fd_pr__pfet_01v8_hvt ad=0.2262 pd=2.26 as=0 ps=0 w=0.87 l=4.73
X365 VDD VSS.t4346 VDD VDD sky130_fd_pr__pfet_01v8_hvt ad=0.2262 pd=2.26 as=0 ps=0 w=0.87 l=4.73
X366 VSS.t569 VDD VSS.t568 VSS.t567 sky130_fd_pr__nfet_01v8 ad=0.143 pd=1.62 as=0 ps=0 w=0.55 l=4.73
X367 VDD VSS.t4040 VDD VDD sky130_fd_pr__pfet_01v8_hvt ad=0.2262 pd=2.26 as=0 ps=0 w=0.87 l=4.73
X368 VSS.t2138 VDD VSS.t2137 VSS.t2136 sky130_fd_pr__nfet_01v8 ad=0.143 pd=1.62 as=0 ps=0 w=0.55 l=4.73
X369 VSS.t1600 VDD VSS.t1600 VSS.t1599 sky130_fd_pr__nfet_01v8 ad=0.143 pd=1.62 as=0 ps=0 w=0.55 l=0.59
X370 VDD VSS.t3952 VDD VDD sky130_fd_pr__pfet_01v8_hvt ad=0.2262 pd=2.26 as=0 ps=0 w=0.87 l=1.97
X371 VSS.t726 VDD VSS.t725 VSS.t724 sky130_fd_pr__nfet_01v8 ad=0.143 pd=1.62 as=0 ps=0 w=0.55 l=4.73
X372 VSS.t485 VDD VSS.t484 VSS.t483 sky130_fd_pr__nfet_01v8 ad=0.143 pd=1.62 as=0 ps=0 w=0.55 l=4.73
X373 VDD VSS.t3760 VDD VDD sky130_fd_pr__pfet_01v8_hvt ad=0.2262 pd=2.26 as=0 ps=0 w=0.87 l=4.73
X374 VDD VSS.t4218 VDD VDD sky130_fd_pr__pfet_01v8_hvt ad=0.2262 pd=2.26 as=0 ps=0 w=0.87 l=1.05
X375 VSS.t1801 VDD VSS.t1800 VSS.t1799 sky130_fd_pr__nfet_01v8 ad=0.143 pd=1.62 as=0 ps=0 w=0.55 l=4.73
X376 a_23791_15645# a_23009_15279# a_23707_15645# VDD sky130_fd_pr__pfet_01v8_hvt ad=0.0882 pd=0.84 as=0.0567 ps=0.69 w=0.42 l=0.15
X377 VDD VSS.t3715 VDD VDD sky130_fd_pr__pfet_01v8_hvt ad=0.2262 pd=2.26 as=0 ps=0 w=0.87 l=4.73
X378 VDD VSS.t3933 VDD VDD sky130_fd_pr__pfet_01v8_hvt ad=0.2262 pd=2.26 as=0 ps=0 w=0.87 l=1.97
X379 VSS.t3401 a_1407_9839# input2.X.t1 VSS.t3400 sky130_fd_pr__nfet_01v8 ad=0.17225 pd=1.83 as=0.08775 ps=0.92 w=0.65 l=0.15
X380 VDD VSS.t1708 VDD VDD sky130_fd_pr__pfet_01v8_hvt ad=0.2262 pd=2.26 as=0 ps=0 w=0.87 l=0.59
X381 VSS.t920 VDD VSS.t919 VSS.t918 sky130_fd_pr__nfet_01v8 ad=0.143 pd=1.62 as=0 ps=0 w=0.55 l=1.97
X382 VSS.t2673 VDD VSS.t2672 VSS.t2671 sky130_fd_pr__nfet_01v8 ad=0.143 pd=1.62 as=0 ps=0 w=0.55 l=1.97
X383 VSS.t3115 VDD VSS.t3114 VSS.t3113 sky130_fd_pr__nfet_01v8 ad=0.143 pd=1.62 as=0 ps=0 w=0.55 l=4.73
X384 VDD VSS.t3936 VDD VDD sky130_fd_pr__pfet_01v8_hvt ad=0.2262 pd=2.26 as=0 ps=0 w=0.87 l=4.73
X385 VDD a_7716_16885# counter_value_o[1] VDD sky130_fd_pr__pfet_01v8_hvt ad=0.149 pd=1.325 as=0.135 ps=1.27 w=1 l=0.15
X386 VSS.t321 VDD VSS.t320 VSS.t319 sky130_fd_pr__nfet_01v8 ad=0.143 pd=1.62 as=0 ps=0 w=0.55 l=4.73
X387 VDD VSS.t3735 VDD VDD sky130_fd_pr__pfet_01v8_hvt ad=0.2262 pd=2.26 as=0 ps=0 w=0.87 l=4.73
X388 VDD VSS.t4100 VDD VDD sky130_fd_pr__pfet_01v8_hvt ad=0.2262 pd=2.26 as=0 ps=0 w=0.87 l=4.73
X389 VSS.t2293 VDD VSS.t2292 VSS.t2291 sky130_fd_pr__nfet_01v8 ad=0.143 pd=1.62 as=0 ps=0 w=0.55 l=4.73
X390 a_28434_16733# a_28161_16367# a_28349_16367# VDD sky130_fd_pr__pfet_01v8_hvt ad=0.06825 pd=0.745 as=0.05775 ps=0.695 w=0.42 l=0.15
X391 VDD VSS.t3700 VDD VDD sky130_fd_pr__pfet_01v8_hvt ad=0.2262 pd=2.26 as=0 ps=0 w=0.87 l=4.73
X392 VDD VSS.t4223 VDD VDD sky130_fd_pr__pfet_01v8_hvt ad=0.2262 pd=2.26 as=0 ps=0 w=0.87 l=1.97
X393 VDD VSS.t4230 VDD VDD sky130_fd_pr__pfet_01v8_hvt ad=0.2262 pd=2.26 as=0 ps=0 w=0.87 l=4.73
X394 VSS.t3169 VDD VSS.t3168 VSS.t3167 sky130_fd_pr__nfet_01v8 ad=0.143 pd=1.62 as=0 ps=0 w=0.55 l=4.73
X395 VDD VSS.t3966 VDD VDD sky130_fd_pr__pfet_01v8_hvt ad=0.2262 pd=2.26 as=0 ps=0 w=0.87 l=4.73
X396 VSS.t2586 VDD VSS.t2585 VSS.t2584 sky130_fd_pr__nfet_01v8 ad=0.143 pd=1.62 as=0 ps=0 w=0.55 l=4.73
X397 VDD VSS.t3903 VDD VDD sky130_fd_pr__pfet_01v8_hvt ad=0.2262 pd=2.26 as=0 ps=0 w=0.87 l=4.73
X398 VSS.t788 VDD VSS.t787 VSS.t786 sky130_fd_pr__nfet_01v8 ad=0.143 pd=1.62 as=0 ps=0 w=0.55 l=4.73
X399 VSS.t2520 VDD VSS.t2519 VSS.t2518 sky130_fd_pr__nfet_01v8 ad=0.143 pd=1.62 as=0 ps=0 w=0.55 l=4.73
X400 VSS.t1173 VDD VSS.t1172 VSS.t1171 sky130_fd_pr__nfet_01v8 ad=0.143 pd=1.62 as=0 ps=0 w=0.55 l=4.73
X401 VDD VSS.t3685 VDD VDD sky130_fd_pr__pfet_01v8_hvt ad=0.2262 pd=2.26 as=0 ps=0 w=0.87 l=4.73
X402 VSS.t2741 VDD VSS.t2740 VSS.t2739 sky130_fd_pr__nfet_01v8 ad=0.143 pd=1.62 as=0 ps=0 w=0.55 l=4.73
X403 VDD VSS.t3977 VDD VDD sky130_fd_pr__pfet_01v8_hvt ad=0.2262 pd=2.26 as=0 ps=0 w=0.87 l=4.73
X404 a_28859_16733# a_28161_16367# a_28602_16479# VSS.t3274 sky130_fd_pr__special_nfet_01v8 ad=0.0684 pd=0.74 as=0.0989 ps=0.995 w=0.36 l=0.15
X405 VSS.t436 _50_.B1.t4 a_24777_15939# VSS.t3265 sky130_fd_pr__nfet_01v8 ad=0.10187 pd=0.99 as=0.0567 ps=0.69 w=0.42 l=0.15
X406 VDD _50_.B1.t3 a_24931_15939# VDD sky130_fd_pr__pfet_01v8_hvt ad=0.14825 pd=1.34 as=0.0693 ps=0.75 w=0.42 l=0.15
X407 VSS.t764 VDD VSS.t763 VSS.t762 sky130_fd_pr__nfet_01v8 ad=0.143 pd=1.62 as=0 ps=0 w=0.55 l=4.73
X408 a_28434_16733# a_27995_16367# a_28349_16367# VSS.t15 sky130_fd_pr__special_nfet_01v8 ad=0.0621 pd=0.705 as=0.0813 ps=0.83 w=0.36 l=0.15
X409 VSS.t578 VDD VSS.t577 VSS.t576 sky130_fd_pr__nfet_01v8 ad=0.143 pd=1.62 as=0 ps=0 w=0.55 l=4.73
X410 VSS.t1072 VDD VSS.t1071 VSS.t1070 sky130_fd_pr__nfet_01v8 ad=0.143 pd=1.62 as=0 ps=0 w=0.55 l=4.73
X411 VSS.t1126 VDD VSS.t1125 VSS.t1124 sky130_fd_pr__nfet_01v8 ad=0.143 pd=1.62 as=0 ps=0 w=0.55 l=4.73
X412 counter_value_o[4] a_22843_16919# VDD VDD sky130_fd_pr__pfet_01v8_hvt ad=0.135 pd=1.27 as=0.149 ps=1.325 w=1 l=0.15
X413 VSS.t1060 VDD VSS.t1059 VSS.t1058 sky130_fd_pr__nfet_01v8 ad=0.143 pd=1.62 as=0 ps=0 w=0.55 l=4.73
X414 VSS.t1266 VDD VSS.t1265 VSS.t1264 sky130_fd_pr__nfet_01v8 ad=0.143 pd=1.62 as=0 ps=0 w=0.55 l=1.97
X415 VSS.t3223 VDD VSS.t3222 VSS.t3221 sky130_fd_pr__nfet_01v8 ad=0.143 pd=1.62 as=0 ps=0 w=0.55 l=4.73
X416 VSS.t1818 VDD VSS.t1818 VSS.t1817 sky130_fd_pr__nfet_01v8 ad=0.143 pd=1.62 as=0 ps=0 w=0.55 l=0.59
X417 VSS.t1639 VDD VSS.t1638 VSS.t1637 sky130_fd_pr__nfet_01v8 ad=0.143 pd=1.62 as=0 ps=0 w=0.55 l=4.73
X418 VDD VSS.t3972 VDD VDD sky130_fd_pr__pfet_01v8_hvt ad=0.2262 pd=2.26 as=0 ps=0 w=0.87 l=1.97
X419 a_4990_16367# a_4675_16519# VSS.t3415 VSS.t3414 sky130_fd_pr__nfet_01v8 ad=0.066 pd=0.745 as=0.1092 ps=1.36 w=0.42 l=0.15
X420 VDD _45_.Y a_23024_16617# VDD sky130_fd_pr__pfet_01v8_hvt ad=0.14 pd=1.28 as=0.14 ps=1.28 w=1 l=0.15
X421 VDD VSS.t3891 VDD VDD sky130_fd_pr__pfet_01v8_hvt ad=0.2262 pd=2.26 as=0 ps=0 w=0.87 l=4.73
X422 a_23009_15279# a_22843_15279# VSS.t197 VSS.t196 sky130_fd_pr__nfet_01v8 ad=0.1092 pd=1.36 as=0.0567 ps=0.69 w=0.42 l=0.15
X423 VSS.t2920 VDD VSS.t2919 VSS.t2918 sky130_fd_pr__nfet_01v8 ad=0.143 pd=1.62 as=0 ps=0 w=0.55 l=4.73
X424 VDD VSS.t3957 VDD VDD sky130_fd_pr__pfet_01v8_hvt ad=0.2262 pd=2.26 as=0 ps=0 w=0.87 l=1.97
X425 VSS.t1385 VDD VSS.t1385 VSS.t1384 sky130_fd_pr__nfet_01v8 ad=0.143 pd=1.62 as=0 ps=0 w=0.55 l=0.59
X426 VDD a_27535_16919# counter_value_o[5] VDD sky130_fd_pr__pfet_01v8_hvt ad=0.265 pd=2.53 as=0.135 ps=1.27 w=1 l=0.15
X427 a_18298_16479# a_18130_16733# VDD VDD sky130_fd_pr__pfet_01v8_hvt ad=0.1095 pd=1.075 as=0.17887 ps=1.26 w=0.75 l=0.15
X428 VDD VSS.t4198 VDD VDD sky130_fd_pr__pfet_01v8_hvt ad=0.2262 pd=2.26 as=0 ps=0 w=0.87 l=1.97
X429 VSS.t2604 VDD VSS.t2603 VSS.t2602 sky130_fd_pr__nfet_01v8 ad=0.143 pd=1.62 as=0 ps=0 w=0.55 l=4.73
X430 VSS.t905 VDD VSS.t904 VSS.t903 sky130_fd_pr__nfet_01v8 ad=0.143 pd=1.62 as=0 ps=0 w=0.55 l=1.97
X431 VDD VSS.t4156 VDD VDD sky130_fd_pr__pfet_01v8_hvt ad=0.2262 pd=2.26 as=0 ps=0 w=0.87 l=4.73
X432 a_21143_15279# a_20923_15279# VSS.t3321 VSS.t3320 sky130_fd_pr__nfet_01v8 ad=0.0696 pd=0.765 as=0.12095 ps=1.085 w=0.42 l=0.15
X433 VDD VSS.t4370 VDD VDD sky130_fd_pr__pfet_01v8_hvt ad=0.2262 pd=2.26 as=0 ps=0 w=0.87 l=4.73
X434 VSS.t2995 VDD VSS.t2994 VSS.t2993 sky130_fd_pr__nfet_01v8 ad=0.143 pd=1.62 as=0 ps=0 w=0.55 l=4.73
X435 VDD VSS.t3662 VDD VDD sky130_fd_pr__pfet_01v8_hvt ad=0.2262 pd=2.26 as=0 ps=0 w=0.87 l=4.73
X436 VSS.t2750 VDD VSS.t2749 VSS.t2748 sky130_fd_pr__nfet_01v8 ad=0.143 pd=1.62 as=0 ps=0 w=0.55 l=4.73
X437 VSS.t516 VDD VSS.t516 VSS.t515 sky130_fd_pr__nfet_01v8 ad=0.143 pd=1.62 as=0 ps=0 w=0.55 l=0.59
X438 VDD VSS.t3634 VDD VDD sky130_fd_pr__pfet_01v8_hvt ad=0.2262 pd=2.26 as=0 ps=0 w=0.87 l=4.73
X439 VDD _60_.X a_4535_15823# VDD sky130_fd_pr__pfet_01v8_hvt ad=0.11455 pd=1.08 as=0.2054 ps=2.1 w=0.79 l=0.15
X440 a_20787_15253.t0 _77_.CLK VSS.t266 VSS.t265 sky130_fd_pr__nfet_01v8 ad=0.1092 pd=1.36 as=0.0567 ps=0.69 w=0.42 l=0.15
X441 _63_.B output3.A.t16 VDD VDD sky130_fd_pr__pfet_01v8_hvt ad=0.135 pd=1.27 as=0.26 ps=2.52 w=1 l=0.15
X442 VSS.t433 VDD VSS.t433 VSS.t432 sky130_fd_pr__nfet_01v8 ad=0.143 pd=1.62 as=0 ps=0 w=0.55 l=1.97
X443 VDD a_21914_15823.t21 _77_.CLK VDD sky130_fd_pr__pfet_01v8_hvt ad=0.14 pd=1.28 as=0.14 ps=1.28 w=1 l=0.15
X444 VDD VSS.t3496 VDD VDD sky130_fd_pr__pfet_01v8_hvt ad=0.2262 pd=2.26 as=0 ps=0 w=0.87 l=4.73
X445 VDD a_21914_15823.t11 _77_.CLK VDD sky130_fd_pr__pfet_01v8_hvt ad=0.14 pd=1.28 as=0.14 ps=1.28 w=1 l=0.15
X446 VSS.t1568 VDD VSS.t1567 VSS.t1566 sky130_fd_pr__nfet_01v8 ad=0.143 pd=1.62 as=0 ps=0 w=0.55 l=4.73
X447 VDD VSS.t4001 VDD VDD sky130_fd_pr__pfet_01v8_hvt ad=0.2262 pd=2.26 as=0 ps=0 w=0.87 l=4.73
X448 VSS.t312 VDD VSS.t311 VSS.t310 sky130_fd_pr__nfet_01v8 ad=0.143 pd=1.62 as=0 ps=0 w=0.55 l=4.73
X449 VSS.t3058 VDD VSS.t3057 VSS.t3056 sky130_fd_pr__nfet_01v8 ad=0.143 pd=1.62 as=0 ps=0 w=0.55 l=4.73
X450 VSS.t677 VDD VSS.t676 VSS.t675 sky130_fd_pr__nfet_01v8 ad=0.143 pd=1.62 as=0 ps=0 w=0.55 l=4.73
X451 VDD VSS.t3646 VDD VDD sky130_fd_pr__pfet_01v8_hvt ad=0.2262 pd=2.26 as=0 ps=0 w=0.87 l=4.73
X452 VDD VSS.t4026 VDD VDD sky130_fd_pr__pfet_01v8_hvt ad=0.2262 pd=2.26 as=0 ps=0 w=0.87 l=4.73
X453 VSS.t282 VDD VSS.t281 VSS.t280 sky130_fd_pr__nfet_01v8 ad=0.143 pd=1.62 as=0 ps=0 w=0.55 l=1.97
X454 VDD a_16762_15823.t12 clkbuf_0_clock_i.X VDD sky130_fd_pr__pfet_01v8_hvt ad=0.14 pd=1.28 as=0.14 ps=1.28 w=1 l=0.15
X455 VDD VSS.t4291 VDD VDD sky130_fd_pr__pfet_01v8_hvt ad=0.2262 pd=2.26 as=0 ps=0 w=0.87 l=4.73
X456 VSS.t773 VDD VSS.t772 VSS.t771 sky130_fd_pr__nfet_01v8 ad=0.143 pd=1.62 as=0 ps=0 w=0.55 l=4.73
X457 VDD VSS.t3536 VDD VDD sky130_fd_pr__pfet_01v8_hvt ad=0.2262 pd=2.26 as=0 ps=0 w=0.87 l=4.73
X458 VSS.t3160 VDD VSS.t3159 VSS.t3158 sky130_fd_pr__nfet_01v8 ad=0.143 pd=1.62 as=0 ps=0 w=0.55 l=4.73
X459 VSS.t1983 VDD VSS.t1982 VSS.t1981 sky130_fd_pr__nfet_01v8 ad=0.143 pd=1.62 as=0 ps=0 w=0.55 l=1.97
X460 VDD VSS.t4131 VDD VDD sky130_fd_pr__pfet_01v8_hvt ad=0.2262 pd=2.26 as=0 ps=0 w=0.87 l=4.73
X461 VDD VSS.t4149 VDD VDD sky130_fd_pr__pfet_01v8_hvt ad=0.2262 pd=2.26 as=0 ps=0 w=0.87 l=4.73
X462 VSS.t1857 VDD VSS.t1856 VSS.t1855 sky130_fd_pr__nfet_01v8 ad=0.143 pd=1.62 as=0 ps=0 w=0.55 l=4.73
X463 clkbuf_0_clock_i.X a_16762_15823.t33 VSS.t162 VSS.t161 sky130_fd_pr__nfet_01v8 ad=0.0588 pd=0.7 as=0.0588 ps=0.7 w=0.42 l=0.15
X464 VSS.t1132 VDD VSS.t1131 VSS.t1130 sky130_fd_pr__nfet_01v8 ad=0.143 pd=1.62 as=0 ps=0 w=0.55 l=4.73
X465 VDD VSS.t3483 VDD VDD sky130_fd_pr__pfet_01v8_hvt ad=0.2262 pd=2.26 as=0 ps=0 w=0.87 l=4.73
X466 VDD VSS.t3880 VDD VDD sky130_fd_pr__pfet_01v8_hvt ad=0.2262 pd=2.26 as=0 ps=0 w=0.87 l=4.73
X467 VSS.t495 VDD VSS.t494 VSS.t408 sky130_fd_pr__nfet_01v8 ad=0.143 pd=1.62 as=0 ps=0 w=0.55 l=4.73
X468 VSS.t2693 VDD VSS.t2692 VSS.t2691 sky130_fd_pr__nfet_01v8 ad=0.143 pd=1.62 as=0 ps=0 w=0.55 l=4.73
X469 VSS.t10 a_5262_16341# a_5191_16367# VSS.t9 sky130_fd_pr__nfet_01v8 ad=0.12095 pd=1.085 as=0.0989 ps=0.995 w=0.64 l=0.15
X470 VDD VSS.t3631 VDD VDD sky130_fd_pr__pfet_01v8_hvt ad=0.2262 pd=2.26 as=0 ps=0 w=0.87 l=4.73
X471 VSS.t1595 VDD VSS.t1594 VSS.t1593 sky130_fd_pr__nfet_01v8 ad=0.143 pd=1.62 as=0 ps=0 w=0.55 l=1.97
X472 a_11413_16341.t2 clkbuf_0_clock_i.X VSS.t3303 VSS.t3304 sky130_fd_pr__nfet_01v8 ad=0.0588 pd=0.7 as=0.0588 ps=0.7 w=0.42 l=0.15
X473 VDD VSS.t3559 VDD VDD sky130_fd_pr__pfet_01v8_hvt ad=0.2262 pd=2.26 as=0 ps=0 w=0.87 l=4.73
X474 a_27330_15645# a_27057_15279# a_27245_15279# VDD sky130_fd_pr__pfet_01v8_hvt ad=0.06825 pd=0.745 as=0.05775 ps=0.695 w=0.42 l=0.15
X475 VDD VSS.t4203 VDD VDD sky130_fd_pr__pfet_01v8_hvt ad=0.2262 pd=2.26 as=0 ps=0 w=0.87 l=1.97
X476 VDD VSS.t4086 VDD VDD sky130_fd_pr__pfet_01v8_hvt ad=0.2262 pd=2.26 as=0 ps=0 w=0.87 l=4.73
X477 _69_.A a_10547_16395# VSS.t195 VSS.t194 sky130_fd_pr__nfet_01v8 ad=0.182 pd=1.86 as=0.1118 ps=1.04 w=0.65 l=0.15
X478 input1.X.t2 a_1407_3311# VDD VDD sky130_fd_pr__pfet_01v8_hvt ad=0.135 pd=1.27 as=0.149 ps=1.325 w=1 l=0.15
X479 VSS.t1735 VDD VSS.t1734 VSS.t1733 sky130_fd_pr__nfet_01v8 ad=0.143 pd=1.62 as=0 ps=0 w=0.55 l=4.73
X480 VSS.t1666 VDD VSS.t1665 VSS.t1664 sky130_fd_pr__nfet_01v8 ad=0.143 pd=1.62 as=0 ps=0 w=0.55 l=1.97
X481 VDD _48_.A.t3 a_23027_14735# VDD sky130_fd_pr__pfet_01v8_hvt ad=0.135 pd=1.27 as=0.26 ps=2.52 w=1 l=0.15
X482 VSS.t1708 VDD VSS.t1708 VSS.t1703 sky130_fd_pr__nfet_01v8 ad=0.143 pd=1.62 as=0 ps=0 w=0.55 l=0.59
X483 VDD VSS.t3995 VDD VDD sky130_fd_pr__pfet_01v8_hvt ad=0.2262 pd=2.26 as=0 ps=0 w=0.87 l=4.73
X484 VSS.t1992 VDD VSS.t1991 VSS.t1990 sky130_fd_pr__nfet_01v8 ad=0.143 pd=1.62 as=0 ps=0 w=0.55 l=4.73
X485 VDD VSS.t3975 VDD VDD sky130_fd_pr__pfet_01v8_hvt ad=0.2262 pd=2.26 as=0 ps=0 w=0.87 l=2.89
X486 a_7716_16885# _63_.A.t16 VDD VDD sky130_fd_pr__pfet_01v8_hvt ad=0.1664 pd=1.8 as=0.149 ps=1.325 w=0.64 l=0.15
X487 VDD VSS.t3523 VDD VDD sky130_fd_pr__pfet_01v8_hvt ad=0.2262 pd=2.26 as=0 ps=0 w=0.87 l=1.97
X488 VSS.t2213 VDD VSS.t2212 VSS.t2211 sky130_fd_pr__nfet_01v8 ad=0.143 pd=1.62 as=0 ps=0 w=0.55 l=1.97
X489 VDD a_11413_16341.t32 _75_.CLK VDD sky130_fd_pr__pfet_01v8_hvt ad=0.1375 pd=1.275 as=0.14 ps=1.28 w=1 l=0.15
X490 a_27755_15645# a_27057_15279# a_27498_15391# VSS.t3344 sky130_fd_pr__special_nfet_01v8 ad=0.0684 pd=0.74 as=0.0989 ps=0.995 w=0.36 l=0.15
X491 VDD VSS.t3484 VDD VDD sky130_fd_pr__pfet_01v8_hvt ad=0.2262 pd=2.26 as=0 ps=0 w=0.87 l=4.73
X492 VSS.t3411 a_21914_15823.t33 _77_.CLK VSS.t3412 sky130_fd_pr__nfet_01v8 ad=0.0588 pd=0.7 as=0.0588 ps=0.7 w=0.42 l=0.15
X493 VDD VSS.t3673 VDD VDD sky130_fd_pr__pfet_01v8_hvt ad=0.2262 pd=2.26 as=0 ps=0 w=0.87 l=4.73
X494 VSS.t1382 VDD VSS.t1381 VSS.t1273 sky130_fd_pr__nfet_01v8 ad=0.143 pd=1.62 as=0 ps=0 w=0.55 l=4.73
X495 VSS.t1753 VDD VSS.t1752 VSS.t1751 sky130_fd_pr__nfet_01v8 ad=0.143 pd=1.62 as=0 ps=0 w=0.55 l=1.97
X496 VDD VSS.t4061 VDD VDD sky130_fd_pr__pfet_01v8_hvt ad=0.2262 pd=2.26 as=0 ps=0 w=0.87 l=4.73
X497 VDD VSS.t4079 VDD VDD sky130_fd_pr__pfet_01v8_hvt ad=0.2262 pd=2.26 as=0 ps=0 w=0.87 l=4.73
X498 VDD VSS.t3853 VDD VDD sky130_fd_pr__pfet_01v8_hvt ad=0.2262 pd=2.26 as=0 ps=0 w=0.87 l=1.97
X499 VSS.t1466 VDD VSS.t1465 VSS.t1464 sky130_fd_pr__nfet_01v8 ad=0.143 pd=1.62 as=0 ps=0 w=0.55 l=1.97
X500 VDD VSS.t4129 VDD VDD sky130_fd_pr__pfet_01v8_hvt ad=0.2262 pd=2.26 as=0 ps=0 w=0.87 l=4.73
X501 _50_.B1.t1 a_27923_15547# VDD VDD sky130_fd_pr__pfet_01v8_hvt ad=0.26 pd=2.52 as=0.135 ps=1.27 w=1 l=0.15
X502 VSS.t1493 VDD VSS.t1493 VSS.t1488 sky130_fd_pr__nfet_01v8 ad=0.143 pd=1.62 as=0 ps=0 w=0.55 l=0.59
X503 a_21341_15279# a_20794_15553# a_20994_15253# VDD sky130_fd_pr__pfet_01v8_hvt ad=0.05775 pd=0.695 as=0.06825 ps=0.745 w=0.42 l=0.15
X504 VSS.t1815 VDD VSS.t1814 VSS.t1703 sky130_fd_pr__nfet_01v8 ad=0.143 pd=1.62 as=0 ps=0 w=0.55 l=4.73
X505 VSS.t2344 VDD VSS.t2343 VSS.t2342 sky130_fd_pr__nfet_01v8 ad=0.143 pd=1.62 as=0 ps=0 w=0.55 l=1.97
X506 VSS.t1117 VDD VSS.t1116 VSS.t1115 sky130_fd_pr__nfet_01v8 ad=0.143 pd=1.62 as=0 ps=0 w=0.55 l=4.73
X507 a_12517_16201# a_11527_15829# a_12391_15823# VSS.t3391 sky130_fd_pr__special_nfet_01v8 ad=0.066 pd=0.745 as=0.0684 ps=0.74 w=0.36 l=0.15
X508 VSS.t947 VDD VSS.t946 VSS.t945 sky130_fd_pr__nfet_01v8 ad=0.143 pd=1.62 as=0 ps=0 w=0.55 l=4.73
X509 VDD VSS.t3453 VDD VDD sky130_fd_pr__pfet_01v8_hvt ad=0.2262 pd=2.26 as=0 ps=0 w=0.87 l=4.73
X510 VSS.t3267 a_23450_15391# a_23408_15279# VSS.t3266 sky130_fd_pr__nfet_01v8 ad=0.12095 pd=1.085 as=0.0696 ps=0.765 w=0.42 l=0.15
X511 _53_.X a_26339_15279# VDD VDD sky130_fd_pr__pfet_01v8_hvt ad=0.135 pd=1.27 as=0.135 ps=1.27 w=1 l=0.15
X512 VSS.t1884 VDD VSS.t1883 VSS.t1882 sky130_fd_pr__nfet_01v8 ad=0.143 pd=1.62 as=0 ps=0 w=0.55 l=1.97
X513 VSS.t2690 VDD VSS.t2689 VSS.t2688 sky130_fd_pr__nfet_01v8 ad=0.143 pd=1.62 as=0 ps=0 w=0.55 l=4.73
X514 VDD VSS.t3941 VDD VDD sky130_fd_pr__pfet_01v8_hvt ad=0.2262 pd=2.26 as=0 ps=0 w=0.87 l=4.73
X515 VDD VSS.t3692 VDD VDD sky130_fd_pr__pfet_01v8_hvt ad=0.2262 pd=2.26 as=0 ps=0 w=0.87 l=1.97
X516 VDD VSS.t740 VDD VDD sky130_fd_pr__pfet_01v8_hvt ad=0.2262 pd=2.26 as=0 ps=0 w=0.87 l=0.59
X517 VDD VSS.t3913 VDD VDD sky130_fd_pr__pfet_01v8_hvt ad=0.2262 pd=2.26 as=0 ps=0 w=0.87 l=1.97
X518 VSS.t1424 VDD VSS.t1423 VSS.t1422 sky130_fd_pr__nfet_01v8 ad=0.143 pd=1.62 as=0 ps=0 w=0.55 l=4.73
X519 VDD VSS.t3850 VDD VDD sky130_fd_pr__pfet_01v8_hvt ad=0.2262 pd=2.26 as=0 ps=0 w=0.87 l=4.73
X520 VDD VSS.t3549 VDD VDD sky130_fd_pr__pfet_01v8_hvt ad=0.2262 pd=2.26 as=0 ps=0 w=0.87 l=4.73
X521 VSS.t2428 VDD VSS.t2427 VSS.t2426 sky130_fd_pr__nfet_01v8 ad=0.143 pd=1.62 as=0 ps=0 w=0.55 l=1.97
X522 VSS.t1618 VDD VSS.t1617 VSS.t1616 sky130_fd_pr__nfet_01v8 ad=0.143 pd=1.62 as=0 ps=0 w=0.55 l=4.73
X523 VDD VSS.t3778 VDD VDD sky130_fd_pr__pfet_01v8_hvt ad=0.2262 pd=2.26 as=0 ps=0 w=0.87 l=1.97
X524 VSS.t1311 VDD VSS.t1310 VSS.t1309 sky130_fd_pr__nfet_01v8 ad=0.143 pd=1.62 as=0 ps=0 w=0.55 l=4.73
X525 a_23707_15645# a_22843_15279# a_23450_15391# VDD sky130_fd_pr__pfet_01v8_hvt ad=0.0567 pd=0.69 as=0.1095 ps=1.075 w=0.42 l=0.15
X526 VSS.t815 VDD VSS.t814 VSS.t813 sky130_fd_pr__nfet_01v8 ad=0.143 pd=1.62 as=0 ps=0 w=0.55 l=4.73
X527 VSS.t560 VDD VSS.t559 VSS.t558 sky130_fd_pr__nfet_01v8 ad=0.143 pd=1.62 as=0 ps=0 w=0.55 l=4.73
X528 VSS.t1935 VDD VSS.t1934 VSS.t1933 sky130_fd_pr__nfet_01v8 ad=0.143 pd=1.62 as=0 ps=0 w=0.55 l=4.73
X529 VSS.t378 VDD VSS.t377 VSS.t376 sky130_fd_pr__nfet_01v8 ad=0.143 pd=1.62 as=0 ps=0 w=0.55 l=4.73
X530 a_23377_15645# a_22843_15279# a_23282_15645# VDD sky130_fd_pr__pfet_01v8_hvt ad=0.07665 pd=0.785 as=0.06825 ps=0.745 w=0.42 l=0.15
X531 VDD VSS.t3524 VDD VDD sky130_fd_pr__pfet_01v8_hvt ad=0.2262 pd=2.26 as=0 ps=0 w=0.87 l=4.73
X532 VSS.t2466 VDD VSS.t2465 VSS.t2464 sky130_fd_pr__nfet_01v8 ad=0.143 pd=1.62 as=0 ps=0 w=0.55 l=4.73
X533 counter_value_o[1] a_7716_16885# VDD VDD sky130_fd_pr__pfet_01v8_hvt ad=0.135 pd=1.27 as=0.265 ps=2.53 w=1 l=0.15
X534 VSS.t2655 VDD VSS.t2654 VSS.t2653 sky130_fd_pr__nfet_01v8 ad=0.143 pd=1.62 as=0 ps=0 w=0.55 l=4.73
X535 VDD VSS.t3510 VDD VDD sky130_fd_pr__pfet_01v8_hvt ad=0.2262 pd=2.26 as=0 ps=0 w=0.87 l=4.73
X536 VSS.t1406 VDD VSS.t1405 VSS.t1404 sky130_fd_pr__nfet_01v8 ad=0.143 pd=1.62 as=0 ps=0 w=0.55 l=1.97
X537 VDD VSS.t4059 VDD VDD sky130_fd_pr__pfet_01v8_hvt ad=0.2262 pd=2.26 as=0 ps=0 w=0.87 l=4.73
X538 VSS.t1654 VDD VSS.t1653 VSS.t1652 sky130_fd_pr__nfet_01v8 ad=0.143 pd=1.62 as=0 ps=0 w=0.55 l=4.73
X539 VDD VSS.t4309 VDD VDD sky130_fd_pr__pfet_01v8_hvt ad=0.2262 pd=2.26 as=0 ps=0 w=0.87 l=4.73
X540 VSS.t1451 VDD VSS.t1450 VSS.t1449 sky130_fd_pr__nfet_01v8 ad=0.143 pd=1.62 as=0 ps=0 w=0.55 l=1.97
X541 a_5055_16341.t1 _75_.CLK VDD VDD sky130_fd_pr__pfet_01v8_hvt ad=0.1664 pd=1.8 as=0.0864 ps=0.91 w=0.64 l=0.15
X542 VDD VSS.t4172 VDD VDD sky130_fd_pr__pfet_01v8_hvt ad=0.2262 pd=2.26 as=0 ps=0 w=0.87 l=1.97
X543 VSS.t2114 VDD VSS.t2113 VSS.t2112 sky130_fd_pr__nfet_01v8 ad=0.143 pd=1.62 as=0 ps=0 w=0.55 l=1.97
X544 VDD VSS.t4134 VDD VDD sky130_fd_pr__pfet_01v8_hvt ad=0.2262 pd=2.26 as=0 ps=0 w=0.87 l=4.73
X545 VDD VSS.t3948 VDD VDD sky130_fd_pr__pfet_01v8_hvt ad=0.2262 pd=2.26 as=0 ps=0 w=0.87 l=4.73
X546 VDD VSS.t4384 VDD VDD sky130_fd_pr__pfet_01v8_hvt ad=0.2262 pd=2.26 as=0 ps=0 w=0.87 l=2.89
X547 VDD VSS.t4189 VDD VDD sky130_fd_pr__pfet_01v8_hvt ad=0.2262 pd=2.26 as=0 ps=0 w=0.87 l=4.73
X548 VDD VSS.t4283 VDD VDD sky130_fd_pr__pfet_01v8_hvt ad=0.2262 pd=2.26 as=0 ps=0 w=0.87 l=4.73
X549 VSS.t2619 VDD VSS.t2618 VSS.t2617 sky130_fd_pr__nfet_01v8 ad=0.143 pd=1.62 as=0 ps=0 w=0.55 l=4.73
X550 VDD VSS.t3892 VDD VDD sky130_fd_pr__pfet_01v8_hvt ad=0.2262 pd=2.26 as=0 ps=0 w=0.87 l=1.97
X551 VSS.t548 VDD VSS.t547 VSS.t546 sky130_fd_pr__nfet_01v8 ad=0.143 pd=1.62 as=0 ps=0 w=0.55 l=4.73
X552 VSS.t932 VDD VSS.t931 VSS.t930 sky130_fd_pr__nfet_01v8 ad=0.143 pd=1.62 as=0 ps=0 w=0.55 l=4.73
X553 VDD VSS.t3469 VDD VDD sky130_fd_pr__pfet_01v8_hvt ad=0.2262 pd=2.26 as=0 ps=0 w=0.87 l=0.59
X554 a_7274_16733# a_7001_16367# a_7189_16367# VDD sky130_fd_pr__pfet_01v8_hvt ad=0.06825 pd=0.745 as=0.05775 ps=0.695 w=0.42 l=0.15
X555 VSS.t3148 VDD VSS.t3147 VSS.t3146 sky130_fd_pr__nfet_01v8 ad=0.143 pd=1.62 as=0 ps=0 w=0.55 l=4.73
X556 VSS.t2341 VDD VSS.t2340 VSS.t2339 sky130_fd_pr__nfet_01v8 ad=0.143 pd=1.62 as=0 ps=0 w=0.55 l=4.73
X557 VDD VSS.t3456 VDD VDD sky130_fd_pr__pfet_01v8_hvt ad=0.2262 pd=2.26 as=0 ps=0 w=0.87 l=4.73
X558 VSS.t1499 VDD VSS.t1498 VSS.t1497 sky130_fd_pr__nfet_01v8 ad=0.143 pd=1.62 as=0 ps=0 w=0.55 l=4.73
X559 VSS.t1329 VDD VSS.t1328 VSS.t1327 sky130_fd_pr__nfet_01v8 ad=0.143 pd=1.62 as=0 ps=0 w=0.55 l=4.73
X560 VSS.t2664 VDD VSS.t2663 VSS.t2662 sky130_fd_pr__nfet_01v8 ad=0.143 pd=1.62 as=0 ps=0 w=0.55 l=4.73
X561 VSS.t1836 VDD VSS.t1835 VSS.t1834 sky130_fd_pr__nfet_01v8 ad=0.143 pd=1.62 as=0 ps=0 w=0.55 l=4.73
X562 VSS.t5 _77_.Q a_22843_16919# VSS.t4 sky130_fd_pr__nfet_01v8 ad=0.097 pd=0.975 as=0.1092 ps=1.36 w=0.42 l=0.15
X563 VSS.t261 _42_.A2 a_20624_16367# VSS.t260 sky130_fd_pr__nfet_01v8 ad=0.17225 pd=1.83 as=0.091 ps=0.93 w=0.65 l=0.15
X564 VDD VSS.t3708 VDD VDD sky130_fd_pr__pfet_01v8_hvt ad=0.2262 pd=2.26 as=0 ps=0 w=0.87 l=1.97
X565 VSS.t2885 VDD VSS.t2884 VSS.t2883 sky130_fd_pr__nfet_01v8 ad=0.143 pd=1.62 as=0 ps=0 w=0.55 l=4.73
X566 VDD VSS.t3992 VDD VDD sky130_fd_pr__pfet_01v8_hvt ad=0.2262 pd=2.26 as=0 ps=0 w=0.87 l=4.73
X567 VSS.t740 VDD VSS.t740 VSS.t739 sky130_fd_pr__nfet_01v8 ad=0.143 pd=1.62 as=0 ps=0 w=0.55 l=0.59
X568 a_7699_16733# a_7001_16367# a_7442_16479# VSS.t254 sky130_fd_pr__special_nfet_01v8 ad=0.0684 pd=0.74 as=0.0989 ps=0.995 w=0.36 l=0.15
X569 VSS.t755 VDD VSS.t754 VSS.t753 sky130_fd_pr__nfet_01v8 ad=0.143 pd=1.62 as=0 ps=0 w=0.55 l=4.73
X570 VDD VSS.t3669 VDD VDD sky130_fd_pr__pfet_01v8_hvt ad=0.2262 pd=2.26 as=0 ps=0 w=0.87 l=4.73
X571 VDD VSS.t3869 VDD VDD sky130_fd_pr__pfet_01v8_hvt ad=0.2262 pd=2.26 as=0 ps=0 w=0.87 l=4.73
X572 a_7274_16733# a_6835_16367# a_7189_16367# VSS.t3418 sky130_fd_pr__special_nfet_01v8 ad=0.0621 pd=0.705 as=0.0813 ps=0.83 w=0.36 l=0.15
X573 VDD VSS.t409 VDD VDD sky130_fd_pr__pfet_01v8_hvt ad=0.2262 pd=2.26 as=0 ps=0 w=0.87 l=2.89
X574 VSS.t3321 a_20994_15253# a_20923_15279# VSS.t3394 sky130_fd_pr__nfet_01v8 ad=0.12095 pd=1.085 as=0.0989 ps=0.995 w=0.64 l=0.15
X575 VSS.t2496 VDD VSS.t2495 VSS.t2494 sky130_fd_pr__nfet_01v8 ad=0.143 pd=1.62 as=0 ps=0 w=0.55 l=4.73
X576 VSS.t74 a_16762_15823.t26 clkbuf_0_clock_i.X VSS.t73 sky130_fd_pr__nfet_01v8 ad=0.0588 pd=0.7 as=0.0588 ps=0.7 w=0.42 l=0.15
X577 VSS.t800 VDD VSS.t799 VSS.t798 sky130_fd_pr__nfet_01v8 ad=0.143 pd=1.62 as=0 ps=0 w=0.55 l=4.73
X578 VDD VSS.t2678 VDD VDD sky130_fd_pr__pfet_01v8_hvt ad=0.2262 pd=2.26 as=0 ps=0 w=0.87 l=0.59
X579 VSS.t1603 VDD VSS.t1602 VSS.t1601 sky130_fd_pr__nfet_01v8 ad=0.143 pd=1.62 as=0 ps=0 w=0.55 l=4.73
X580 VSS.t2487 VDD VSS.t2486 VSS.t2485 sky130_fd_pr__nfet_01v8 ad=0.143 pd=1.62 as=0 ps=0 w=0.55 l=4.73
X581 VSS.t1872 VDD VSS.t1871 VSS.t1870 sky130_fd_pr__nfet_01v8 ad=0.143 pd=1.62 as=0 ps=0 w=0.55 l=4.73
X582 VSS.t1687 VDD VSS.t1686 VSS.t1685 sky130_fd_pr__nfet_01v8 ad=0.143 pd=1.62 as=0 ps=0 w=0.55 l=4.73
X583 VSS.t116 a_11413_16341.t8 _75_.CLK VSS.t115 sky130_fd_pr__nfet_01v8 ad=0.0588 pd=0.7 as=0.0588 ps=0.7 w=0.42 l=0.15
X584 VSS.t869 VDD VSS.t868 VSS.t867 sky130_fd_pr__nfet_01v8 ad=0.143 pd=1.62 as=0 ps=0 w=0.55 l=4.73
X585 VSS.t1159 VDD VSS.t1158 VSS.t1157 sky130_fd_pr__nfet_01v8 ad=0.143 pd=1.62 as=0 ps=0 w=0.55 l=4.73
X586 VDD VSS.t4102 VDD VDD sky130_fd_pr__pfet_01v8_hvt ad=0.2262 pd=2.26 as=0 ps=0 w=0.87 l=1.97
X587 VDD clkbuf_0_clock_i.X a_21914_15823.t6 VDD sky130_fd_pr__pfet_01v8_hvt ad=0.14 pd=1.28 as=0.14 ps=1.28 w=1 l=0.15
X588 VDD VSS.t3917 VDD VDD sky130_fd_pr__pfet_01v8_hvt ad=0.2262 pd=2.26 as=0 ps=0 w=0.87 l=4.73
X589 VDD VSS.t4064 VDD VDD sky130_fd_pr__pfet_01v8_hvt ad=0.2262 pd=2.26 as=0 ps=0 w=0.87 l=4.73
X590 VSS.t450 VDD VSS.t449 VSS.t448 sky130_fd_pr__nfet_01v8 ad=0.143 pd=1.62 as=0 ps=0 w=0.55 l=4.73
X591 VSS.t1212 VDD VSS.t1211 VSS.t1210 sky130_fd_pr__nfet_01v8 ad=0.143 pd=1.62 as=0 ps=0 w=0.55 l=4.73
X592 VDD VSS.t4314 VDD VDD sky130_fd_pr__pfet_01v8_hvt ad=0.2262 pd=2.26 as=0 ps=0 w=0.87 l=4.73
X593 a_8657_16367# _63_.A.t10 a_8573_16367# VSS.t145 sky130_fd_pr__nfet_01v8 ad=0.10725 pd=0.98 as=0.08775 ps=0.92 w=0.65 l=0.15
X594 VDD VSS.t4232 VDD VDD sky130_fd_pr__pfet_01v8_hvt ad=0.2262 pd=2.26 as=0 ps=0 w=0.87 l=1.97
X595 VDD VSS.t4194 VDD VDD sky130_fd_pr__pfet_01v8_hvt ad=0.2262 pd=2.26 as=0 ps=0 w=0.87 l=4.73
X596 VDD clock_i a_16762_15823.t3 VDD sky130_fd_pr__pfet_01v8_hvt ad=0.14 pd=1.28 as=0.14 ps=1.28 w=1 l=0.15
X597 VDD VSS.t3666 VDD VDD sky130_fd_pr__pfet_01v8_hvt ad=0.2262 pd=2.26 as=0 ps=0 w=0.87 l=4.73
X598 VDD VSS.t848 VDD VDD sky130_fd_pr__pfet_01v8_hvt ad=0.2262 pd=2.26 as=0 ps=0 w=0.87 l=0.59
X599 VSS.t1774 VDD VSS.t1773 VSS.t1772 sky130_fd_pr__nfet_01v8 ad=0.143 pd=1.62 as=0 ps=0 w=0.55 l=4.73
X600 VDD VSS.t3652 VDD VDD sky130_fd_pr__pfet_01v8_hvt ad=0.2262 pd=2.26 as=0 ps=0 w=0.87 l=4.73
X601 VSS.t2251 VDD VSS.t2250 VSS.t2249 sky130_fd_pr__nfet_01v8 ad=0.143 pd=1.62 as=0 ps=0 w=0.55 l=4.73
X602 VSS.t2007 VDD VSS.t2006 VSS.t2005 sky130_fd_pr__nfet_01v8 ad=0.143 pd=1.62 as=0 ps=0 w=0.55 l=4.73
X603 VSS.t2726 VDD VSS.t2725 VSS.t2724 sky130_fd_pr__nfet_01v8 ad=0.143 pd=1.62 as=0 ps=0 w=0.55 l=4.73
X604 _77_.CLK a_21914_15823.t26 VSS.t214 VSS.t213 sky130_fd_pr__nfet_01v8 ad=0.0588 pd=0.7 as=0.0588 ps=0.7 w=0.42 l=0.15
X605 VDD VSS.t740 VDD VDD sky130_fd_pr__pfet_01v8_hvt ad=0.2262 pd=2.26 as=0 ps=0 w=0.87 l=0.59
X606 VSS.t3284 _36_.Y a_18269_17249# VSS.t3378 sky130_fd_pr__nfet_01v8 ad=0.1118 pd=1.04 as=0.0567 ps=0.69 w=0.42 l=0.15
X607 VSS.t632 VDD VSS.t631 VSS.t630 sky130_fd_pr__nfet_01v8 ad=0.143 pd=1.62 as=0 ps=0 w=0.55 l=4.73
X608 VDD VSS.t3990 VDD VDD sky130_fd_pr__pfet_01v8_hvt ad=0.2262 pd=2.26 as=0 ps=0 w=0.87 l=4.73
X609 VSS.t3217 VDD VSS.t3216 VSS.t3215 sky130_fd_pr__nfet_01v8 ad=0.143 pd=1.62 as=0 ps=0 w=0.55 l=0.59
X610 VDD VSS.t3616 VDD VDD sky130_fd_pr__pfet_01v8_hvt ad=0.2262 pd=2.26 as=0 ps=0 w=0.87 l=4.73
X611 VDD VSS.t4246 VDD VDD sky130_fd_pr__pfet_01v8_hvt ad=0.2262 pd=2.26 as=0 ps=0 w=0.87 l=4.73
X612 VSS.t1905 VDD VSS.t1904 VSS.t1903 sky130_fd_pr__nfet_01v8 ad=0.143 pd=1.62 as=0 ps=0 w=0.55 l=4.73
X613 VSS.t154 a_11413_16341.t22 _75_.CLK VSS.t155 sky130_fd_pr__nfet_01v8 ad=0.0588 pd=0.7 as=0.0588 ps=0.7 w=0.42 l=0.15
X614 a_20745_15645# a_20407_15431# VDD VDD sky130_fd_pr__pfet_01v8_hvt ad=0.0882 pd=0.84 as=0.1113 ps=1.37 w=0.42 l=0.15
X615 VDD VSS.t4120 VDD VDD sky130_fd_pr__pfet_01v8_hvt ad=0.2262 pd=2.26 as=0 ps=0 w=0.87 l=4.73
X616 VSS.t400 VDD VSS.t399 VSS.t398 sky130_fd_pr__nfet_01v8 ad=0.143 pd=1.62 as=0 ps=0 w=0.55 l=4.73
X617 VDD VSS.t4215 VDD VDD sky130_fd_pr__pfet_01v8_hvt ad=0.2262 pd=2.26 as=0 ps=0 w=0.87 l=4.73
X618 VSS.t1 output3.A.t3 a_8951_16367# VSS.t3252 sky130_fd_pr__nfet_01v8 ad=0.08775 pd=0.92 as=0.08775 ps=0.92 w=0.65 l=0.15
X619 VSS.t456 VDD VSS.t455 VSS.t454 sky130_fd_pr__nfet_01v8 ad=0.143 pd=1.62 as=0 ps=0 w=0.55 l=1.97
X620 VDD VSS.t3888 VDD VDD sky130_fd_pr__pfet_01v8_hvt ad=0.2262 pd=2.26 as=0 ps=0 w=0.87 l=4.73
X621 VDD VSS.t3639 VDD VDD sky130_fd_pr__pfet_01v8_hvt ad=0.2262 pd=2.26 as=0 ps=0 w=0.87 l=4.73
X622 VSS.t1197 VDD VSS.t1196 VSS.t1195 sky130_fd_pr__nfet_01v8 ad=0.143 pd=1.62 as=0 ps=0 w=0.55 l=4.73
X623 VSS.t170 a_21914_15823.t35 _77_.CLK VSS.t171 sky130_fd_pr__nfet_01v8 ad=0.0588 pd=0.7 as=0.0588 ps=0.7 w=0.42 l=0.15
X624 VDD VSS.t3480 VDD VDD sky130_fd_pr__pfet_01v8_hvt ad=0.2262 pd=2.26 as=0 ps=0 w=0.87 l=4.73
X625 VDD VSS.t4252 VDD VDD sky130_fd_pr__pfet_01v8_hvt ad=0.2262 pd=2.26 as=0 ps=0 w=0.87 l=1.97
X626 VSS.t1541 VDD VSS.t1540 VSS.t1539 sky130_fd_pr__nfet_01v8 ad=0.143 pd=1.62 as=0 ps=0 w=0.55 l=4.73
X627 _70_.Q a_23875_15547# VSS.t185 VSS.t3397 sky130_fd_pr__nfet_01v8 ad=0.169 pd=1.82 as=0.08775 ps=0.92 w=0.65 l=0.15
X628 VDD VSS.t4371 VDD VDD sky130_fd_pr__pfet_01v8_hvt ad=0.2262 pd=2.26 as=0 ps=0 w=0.87 l=1.05
X629 VDD VSS.t4237 VDD VDD sky130_fd_pr__pfet_01v8_hvt ad=0.2262 pd=2.26 as=0 ps=0 w=0.87 l=1.97
X630 VSS.t2060 VDD VSS.t2059 VSS.t2058 sky130_fd_pr__nfet_01v8 ad=0.143 pd=1.62 as=0 ps=0 w=0.55 l=4.73
X631 VSS.t3229 VDD VSS.t3228 VSS.t3227 sky130_fd_pr__nfet_01v8 ad=0.143 pd=1.62 as=0 ps=0 w=0.55 l=4.73
X632 VDD VSS.t3908 VDD VDD sky130_fd_pr__pfet_01v8_hvt ad=0.2262 pd=2.26 as=0 ps=0 w=0.87 l=1.97
X633 VSS.t36 _60_.X a_4535_15823# VSS.t55 sky130_fd_pr__nfet_01v8 ad=0.0754 pd=0.81 as=0.1352 ps=1.56 w=0.52 l=0.15
X634 VDD VSS.t3845 VDD VDD sky130_fd_pr__pfet_01v8_hvt ad=0.2262 pd=2.26 as=0 ps=0 w=0.87 l=4.73
X635 a_5055_16341.t0 _75_.CLK VSS.t187 VSS.t186 sky130_fd_pr__nfet_01v8 ad=0.1092 pd=1.36 as=0.0567 ps=0.69 w=0.42 l=0.15
X636 VDD input1.X.t17 a_3889_16617# VDD sky130_fd_pr__pfet_01v8_hvt ad=0.135 pd=1.27 as=0.135 ps=1.27 w=1 l=0.15
X637 VSS.t330 VDD VSS.t329 VSS.t328 sky130_fd_pr__nfet_01v8 ad=0.143 pd=1.62 as=0 ps=0 w=0.55 l=2.89
X638 a_9727_16367# input1.X.t6 a_9369_16367# VSS.t3261 sky130_fd_pr__nfet_01v8 ad=0.08775 pd=0.92 as=0.08775 ps=0.92 w=0.65 l=0.15
X639 VSS.t662 VDD VSS.t661 VSS.t660 sky130_fd_pr__nfet_01v8 ad=0.143 pd=1.62 as=0 ps=0 w=0.55 l=4.73
X640 VSS.t848 VDD VSS.t848 VSS.t843 sky130_fd_pr__nfet_01v8 ad=0.143 pd=1.62 as=0 ps=0 w=0.55 l=0.59
X641 a_12134_15797# a_11966_15823# VDD VDD sky130_fd_pr__pfet_01v8_hvt ad=0.1095 pd=1.075 as=0.17887 ps=1.26 w=0.75 l=0.15
X642 VDD VSS.t4385 VDD VDD sky130_fd_pr__pfet_01v8_hvt ad=0.2262 pd=2.26 as=0 ps=0 w=0.87 l=0.59
X643 VSS.t2135 VDD VSS.t2134 VSS.t2133 sky130_fd_pr__nfet_01v8 ad=0.143 pd=1.62 as=0 ps=0 w=0.55 l=4.73
X644 VSS.t1338 VDD VSS.t1337 VSS.t1336 sky130_fd_pr__nfet_01v8 ad=0.143 pd=1.62 as=0 ps=0 w=0.55 l=4.73
X645 VDD VSS.t4021 VDD VDD sky130_fd_pr__pfet_01v8_hvt ad=0.2262 pd=2.26 as=0 ps=0 w=0.87 l=4.73
X646 VSS.t1105 VDD VSS.t1104 VSS.t1103 sky130_fd_pr__nfet_01v8 ad=0.143 pd=1.62 as=0 ps=0 w=0.55 l=1.97
X647 VSS.t236 _36_.B.t15 a_23352_16519# VSS.t235 sky130_fd_pr__nfet_01v8 ad=0.0567 pd=0.69 as=0.0567 ps=0.69 w=0.42 l=0.15
X648 VDD a_9523_16143# _67_.Y VDD sky130_fd_pr__pfet_01v8_hvt ad=0.36 pd=2.72 as=0.165 ps=1.33 w=1 l=0.15
X649 VSS.t842 VDD VSS.t841 VSS.t840 sky130_fd_pr__nfet_01v8 ad=0.143 pd=1.62 as=0 ps=0 w=0.55 l=4.73
X650 VDD a_22843_16919# counter_value_o[4] VDD sky130_fd_pr__pfet_01v8_hvt ad=0.265 pd=2.53 as=0.135 ps=1.27 w=1 l=0.15
X651 VDD _67_.A.t12 _36_.B.t3 VDD sky130_fd_pr__pfet_01v8_hvt ad=0.135 pd=1.27 as=0.135 ps=1.27 w=1 l=0.15
X652 _43_.X a_20359_14735# VSS.t127 VSS.t3348 sky130_fd_pr__nfet_01v8 ad=0.08775 pd=0.92 as=0.08775 ps=0.92 w=0.65 l=0.15
X653 VDD VSS.t3885 VDD VDD sky130_fd_pr__pfet_01v8_hvt ad=0.2262 pd=2.26 as=0 ps=0 w=0.87 l=4.73
X654 VDD a_18611_15831# _38_.X VDD sky130_fd_pr__pfet_01v8_hvt ad=0.265 pd=2.53 as=0.135 ps=1.27 w=1 l=0.15
X655 VDD VSS.t3577 VDD VDD sky130_fd_pr__pfet_01v8_hvt ad=0.2262 pd=2.26 as=0 ps=0 w=0.87 l=4.73
X656 VDD VSS.t3473 VDD VDD sky130_fd_pr__pfet_01v8_hvt ad=0.2262 pd=2.26 as=0 ps=0 w=0.87 l=4.73
X657 VSS.t1081 VDD VSS.t1080 VSS.t1079 sky130_fd_pr__nfet_01v8 ad=0.143 pd=1.62 as=0 ps=0 w=0.55 l=4.73
X658 _36_.B.t0 _63_.A.t12 VDD VDD sky130_fd_pr__pfet_01v8_hvt ad=0.135 pd=1.27 as=0.135 ps=1.27 w=1 l=0.15
X659 VSS.t637 VDD VSS.t636 VSS.t633 sky130_fd_pr__nfet_01v8 ad=0.143 pd=1.62 as=0 ps=0 w=0.55 l=1.97
X660 VSS.t617 VDD VSS.t616 VSS.t615 sky130_fd_pr__nfet_01v8 ad=0.143 pd=1.62 as=0 ps=0 w=0.55 l=4.73
X661 VDD VSS.t3505 VDD VDD sky130_fd_pr__pfet_01v8_hvt ad=0.2262 pd=2.26 as=0 ps=0 w=0.87 l=4.73
X662 VSS.t2195 VDD VSS.t2194 VSS.t2193 sky130_fd_pr__nfet_01v8 ad=0.143 pd=1.62 as=0 ps=0 w=0.55 l=4.73
X663 VDD VSS.t3937 VDD VDD sky130_fd_pr__pfet_01v8_hvt ad=0.2262 pd=2.26 as=0 ps=0 w=0.87 l=4.73
X664 VDD VSS.t4050 VDD VDD sky130_fd_pr__pfet_01v8_hvt ad=0.2262 pd=2.26 as=0 ps=0 w=0.87 l=4.73
X665 VDD a_20868_16519# _42_.A2 VDD sky130_fd_pr__pfet_01v8_hvt ad=0.14825 pd=1.34 as=0.28 ps=2.56 w=1 l=0.15
X666 VDD VSS.t966 VDD VDD sky130_fd_pr__pfet_01v8_hvt ad=0.2262 pd=2.26 as=0 ps=0 w=0.87 l=4.73
X667 VSS.t3031 VDD VSS.t3030 VSS.t3029 sky130_fd_pr__nfet_01v8 ad=0.143 pd=1.62 as=0 ps=0 w=0.55 l=1.97
X668 VSS.t1478 VDD VSS.t1477 VSS.t1476 sky130_fd_pr__nfet_01v8 ad=0.143 pd=1.62 as=0 ps=0 w=0.55 l=4.73
X669 VDD VSS.t4303 VDD VDD sky130_fd_pr__pfet_01v8_hvt ad=0.2262 pd=2.26 as=0 ps=0 w=0.87 l=2.89
X670 VDD a_27923_15547# a_27839_15645# VDD sky130_fd_pr__pfet_01v8_hvt ad=0.1113 pd=1.37 as=0.0882 ps=0.84 w=0.42 l=0.15
X671 VDD VSS.t4163 VDD VDD sky130_fd_pr__pfet_01v8_hvt ad=0.2262 pd=2.26 as=0 ps=0 w=0.87 l=4.73
X672 VDD VSS.t2678 VDD VDD sky130_fd_pr__pfet_01v8_hvt ad=0.2262 pd=2.26 as=0 ps=0 w=0.87 l=0.59
X673 VSS.t1651 VDD VSS.t1650 VSS.t1649 sky130_fd_pr__nfet_01v8 ad=0.143 pd=1.62 as=0 ps=0 w=0.55 l=1.97
X674 VSS.t2290 VDD VSS.t2289 VSS.t2288 sky130_fd_pr__nfet_01v8 ad=0.143 pd=1.62 as=0 ps=0 w=0.55 l=4.73
X675 VSS.t3022 VDD VSS.t3021 VSS.t3020 sky130_fd_pr__nfet_01v8 ad=0.143 pd=1.62 as=0 ps=0 w=0.55 l=4.73
X676 VDD VSS.t3607 VDD VDD sky130_fd_pr__pfet_01v8_hvt ad=0.2262 pd=2.26 as=0 ps=0 w=0.87 l=1.97
X677 VDD VSS.t3490 VDD VDD sky130_fd_pr__pfet_01v8_hvt ad=0.2262 pd=2.26 as=0 ps=0 w=0.87 l=4.73
X678 VSS.t1947 VDD VSS.t1946 VSS.t1945 sky130_fd_pr__nfet_01v8 ad=0.143 pd=1.62 as=0 ps=0 w=0.55 l=4.73
X679 VDD VSS.t3904 VDD VDD sky130_fd_pr__pfet_01v8_hvt ad=0.2262 pd=2.26 as=0 ps=0 w=0.87 l=4.73
X680 VDD VSS.t3931 VDD VDD sky130_fd_pr__pfet_01v8_hvt ad=0.2262 pd=2.26 as=0 ps=0 w=0.87 l=4.73
X681 VDD VSS.t3658 VDD VDD sky130_fd_pr__pfet_01v8_hvt ad=0.2262 pd=2.26 as=0 ps=0 w=0.87 l=1.05
X682 counter_value_o[6] a_32503_16919# VSS.t96 VSS.t95 sky130_fd_pr__nfet_01v8 ad=0.08775 pd=0.92 as=0.097 ps=0.975 w=0.65 l=0.15
X683 VDD VSS.t848 VDD VDD sky130_fd_pr__pfet_01v8_hvt ad=0.2262 pd=2.26 as=0 ps=0 w=0.87 l=0.59
X684 VDD VSS.t4033 VDD VDD sky130_fd_pr__pfet_01v8_hvt ad=0.2262 pd=2.26 as=0 ps=0 w=0.87 l=4.73
X685 VDD a_5055_16341.t5 a_5062_16641# VDD sky130_fd_pr__pfet_01v8_hvt ad=0.0864 pd=0.91 as=0.1664 ps=1.8 w=0.64 l=0.15
X686 a_11693_15829# a_11527_15829# VSS.t191 VSS.t3389 sky130_fd_pr__nfet_01v8 ad=0.1092 pd=1.36 as=0.0567 ps=0.69 w=0.42 l=0.15
X687 VSS.t3220 VDD VSS.t3219 VSS.t3218 sky130_fd_pr__nfet_01v8 ad=0.143 pd=1.62 as=0 ps=0 w=0.55 l=4.73
X688 VDD VSS.t4138 VDD VDD sky130_fd_pr__pfet_01v8_hvt ad=0.2262 pd=2.26 as=0 ps=0 w=0.87 l=1.97
X689 VDD VSS.t4041 VDD VDD sky130_fd_pr__pfet_01v8_hvt ad=0.2262 pd=2.26 as=0 ps=0 w=0.87 l=4.73
X690 VSS.t1344 VDD VSS.t1343 VSS.t1342 sky130_fd_pr__nfet_01v8 ad=0.143 pd=1.62 as=0 ps=0 w=0.55 l=4.73
X691 VDD VSS.t4391 VDD VDD sky130_fd_pr__pfet_01v8_hvt ad=0.2262 pd=2.26 as=0 ps=0 w=0.87 l=0.59
X692 VDD VSS.t3819 VDD VDD sky130_fd_pr__pfet_01v8_hvt ad=0.2262 pd=2.26 as=0 ps=0 w=0.87 l=4.73
X693 VDD VSS.t4146 VDD VDD sky130_fd_pr__pfet_01v8_hvt ad=0.2262 pd=2.26 as=0 ps=0 w=0.87 l=4.73
X694 VSS.t1090 VDD VSS.t1089 VSS.t1088 sky130_fd_pr__nfet_01v8 ad=0.143 pd=1.62 as=0 ps=0 w=0.55 l=1.97
X695 VDD VSS.t4267 VDD VDD sky130_fd_pr__pfet_01v8_hvt ad=0.2262 pd=2.26 as=0 ps=0 w=0.87 l=4.73
X696 VSS.t847 VDD VSS.t846 VSS.t843 sky130_fd_pr__nfet_01v8 ad=0.143 pd=1.62 as=0 ps=0 w=0.55 l=1.97
X697 VSS.t827 VDD VSS.t826 VSS.t825 sky130_fd_pr__nfet_01v8 ad=0.143 pd=1.62 as=0 ps=0 w=0.55 l=4.73
X698 VSS.t2601 VDD VSS.t2600 VSS.t2599 sky130_fd_pr__nfet_01v8 ad=0.143 pd=1.62 as=0 ps=0 w=0.55 l=4.73
X699 VSS.t2410 VDD VSS.t2409 VSS.t2408 sky130_fd_pr__nfet_01v8 ad=0.143 pd=1.62 as=0 ps=0 w=0.55 l=4.73
X700 VSS.t1965 VDD VSS.t1964 VSS.t1963 sky130_fd_pr__nfet_01v8 ad=0.143 pd=1.62 as=0 ps=0 w=0.55 l=4.73
X701 VDD VSS.t3532 VDD VDD sky130_fd_pr__pfet_01v8_hvt ad=0.2262 pd=2.26 as=0 ps=0 w=0.87 l=1.97
X702 VDD VSS.t3784 VDD VDD sky130_fd_pr__pfet_01v8_hvt ad=0.2262 pd=2.26 as=0 ps=0 w=0.87 l=4.73
X703 VSS.t1391 VDD VSS.t1390 VSS.t1389 sky130_fd_pr__nfet_01v8 ad=0.143 pd=1.62 as=0 ps=0 w=0.55 l=4.73
X704 a_18225_15279# _36_.A.t3 VSS.t109 VSS.t108 sky130_fd_pr__nfet_01v8 ad=0.169 pd=1.82 as=0.08775 ps=0.92 w=0.65 l=0.15
X705 VDD VSS.t1181 VDD VDD sky130_fd_pr__pfet_01v8_hvt ad=0.2262 pd=2.26 as=0 ps=0 w=0.87 l=4.73
X706 VSS.t1869 VDD VSS.t1868 VSS.t1867 sky130_fd_pr__nfet_01v8 ad=0.143 pd=1.62 as=0 ps=0 w=0.55 l=1.97
X707 VDD VSS.t4093 VDD VDD sky130_fd_pr__pfet_01v8_hvt ad=0.2262 pd=2.26 as=0 ps=0 w=0.87 l=4.73
X708 VDD VSS.t4388 VDD VDD sky130_fd_pr__pfet_01v8_hvt ad=0.2262 pd=2.26 as=0 ps=0 w=0.87 l=0.59
X709 a_5609_16367# a_5062_16641# a_5262_16341# VDD sky130_fd_pr__pfet_01v8_hvt ad=0.05775 pd=0.695 as=0.06825 ps=0.745 w=0.42 l=0.15
X710 VDD VSS.t4183 VDD VDD sky130_fd_pr__pfet_01v8_hvt ad=0.2262 pd=2.26 as=0 ps=0 w=0.87 l=4.73
X711 VSS.t1239 VDD VSS.t1238 VSS.t1237 sky130_fd_pr__nfet_01v8 ad=0.143 pd=1.62 as=0 ps=0 w=0.55 l=4.73
X712 VSS.t2747 VDD VSS.t2746 VSS.t2745 sky130_fd_pr__nfet_01v8 ad=0.143 pd=1.62 as=0 ps=0 w=0.55 l=4.73
X713 VDD VSS.t479 VDD VDD sky130_fd_pr__pfet_01v8_hvt ad=0.2262 pd=2.26 as=0 ps=0 w=0.87 l=1.05
X714 VDD VSS.t518 VDD VDD sky130_fd_pr__pfet_01v8_hvt ad=0.2262 pd=2.26 as=0 ps=0 w=0.87 l=4.73
X715 VDD VSS.t4258 VDD VDD sky130_fd_pr__pfet_01v8_hvt ad=0.2262 pd=2.26 as=0 ps=0 w=0.87 l=1.97
X716 VDD VSS.t3865 VDD VDD sky130_fd_pr__pfet_01v8_hvt ad=0.2262 pd=2.26 as=0 ps=0 w=0.87 l=4.73
X717 VSS.t878 VDD VSS.t877 VSS.t876 sky130_fd_pr__nfet_01v8 ad=0.143 pd=1.62 as=0 ps=0 w=0.55 l=4.73
X718 VDD VSS.t3623 VDD VDD sky130_fd_pr__pfet_01v8_hvt ad=0.2262 pd=2.26 as=0 ps=0 w=0.87 l=4.73
X719 a_5191_16367# a_5055_16341.t7 a_4771_16341# VDD sky130_fd_pr__pfet_01v8_hvt ad=0.1095 pd=1.075 as=0.0567 ps=0.69 w=0.42 l=0.15
X720 VSS.t118 a_11413_16341.t10 _75_.CLK VSS.t119 sky130_fd_pr__nfet_01v8 ad=0.0588 pd=0.7 as=0.0588 ps=0.7 w=0.42 l=0.15
X721 a_18639_16733# a_17857_16367# a_18555_16733# VDD sky130_fd_pr__pfet_01v8_hvt ad=0.0882 pd=0.84 as=0.0567 ps=0.69 w=0.42 l=0.15
X722 VDD VSS.t4171 VDD VDD sky130_fd_pr__pfet_01v8_hvt ad=0.2262 pd=2.26 as=0 ps=0 w=0.87 l=4.73
X723 VDD _50_.B1.t6 _56_.Y VDD sky130_fd_pr__pfet_01v8_hvt ad=0.26 pd=2.52 as=0.26 ps=2.52 w=1 l=0.15
X724 VSS.t181 _63_.Y a_6493_16395# VSS.t180 sky130_fd_pr__nfet_01v8 ad=0.1118 pd=1.04 as=0.0567 ps=0.69 w=0.42 l=0.15
X725 VSS.t2640 VDD VSS.t2639 VSS.t2638 sky130_fd_pr__nfet_01v8 ad=0.143 pd=1.62 as=0 ps=0 w=0.55 l=4.73
X726 VDD VSS.t4068 VDD VDD sky130_fd_pr__pfet_01v8_hvt ad=0.2262 pd=2.26 as=0 ps=0 w=0.87 l=1.97
X727 VDD a_20787_15253.t5 a_20794_15553# VDD sky130_fd_pr__pfet_01v8_hvt ad=0.0864 pd=0.91 as=0.1664 ps=1.8 w=0.64 l=0.15
X728 VDD VSS.t1829 VDD VDD sky130_fd_pr__pfet_01v8_hvt ad=0.2262 pd=2.26 as=0 ps=0 w=0.87 l=4.73
X729 VDD VSS.t4038 VDD VDD sky130_fd_pr__pfet_01v8_hvt ad=0.2262 pd=2.26 as=0 ps=0 w=0.87 l=4.73
X730 VDD VSS.t3749 VDD VDD sky130_fd_pr__pfet_01v8_hvt ad=0.2262 pd=2.26 as=0 ps=0 w=0.87 l=4.73
X731 hold12.A _54_.Y a_27133_16367# VSS.t3288 sky130_fd_pr__nfet_01v8 ad=0.10075 pd=0.96 as=0.08775 ps=0.92 w=0.65 l=0.15
X732 _48_.X a_23027_14735# VDD VDD sky130_fd_pr__pfet_01v8_hvt ad=0.135 pd=1.27 as=0.135 ps=1.27 w=1 l=0.15
X733 VDD VSS.t3981 VDD VDD sky130_fd_pr__pfet_01v8_hvt ad=0.2262 pd=2.26 as=0 ps=0 w=0.87 l=4.73
X734 VDD VSS.t4076 VDD VDD sky130_fd_pr__pfet_01v8_hvt ad=0.2262 pd=2.26 as=0 ps=0 w=0.87 l=4.73
X735 counter_value_o[2] a_12684_16885# VDD VDD sky130_fd_pr__pfet_01v8_hvt ad=0.135 pd=1.27 as=0.265 ps=2.53 w=1 l=0.15
X736 VSS.t375 VDD VSS.t374 VSS.t373 sky130_fd_pr__nfet_01v8 ad=0.143 pd=1.62 as=0 ps=0 w=0.55 l=1.05
X737 VDD output3.A.t14 a_4057_16617# VDD sky130_fd_pr__pfet_01v8_hvt ad=0.26 pd=2.52 as=0.135 ps=1.27 w=1 l=0.15
X738 VDD VSS.t3611 VDD VDD sky130_fd_pr__pfet_01v8_hvt ad=0.2262 pd=2.26 as=0 ps=0 w=0.87 l=4.73
X739 VDD VSS.t3632 VDD VDD sky130_fd_pr__pfet_01v8_hvt ad=0.2262 pd=2.26 as=0 ps=0 w=0.87 l=4.73
X740 VDD VSS.t4143 VDD VDD sky130_fd_pr__pfet_01v8_hvt ad=0.2262 pd=2.26 as=0 ps=0 w=0.87 l=1.97
X741 VDD VSS.t3859 VDD VDD sky130_fd_pr__pfet_01v8_hvt ad=0.2262 pd=2.26 as=0 ps=0 w=0.87 l=4.73
X742 VDD _70_.Q a_27535_16919# VDD sky130_fd_pr__pfet_01v8_hvt ad=0.149 pd=1.325 as=0.1664 ps=1.8 w=0.64 l=0.15
X743 VSS.t3385 a_18555_16733# a_18723_16635# VSS.t3384 sky130_fd_pr__nfet_01v8 ad=0.08775 pd=0.92 as=0.169 ps=1.82 w=0.65 l=0.15
X744 VSS.t2785 VDD VSS.t2784 VSS.t2781 sky130_fd_pr__nfet_01v8 ad=0.143 pd=1.62 as=0 ps=0 w=0.55 l=1.97
X745 VDD VSS.t3714 VDD VDD sky130_fd_pr__pfet_01v8_hvt ad=0.2262 pd=2.26 as=0 ps=0 w=0.87 l=4.73
X746 VDD VSS.t2571 VDD VDD sky130_fd_pr__pfet_01v8_hvt ad=0.2262 pd=2.26 as=0 ps=0 w=0.87 l=0.59
X747 VDD VSS.t4321 VDD VDD sky130_fd_pr__pfet_01v8_hvt ad=0.2262 pd=2.26 as=0 ps=0 w=0.87 l=4.73
X748 VSS.t1663 VDD VSS.t1662 VSS.t1661 sky130_fd_pr__nfet_01v8 ad=0.143 pd=1.62 as=0 ps=0 w=0.55 l=4.73
X749 VSS.t327 VDD VSS.t326 VSS.t325 sky130_fd_pr__nfet_01v8 ad=0.143 pd=1.62 as=0 ps=0 w=0.55 l=0.59
X750 VDD VSS.t4113 VDD VDD sky130_fd_pr__pfet_01v8_hvt ad=0.2262 pd=2.26 as=0 ps=0 w=0.87 l=4.73
X751 _77_.CLK a_21914_15823.t38 VSS.t176 VSS.t175 sky130_fd_pr__nfet_01v8 ad=0.0588 pd=0.7 as=0.0588 ps=0.7 w=0.42 l=0.15
X752 VSS.t2326 VDD VSS.t2325 VSS.t2324 sky130_fd_pr__nfet_01v8 ad=0.143 pd=1.62 as=0 ps=0 w=0.55 l=4.73
X753 _77_.CLK a_21914_15823.t28 VSS.t3405 VSS.t3404 sky130_fd_pr__nfet_01v8 ad=0.0588 pd=0.7 as=0.0588 ps=0.7 w=0.42 l=0.15
X754 VDD a_7867_16635# a_7783_16733# VDD sky130_fd_pr__pfet_01v8_hvt ad=0.1113 pd=1.37 as=0.0882 ps=0.84 w=0.42 l=0.15
X755 VSS.t2831 VDD VSS.t2830 VSS.t2829 sky130_fd_pr__nfet_01v8 ad=0.143 pd=1.62 as=0 ps=0 w=0.55 l=4.73
X756 a_18269_17249# input2.X.t21 a_18183_17249# VSS.t86 sky130_fd_pr__nfet_01v8 ad=0.0567 pd=0.69 as=0.1176 ps=1.4 w=0.42 l=0.15
X757 VDD VSS.t4228 VDD VDD sky130_fd_pr__pfet_01v8_hvt ad=0.2262 pd=2.26 as=0 ps=0 w=0.87 l=4.73
X758 VDD VSS.t3485 VDD VDD sky130_fd_pr__pfet_01v8_hvt ad=0.2262 pd=2.26 as=0 ps=0 w=0.87 l=4.73
X759 VDD VSS.t3964 VDD VDD sky130_fd_pr__pfet_01v8_hvt ad=0.2262 pd=2.26 as=0 ps=0 w=0.87 l=4.73
X760 VDD VSS.t4212 VDD VDD sky130_fd_pr__pfet_01v8_hvt ad=0.2262 pd=2.26 as=0 ps=0 w=0.87 l=4.73
X761 VSS.t2678 VDD VSS.t2678 VSS.t2677 sky130_fd_pr__nfet_01v8 ad=0.143 pd=1.62 as=0 ps=0 w=0.55 l=0.59
X762 VDD VSS.t3674 VDD VDD sky130_fd_pr__pfet_01v8_hvt ad=0.2262 pd=2.26 as=0 ps=0 w=0.87 l=4.73
X763 VDD VSS.t4101 VDD VDD sky130_fd_pr__pfet_01v8_hvt ad=0.2262 pd=2.26 as=0 ps=0 w=0.87 l=4.73
X764 VSS.t3426 a_29027_16635# a_28985_16367# VSS.t3425 sky130_fd_pr__nfet_01v8 ad=0.1092 pd=1.36 as=0.066 ps=0.745 w=0.42 l=0.15
X765 a_18317_15529# _36_.A.t5 VDD VDD sky130_fd_pr__pfet_01v8_hvt ad=0.105 pd=1.21 as=0.365 ps=1.73 w=1 l=0.15
X766 a_25225_16617# _50_.A2 _57_.Y VDD sky130_fd_pr__pfet_01v8_hvt ad=0.135 pd=1.27 as=0.26 ps=2.52 w=1 l=0.15
X767 VDD VSS.t4378 VDD VDD sky130_fd_pr__pfet_01v8_hvt ad=0.2262 pd=2.26 as=0 ps=0 w=0.87 l=4.73
X768 a_8951_16367# output3.A.t4 VSS.t24 VSS.t23 sky130_fd_pr__nfet_01v8 ad=0.08775 pd=0.92 as=0.08775 ps=0.92 w=0.65 l=0.15
X769 VSS.t1672 VDD VSS.t1671 VSS.t1670 sky130_fd_pr__nfet_01v8 ad=0.143 pd=1.62 as=0 ps=0 w=0.55 l=4.73
X770 a_18681_16367# a_17691_16367# a_18555_16733# VSS.t3383 sky130_fd_pr__special_nfet_01v8 ad=0.066 pd=0.745 as=0.0684 ps=0.74 w=0.36 l=0.15
X771 VSS.t2269 VDD VSS.t2268 VSS.t2267 sky130_fd_pr__nfet_01v8 ad=0.143 pd=1.62 as=0 ps=0 w=0.55 l=1.97
X772 VSS.t270 a_12134_15797# a_12092_16201# VSS.t269 sky130_fd_pr__nfet_01v8 ad=0.12095 pd=1.085 as=0.0696 ps=0.765 w=0.42 l=0.15
X773 VSS.t545 VDD VSS.t545 VSS.t544 sky130_fd_pr__nfet_01v8 ad=0.143 pd=1.62 as=0 ps=0 w=0.55 l=0.59
X774 VDD VSS.t3467 VDD VDD sky130_fd_pr__pfet_01v8_hvt ad=0.2262 pd=2.26 as=0 ps=0 w=0.87 l=4.73
X775 VDD VSS.t4073 VDD VDD sky130_fd_pr__pfet_01v8_hvt ad=0.2262 pd=2.26 as=0 ps=0 w=0.87 l=1.97
X776 VDD VSS.t3600 VDD VDD sky130_fd_pr__pfet_01v8_hvt ad=0.2262 pd=2.26 as=0 ps=0 w=0.87 l=4.73
X777 VSS.t2953 VDD VSS.t2952 VSS.t2951 sky130_fd_pr__nfet_01v8 ad=0.143 pd=1.62 as=0 ps=0 w=0.55 l=4.73
X778 a_23450_15391# a_23282_15645# VDD VDD sky130_fd_pr__pfet_01v8_hvt ad=0.1095 pd=1.075 as=0.17887 ps=1.26 w=0.75 l=0.15
X779 VSS.t2708 VDD VSS.t2707 VSS.t2706 sky130_fd_pr__nfet_01v8 ad=0.143 pd=1.62 as=0 ps=0 w=0.55 l=4.73
X780 VSS.t2583 VDD VSS.t2582 VSS.t2581 sky130_fd_pr__nfet_01v8 ad=0.143 pd=1.62 as=0 ps=0 w=0.55 l=1.05
X781 VSS.t185 a_23707_15645# a_23875_15547# VSS.t184 sky130_fd_pr__nfet_01v8 ad=0.08775 pd=0.92 as=0.169 ps=1.82 w=0.65 l=0.15
X782 VSS.t1881 VDD VSS.t1880 VSS.t1879 sky130_fd_pr__nfet_01v8 ad=0.143 pd=1.62 as=0 ps=0 w=0.55 l=4.73
X783 VSS.t3240 VDD VSS.t3239 VSS.t3236 sky130_fd_pr__nfet_01v8 ad=0.143 pd=1.62 as=0 ps=0 w=0.55 l=0.59
X784 VDD VSS.t4154 VDD VDD sky130_fd_pr__pfet_01v8_hvt ad=0.2262 pd=2.26 as=0 ps=0 w=0.87 l=4.73
X785 VDD VSS.t3942 VDD VDD sky130_fd_pr__pfet_01v8_hvt ad=0.2262 pd=2.26 as=0 ps=0 w=0.87 l=4.73
X786 VDD VSS.t3449 VDD VDD sky130_fd_pr__pfet_01v8_hvt ad=0.2262 pd=2.26 as=0 ps=0 w=0.87 l=4.73
X787 VSS.t187 a_5055_16341.t2 a_5062_16641# VSS.t3291 sky130_fd_pr__nfet_01v8 ad=0.0567 pd=0.69 as=0.1092 ps=1.36 w=0.42 l=0.15
X788 VSS.t2783 VDD VSS.t2782 VSS.t2781 sky130_fd_pr__nfet_01v8 ad=0.143 pd=1.62 as=0 ps=0 w=0.55 l=4.73
X789 VDD VSS.t3914 VDD VDD sky130_fd_pr__pfet_01v8_hvt ad=0.2262 pd=2.26 as=0 ps=0 w=0.87 l=4.73
X790 a_3889_16617# output3.A.t15 a_3807_16617# VDD sky130_fd_pr__pfet_01v8_hvt ad=0.135 pd=1.27 as=0.26 ps=2.52 w=1 l=0.15
X791 VDD _51_.X.t2 a_25235_15823# VDD sky130_fd_pr__pfet_01v8_hvt ad=0.14 pd=1.28 as=0.265 ps=2.53 w=1 l=0.15
X792 VSS.t309 VDD VSS.t308 VSS.t307 sky130_fd_pr__nfet_01v8 ad=0.143 pd=1.62 as=0 ps=0 w=0.55 l=0.59
X793 a_9369_16367# input1.X.t7 a_9727_16367# VSS.t111 sky130_fd_pr__nfet_01v8 ad=0.08775 pd=0.92 as=0.169 ps=1.82 w=0.65 l=0.15
X794 VDD VSS.t3550 VDD VDD sky130_fd_pr__pfet_01v8_hvt ad=0.2262 pd=2.26 as=0 ps=0 w=0.87 l=4.73
X795 VSS.t708 VDD VSS.t707 VSS.t706 sky130_fd_pr__nfet_01v8 ad=0.143 pd=1.62 as=0 ps=0 w=0.55 l=4.73
X796 VDD VSS.t4255 VDD VDD sky130_fd_pr__pfet_01v8_hvt ad=0.2262 pd=2.26 as=0 ps=0 w=0.87 l=4.73
X797 VSS.t3007 VDD VSS.t2898 VSS.t3006 sky130_fd_pr__nfet_01v8 ad=0.143 pd=1.62 as=0 ps=0 w=0.55 l=4.73
X798 VDD VSS.t2041 VDD VDD sky130_fd_pr__pfet_01v8_hvt ad=0.2262 pd=2.26 as=0 ps=0 w=0.87 l=4.73
X799 VSS.t1615 VDD VSS.t1614 VSS.t1613 sky130_fd_pr__nfet_01v8 ad=0.143 pd=1.62 as=0 ps=0 w=0.55 l=4.73
X800 a_23352_16519# _70_.Q VSS.t3333 VSS.t3437 sky130_fd_pr__nfet_01v8 ad=0.0567 pd=0.69 as=0.10187 ps=0.99 w=0.42 l=0.15
X801 VSS.t1508 VDD VSS.t1507 VSS.t1506 sky130_fd_pr__nfet_01v8 ad=0.143 pd=1.62 as=0 ps=0 w=0.55 l=4.73
X802 _36_.B.t3 _67_.A.t13 VDD VDD sky130_fd_pr__pfet_01v8_hvt ad=0.135 pd=1.27 as=0.165 ps=1.33 w=1 l=0.15
X803 VSS.t416 VDD VSS.t415 VSS.t414 sky130_fd_pr__nfet_01v8 ad=0.143 pd=1.62 as=0 ps=0 w=0.55 l=4.73
X804 VSS.t3091 VDD VSS.t3090 VSS.t3089 sky130_fd_pr__nfet_01v8 ad=0.143 pd=1.62 as=0 ps=0 w=0.55 l=1.97
X805 _38_.X a_18611_15831# VDD VDD sky130_fd_pr__pfet_01v8_hvt ad=0.135 pd=1.27 as=0.149 ps=1.325 w=1 l=0.15
X806 VSS.t1574 VDD VSS.t1573 VSS.t1572 sky130_fd_pr__nfet_01v8 ad=0.143 pd=1.62 as=0 ps=0 w=0.55 l=4.73
X807 VDD VSS.t3926 VDD VDD sky130_fd_pr__pfet_01v8_hvt ad=0.2262 pd=2.26 as=0 ps=0 w=0.87 l=4.73
X808 VDD clkbuf_0_clock_i.X a_11413_16341.t5 VDD sky130_fd_pr__pfet_01v8_hvt ad=0.14 pd=1.28 as=0.14 ps=1.28 w=1 l=0.15
X809 a_24777_15939# _36_.B.t12 VSS.t22 VSS.t21 sky130_fd_pr__nfet_01v8 ad=0.0567 pd=0.69 as=0.0567 ps=0.69 w=0.42 l=0.15
X810 VSS.t1986 VDD VSS.t1985 VSS.t1984 sky130_fd_pr__nfet_01v8 ad=0.143 pd=1.62 as=0 ps=0 w=0.55 l=4.73
X811 VDD VSS.t3999 VDD VDD sky130_fd_pr__pfet_01v8_hvt ad=0.2262 pd=2.26 as=0 ps=0 w=0.87 l=4.73
X812 VSS.t318 VDD VSS.t317 VSS.t316 sky130_fd_pr__nfet_01v8 ad=0.143 pd=1.62 as=0 ps=0 w=0.55 l=0.59
X813 VSS.t1932 VDD VSS.t1931 VSS.t1930 sky130_fd_pr__nfet_01v8 ad=0.143 pd=1.62 as=0 ps=0 w=0.55 l=4.73
X814 VSS.t3328 a_28253_15823# a_28359_15823# VSS.t3327 sky130_fd_pr__nfet_01v8 ad=0.097 pd=0.975 as=0.1092 ps=1.36 w=0.42 l=0.5
X815 VDD VSS.t3525 VDD VDD sky130_fd_pr__pfet_01v8_hvt ad=0.2262 pd=2.26 as=0 ps=0 w=0.87 l=4.73
X816 VSS.t3199 VDD VSS.t3198 VSS.t3197 sky130_fd_pr__nfet_01v8 ad=0.143 pd=1.62 as=0 ps=0 w=0.55 l=0.59
X817 VDD VSS.t3969 VDD VDD sky130_fd_pr__pfet_01v8_hvt ad=0.2262 pd=2.26 as=0 ps=0 w=0.87 l=4.73
X818 VDD VSS.t4024 VDD VDD sky130_fd_pr__pfet_01v8_hvt ad=0.2262 pd=2.26 as=0 ps=0 w=0.87 l=4.73
X819 VDD VSS.t3573 VDD VDD sky130_fd_pr__pfet_01v8_hvt ad=0.2262 pd=2.26 as=0 ps=0 w=0.87 l=1.97
X820 VSS.t3238 VDD VSS.t3237 VSS.t3236 sky130_fd_pr__nfet_01v8 ad=0.143 pd=1.62 as=0 ps=0 w=0.55 l=4.73
X821 VSS.t1890 VDD VSS.t1889 VSS.t1888 sky130_fd_pr__nfet_01v8 ad=0.143 pd=1.62 as=0 ps=0 w=0.55 l=4.73
X822 VDD VSS.t4289 VDD VDD sky130_fd_pr__pfet_01v8_hvt ad=0.2262 pd=2.26 as=0 ps=0 w=0.87 l=4.73
X823 VDD _67_.A.t10 _36_.B.t1 VDD sky130_fd_pr__pfet_01v8_hvt ad=0.26 pd=2.52 as=0.135 ps=1.27 w=1 l=0.15
X824 VSS.t740 VDD VSS.t740 VSS.t739 sky130_fd_pr__nfet_01v8 ad=0.143 pd=1.62 as=0 ps=0 w=0.55 l=0.59
X825 VSS.t1371 VDD VSS.t1370 VSS.t1369 sky130_fd_pr__nfet_01v8 ad=0.143 pd=1.62 as=0 ps=0 w=0.55 l=4.73
X826 VDD VSS.t4382 VDD VDD sky130_fd_pr__pfet_01v8_hvt ad=0.2262 pd=2.26 as=0 ps=0 w=0.87 l=4.73
X827 VSS.t479 VDD VSS.t479 VSS.t478 sky130_fd_pr__nfet_01v8 ad=0.143 pd=1.62 as=0 ps=0 w=0.55 l=1.05
X828 VSS.t735 VDD VSS.t734 VSS.t733 sky130_fd_pr__nfet_01v8 ad=0.143 pd=1.62 as=0 ps=0 w=0.55 l=1.97
X829 VDD VSS.t3911 VDD VDD sky130_fd_pr__pfet_01v8_hvt ad=0.2262 pd=2.26 as=0 ps=0 w=0.87 l=4.73
X830 VSS.t519 VDD VSS.t518 VSS.t517 sky130_fd_pr__nfet_01v8 ad=0.143 pd=1.62 as=0 ps=0 w=0.55 l=4.73
X831 VDD VSS.t3835 VDD VDD sky130_fd_pr__pfet_01v8_hvt ad=0.2262 pd=2.26 as=0 ps=0 w=0.87 l=4.73
X832 VDD VSS.t3893 VDD VDD sky130_fd_pr__pfet_01v8_hvt ad=0.2262 pd=2.26 as=0 ps=0 w=0.87 l=4.73
X833 a_2748_16885# output3.A.t17 VDD VDD sky130_fd_pr__pfet_01v8_hvt ad=0.1664 pd=1.8 as=0.149 ps=1.325 w=0.64 l=0.15
X834 VDD VSS.t3470 VDD VDD sky130_fd_pr__pfet_01v8_hvt ad=0.2262 pd=2.26 as=0 ps=0 w=0.87 l=4.73
X835 VDD VSS.t4084 VDD VDD sky130_fd_pr__pfet_01v8_hvt ad=0.2262 pd=2.26 as=0 ps=0 w=0.87 l=4.73
X836 VDD VSS.t3654 VDD VDD sky130_fd_pr__pfet_01v8_hvt ad=0.2262 pd=2.26 as=0 ps=0 w=0.87 l=4.73
X837 VSS.t2338 VDD VSS.t2337 VSS.t2336 sky130_fd_pr__nfet_01v8 ad=0.143 pd=1.62 as=0 ps=0 w=0.55 l=4.73
X838 VSS.t266 a_20787_15253.t2 a_20794_15553# VSS.t3296 sky130_fd_pr__nfet_01v8 ad=0.0567 pd=0.69 as=0.1092 ps=1.36 w=0.42 l=0.15
X839 VDD VSS.t2571 VDD VDD sky130_fd_pr__pfet_01v8_hvt ad=0.2262 pd=2.26 as=0 ps=0 w=0.87 l=0.59
X840 VSS.t2463 VDD VSS.t2463 VSS.t2462 sky130_fd_pr__nfet_01v8 ad=0.143 pd=1.62 as=0 ps=0 w=0.55 l=0.59
X841 VSS.t2661 VDD VSS.t2660 VSS.t2659 sky130_fd_pr__nfet_01v8 ad=0.143 pd=1.62 as=0 ps=0 w=0.55 l=4.73
X842 VDD VSS.t2256 VDD VDD sky130_fd_pr__pfet_01v8_hvt ad=0.2262 pd=2.26 as=0 ps=0 w=0.87 l=4.73
X843 VSS.t191 _75_.CLK a_11527_15829# VSS.t190 sky130_fd_pr__nfet_01v8 ad=0.0567 pd=0.69 as=0.1092 ps=1.36 w=0.42 l=0.15
X844 VDD VSS.t3570 VDD VDD sky130_fd_pr__pfet_01v8_hvt ad=0.2262 pd=2.26 as=0 ps=0 w=0.87 l=4.73
X845 VSS.t1833 VDD VSS.t1832 VSS.t1831 sky130_fd_pr__nfet_01v8 ad=0.143 pd=1.62 as=0 ps=0 w=0.55 l=4.73
X846 VDD VSS.t3498 VDD VDD sky130_fd_pr__pfet_01v8_hvt ad=0.2262 pd=2.26 as=0 ps=0 w=0.87 l=1.97
X847 VDD VSS.t3811 VDD VDD sky130_fd_pr__pfet_01v8_hvt ad=0.2262 pd=2.26 as=0 ps=0 w=0.87 l=4.73
X848 VSS.t542 VDD VSS.t541 VSS.t463 sky130_fd_pr__nfet_01v8 ad=0.143 pd=1.62 as=0 ps=0 w=0.55 l=4.73
X849 VDD VSS.t3852 VDD VDD sky130_fd_pr__pfet_01v8_hvt ad=0.2262 pd=2.26 as=0 ps=0 w=0.87 l=4.73
X850 VDD VSS.t3870 VDD VDD sky130_fd_pr__pfet_01v8_hvt ad=0.2262 pd=2.26 as=0 ps=0 w=0.87 l=4.73
X851 VSS.t746 VDD VSS.t745 VSS.t744 sky130_fd_pr__nfet_01v8 ad=0.143 pd=1.62 as=0 ps=0 w=0.55 l=4.73
X852 a_28349_16367# hold12.X VSS.t136 VSS.t135 sky130_fd_pr__nfet_01v8 ad=0.0813 pd=0.83 as=0.1092 ps=1.36 w=0.42 l=0.15
X853 VDD a_12559_15797# a_12475_15823# VDD sky130_fd_pr__pfet_01v8_hvt ad=0.1113 pd=1.37 as=0.0882 ps=0.84 w=0.42 l=0.15
X854 VSS.t89 input2.X.t6 a_27432_16143# VSS.t88 sky130_fd_pr__nfet_01v8 ad=0.10025 pd=0.985 as=0.08775 ps=0.92 w=0.65 l=0.15
X855 VDD VSS.t3648 VDD VDD sky130_fd_pr__pfet_01v8_hvt ad=0.2262 pd=2.26 as=0 ps=0 w=0.87 l=1.97
X856 VSS.t1612 VDD VSS.t1611 VSS.t1610 sky130_fd_pr__nfet_01v8 ad=0.143 pd=1.62 as=0 ps=0 w=0.55 l=4.73
X857 VSS.t195 _67_.Y a_10633_16395# VSS.t3311 sky130_fd_pr__nfet_01v8 ad=0.1118 pd=1.04 as=0.0567 ps=0.69 w=0.42 l=0.15
X858 VDD a_16762_15823.t16 clkbuf_0_clock_i.X VDD sky130_fd_pr__pfet_01v8_hvt ad=0.14 pd=1.28 as=0.14 ps=1.28 w=1 l=0.15
X859 VDD VSS.t4044 VDD VDD sky130_fd_pr__pfet_01v8_hvt ad=0.2262 pd=2.26 as=0 ps=0 w=0.87 l=4.73
X860 _69_.X.t1 a_10883_15823# VDD VDD sky130_fd_pr__pfet_01v8_hvt ad=0.2054 pd=2.1 as=0.11455 ps=1.08 w=0.79 l=0.15
X861 VDD a_16762_15823.t6 clkbuf_0_clock_i.X VDD sky130_fd_pr__pfet_01v8_hvt ad=0.265 pd=2.53 as=0.14 ps=1.28 w=1 l=0.15
X862 VSS.t638 VDD VSS.t638 VSS.t633 sky130_fd_pr__nfet_01v8 ad=0.143 pd=1.62 as=0 ps=0 w=0.55 l=0.59
X863 VSS.t2347 VDD VSS.t2346 VSS.t2345 sky130_fd_pr__nfet_01v8 ad=0.143 pd=1.62 as=0 ps=0 w=0.55 l=4.73
X864 VDD VSS.t4029 VDD VDD sky130_fd_pr__pfet_01v8_hvt ad=0.2262 pd=2.26 as=0 ps=0 w=0.87 l=4.73
X865 VDD VSS.t3627 VDD VDD sky130_fd_pr__pfet_01v8_hvt ad=0.2262 pd=2.26 as=0 ps=0 w=0.87 l=4.73
X866 VDD VSS.t3765 VDD VDD sky130_fd_pr__pfet_01v8_hvt ad=0.2262 pd=2.26 as=0 ps=0 w=0.87 l=4.73
X867 VDD VSS.t3827 VDD VDD sky130_fd_pr__pfet_01v8_hvt ad=0.2262 pd=2.26 as=0 ps=0 w=0.87 l=1.97
X868 VDD VSS.t4300 VDD VDD sky130_fd_pr__pfet_01v8_hvt ad=0.2262 pd=2.26 as=0 ps=0 w=0.87 l=4.73
X869 VDD VSS.t3612 VDD VDD sky130_fd_pr__pfet_01v8_hvt ad=0.2262 pd=2.26 as=0 ps=0 w=0.87 l=1.97
X870 VSS.t3079 VDD VSS.t3078 VSS.t3077 sky130_fd_pr__nfet_01v8 ad=0.143 pd=1.62 as=0 ps=0 w=0.55 l=4.73
X871 VSS.t354 VDD VSS.t353 VSS.t352 sky130_fd_pr__nfet_01v8 ad=0.143 pd=1.62 as=0 ps=0 w=0.55 l=4.73
X872 a_4771_16341# a_5062_16641# a_5013_16733# VDD sky130_fd_pr__pfet_01v8_hvt ad=0.0567 pd=0.69 as=0.0882 ps=0.84 w=0.42 l=0.15
X873 _77_.CLK a_21914_15823.t14 VDD VDD sky130_fd_pr__pfet_01v8_hvt ad=0.14 pd=1.28 as=0.1375 ps=1.275 w=1 l=0.15
X874 VSS.t2502 VDD VSS.t2501 VSS.t2500 sky130_fd_pr__nfet_01v8 ad=0.143 pd=1.62 as=0 ps=0 w=0.55 l=4.73
X875 VSS.t584 VDD VSS.t583 VSS.t582 sky130_fd_pr__nfet_01v8 ad=0.143 pd=1.62 as=0 ps=0 w=0.55 l=4.73
X876 VSS.t2004 VDD VSS.t2003 VSS.t2002 sky130_fd_pr__nfet_01v8 ad=0.143 pd=1.62 as=0 ps=0 w=0.55 l=4.73
X877 _74_.D.t1 a_6927_16911# VDD VDD sky130_fd_pr__pfet_01v8_hvt ad=0.2054 pd=2.1 as=0.11455 ps=1.08 w=0.79 l=0.15
X878 clkbuf_0_clock_i.X a_16762_15823.t15 VDD VDD sky130_fd_pr__pfet_01v8_hvt ad=0.14 pd=1.28 as=0.14 ps=1.28 w=1 l=0.15
X879 _36_.Y _36_.B.t8 a_18317_15529# VDD sky130_fd_pr__pfet_01v8_hvt ad=0.165 pd=1.33 as=0.105 ps=1.21 w=1 l=0.15
X880 VSS.t2902 VDD VSS.t2901 VSS.t2900 sky130_fd_pr__nfet_01v8 ad=0.143 pd=1.62 as=0 ps=0 w=0.55 l=4.73
X881 VSS.t2168 VDD VSS.t2167 VSS.t2166 sky130_fd_pr__nfet_01v8 ad=0.143 pd=1.62 as=0 ps=0 w=0.55 l=1.97
X882 VSS.t1430 VDD VSS.t1429 VSS.t1428 sky130_fd_pr__nfet_01v8 ad=0.143 pd=1.62 as=0 ps=0 w=0.55 l=4.73
X883 VSS.t104 _57_.Y a_26799_16367# VSS.t103 sky130_fd_pr__nfet_01v8 ad=0.08775 pd=0.92 as=0.169 ps=1.82 w=0.65 l=0.15
X884 _60_.X a_4107_16161# VSS.t100 VSS.t99 sky130_fd_pr__nfet_01v8 ad=0.182 pd=1.86 as=0.1118 ps=1.04 w=0.65 l=0.15
X885 VDD VSS.t4306 VDD VDD sky130_fd_pr__pfet_01v8_hvt ad=0.2262 pd=2.26 as=0 ps=0 w=0.87 l=1.97
X886 VDD VSS.t3741 VDD VDD sky130_fd_pr__pfet_01v8_hvt ad=0.2262 pd=2.26 as=0 ps=0 w=0.87 l=4.73
X887 VDD a_23027_14735# _48_.X VDD sky130_fd_pr__pfet_01v8_hvt ad=0.135 pd=1.27 as=0.135 ps=1.27 w=1 l=0.15
X888 a_4057_16617# input1.X.t16 VDD VDD sky130_fd_pr__pfet_01v8_hvt ad=0.135 pd=1.27 as=0.135 ps=1.27 w=1 l=0.15
X889 VSS.t2159 VDD VSS.t2158 VSS.t2157 sky130_fd_pr__nfet_01v8 ad=0.143 pd=1.62 as=0 ps=0 w=0.55 l=4.73
X890 VDD VSS.t3955 VDD VDD sky130_fd_pr__pfet_01v8_hvt ad=0.2262 pd=2.26 as=0 ps=0 w=0.87 l=4.73
X891 _67_.B input1.X.t8 a_8657_16367# VSS.t3253 sky130_fd_pr__nfet_01v8 ad=0.169 pd=1.82 as=0.10725 ps=0.98 w=0.65 l=0.15
X892 VSS.t1317 VDD VSS.t1316 VSS.t1315 sky130_fd_pr__nfet_01v8 ad=0.143 pd=1.62 as=0 ps=0 w=0.55 l=4.73
X893 VDD VSS.t4301 VDD VDD sky130_fd_pr__pfet_01v8_hvt ad=0.2262 pd=2.26 as=0 ps=0 w=0.87 l=4.73
X894 VDD VSS.t4221 VDD VDD sky130_fd_pr__pfet_01v8_hvt ad=0.2262 pd=2.26 as=0 ps=0 w=0.87 l=4.73
X895 VDD VSS.t3824 VDD VDD sky130_fd_pr__pfet_01v8_hvt ad=0.2262 pd=2.26 as=0 ps=0 w=0.87 l=4.73
X896 VDD VSS.t4275 VDD VDD sky130_fd_pr__pfet_01v8_hvt ad=0.2262 pd=2.26 as=0 ps=0 w=0.87 l=4.73
X897 VSS.t821 VDD VSS.t820 VSS.t819 sky130_fd_pr__nfet_01v8 ad=0.143 pd=1.62 as=0 ps=0 w=0.55 l=1.97
X898 VDD VSS.t3589 VDD VDD sky130_fd_pr__pfet_01v8_hvt ad=0.2262 pd=2.26 as=0 ps=0 w=0.87 l=4.73
X899 VSS.t1830 VDD VSS.t1829 VSS.t1828 sky130_fd_pr__nfet_01v8 ad=0.143 pd=1.62 as=0 ps=0 w=0.55 l=4.73
X900 a_21914_15823.t2 clkbuf_0_clock_i.X VSS.t3308 VSS.t3309 sky130_fd_pr__nfet_01v8 ad=0.0588 pd=0.7 as=0.0588 ps=0.7 w=0.42 l=0.15
X901 VSS.t566 VDD VSS.t565 VSS.t564 sky130_fd_pr__nfet_01v8 ad=0.143 pd=1.62 as=0 ps=0 w=0.55 l=1.97
X902 VDD VSS.t4369 VDD VDD sky130_fd_pr__pfet_01v8_hvt ad=0.2262 pd=2.26 as=0 ps=0 w=0.87 l=4.73
X903 VSS.t848 VDD VSS.t848 VSS.t843 sky130_fd_pr__nfet_01v8 ad=0.143 pd=1.62 as=0 ps=0 w=0.55 l=0.59
X904 VDD VSS.t4307 VDD VDD sky130_fd_pr__pfet_01v8_hvt ad=0.2262 pd=2.26 as=0 ps=0 w=0.87 l=1.97
X905 VDD VSS.t3757 VDD VDD sky130_fd_pr__pfet_01v8_hvt ad=0.2262 pd=2.26 as=0 ps=0 w=0.87 l=1.97
X906 VSS.t1810 VDD VSS.t1809 VSS.t1808 sky130_fd_pr__nfet_01v8 ad=0.143 pd=1.62 as=0 ps=0 w=0.55 l=4.73
X907 _54_.Y _54_.A a_27253_17231# VSS.t3322 sky130_fd_pr__nfet_01v8 ad=0.169 pd=1.82 as=0.08775 ps=0.92 w=0.65 l=0.15
X908 VSS.t44 input2.X.t11 a_20267_16733# VSS.t43 sky130_fd_pr__nfet_01v8 ad=0.10187 pd=0.99 as=0.1113 ps=1.37 w=0.42 l=0.15
X909 VDD VSS.t4315 VDD VDD sky130_fd_pr__pfet_01v8_hvt ad=0.2262 pd=2.26 as=0 ps=0 w=0.87 l=4.73
X910 VSS.t1254 VDD VSS.t1253 VSS.t1252 sky130_fd_pr__nfet_01v8 ad=0.143 pd=1.62 as=0 ps=0 w=0.55 l=4.73
X911 VSS.t3187 VDD VSS.t3186 VSS.t3185 sky130_fd_pr__nfet_01v8 ad=0.143 pd=1.62 as=0 ps=0 w=0.55 l=4.73
X912 VDD VSS.t4012 VDD VDD sky130_fd_pr__pfet_01v8_hvt ad=0.2262 pd=2.26 as=0 ps=0 w=0.87 l=4.73
X913 a_12684_16885# _67_.A.t15 VSS.t28 VSS.t3364 sky130_fd_pr__nfet_01v8 ad=0.1092 pd=1.36 as=0.097 ps=0.975 w=0.42 l=0.15
X914 VSS.t2843 VDD VSS.t2842 VSS.t2841 sky130_fd_pr__nfet_01v8 ad=0.143 pd=1.62 as=0 ps=0 w=0.55 l=1.97
X915 VSS.t94 a_17652_16885# counter_value_o[3] VSS.t93 sky130_fd_pr__nfet_01v8 ad=0.097 pd=0.975 as=0.08775 ps=0.92 w=0.65 l=0.15
X916 VSS.t644 VDD VSS.t643 VSS.t642 sky130_fd_pr__nfet_01v8 ad=0.143 pd=1.62 as=0 ps=0 w=0.55 l=4.73
X917 VSS.t779 VDD VSS.t778 VSS.t777 sky130_fd_pr__nfet_01v8 ad=0.143 pd=1.62 as=0 ps=0 w=0.55 l=4.73
X918 VDD VSS.t3846 VDD VDD sky130_fd_pr__pfet_01v8_hvt ad=0.2262 pd=2.26 as=0 ps=0 w=0.87 l=4.73
X919 VSS.t339 VDD VSS.t338 VSS.t337 sky130_fd_pr__nfet_01v8 ad=0.143 pd=1.62 as=0 ps=0 w=0.55 l=4.73
X920 _53_.X a_26339_15279# VDD VDD sky130_fd_pr__pfet_01v8_hvt ad=0.135 pd=1.27 as=0.135 ps=1.27 w=1 l=0.15
X921 VSS.t991 VDD VSS.t990 VSS.t989 sky130_fd_pr__nfet_01v8 ad=0.143 pd=1.62 as=0 ps=0 w=0.55 l=1.97
X922 VSS.t1505 VDD VSS.t1504 VSS.t1503 sky130_fd_pr__nfet_01v8 ad=0.143 pd=1.62 as=0 ps=0 w=0.55 l=1.05
X923 VSS.t2383 VDD VSS.t2382 VSS.t2381 sky130_fd_pr__nfet_01v8 ad=0.143 pd=1.62 as=0 ps=0 w=0.55 l=1.97
X924 VDD VSS.t3793 VDD VDD sky130_fd_pr__pfet_01v8_hvt ad=0.2262 pd=2.26 as=0 ps=0 w=0.87 l=1.97
X925 _75_.CLK a_11413_16341.t25 VDD VDD sky130_fd_pr__pfet_01v8_hvt ad=0.14 pd=1.28 as=0.14 ps=1.28 w=1 l=0.15
X926 a_27245_15279# _53_.X VSS.t3339 VSS.t3338 sky130_fd_pr__nfet_01v8 ad=0.0813 pd=0.83 as=0.1092 ps=1.36 w=0.42 l=0.15
X927 VSS.t3106 VDD VSS.t3105 VSS.t3104 sky130_fd_pr__nfet_01v8 ad=0.143 pd=1.62 as=0 ps=0 w=0.55 l=1.97
X928 VSS.t436 VDD VSS.t435 VSS.t434 sky130_fd_pr__nfet_01v8 ad=0.143 pd=1.62 as=0 ps=0 w=0.55 l=2.89
X929 VSS.t893 VDD VSS.t892 VSS.t891 sky130_fd_pr__nfet_01v8 ad=0.143 pd=1.62 as=0 ps=0 w=0.55 l=4.73
X930 VSS.t2374 VDD VSS.t2373 VSS.t2372 sky130_fd_pr__nfet_01v8 ad=0.143 pd=1.62 as=0 ps=0 w=0.55 l=4.73
X931 VSS.t2977 VDD VSS.t2976 VSS.t2975 sky130_fd_pr__nfet_01v8 ad=0.143 pd=1.62 as=0 ps=0 w=0.55 l=4.73
X932 VDD VSS.t3796 VDD VDD sky130_fd_pr__pfet_01v8_hvt ad=0.2262 pd=2.26 as=0 ps=0 w=0.87 l=4.73
X933 VSS.t1415 VDD VSS.t1414 VSS.t1413 sky130_fd_pr__nfet_01v8 ad=0.143 pd=1.62 as=0 ps=0 w=0.55 l=4.73
X934 VDD VSS.t3474 VDD VDD sky130_fd_pr__pfet_01v8_hvt ad=0.2262 pd=2.26 as=0 ps=0 w=0.87 l=4.73
X935 VDD VSS.t3754 VDD VDD sky130_fd_pr__pfet_01v8_hvt ad=0.2262 pd=2.26 as=0 ps=0 w=0.87 l=4.73
X936 VDD VSS.t3886 VDD VDD sky130_fd_pr__pfet_01v8_hvt ad=0.2262 pd=2.26 as=0 ps=0 w=0.87 l=4.73
X937 VSS.t2595 VDD VSS.t2594 VSS.t2593 sky130_fd_pr__nfet_01v8 ad=0.143 pd=1.62 as=0 ps=0 w=0.55 l=4.73
X938 VSS.t2529 VDD VSS.t2528 VSS.t2527 sky130_fd_pr__nfet_01v8 ad=0.143 pd=1.62 as=0 ps=0 w=0.55 l=1.97
X939 VDD VSS.t3960 VDD VDD sky130_fd_pr__pfet_01v8_hvt ad=0.2262 pd=2.26 as=0 ps=0 w=0.87 l=4.73
X940 VDD a_18555_16733# a_18723_16635# VDD sky130_fd_pr__pfet_01v8_hvt ad=0.135 pd=1.27 as=0.27 ps=2.54 w=1 l=0.15
X941 VSS.t761 VDD VSS.t760 VSS.t759 sky130_fd_pr__nfet_01v8 ad=0.143 pd=1.62 as=0 ps=0 w=0.55 l=1.97
X942 VSS.t2571 VDD VSS.t2571 VSS.t2566 sky130_fd_pr__nfet_01v8 ad=0.143 pd=1.62 as=0 ps=0 w=0.55 l=0.59
X943 VDD VSS.t4015 VDD VDD sky130_fd_pr__pfet_01v8_hvt ad=0.2262 pd=2.26 as=0 ps=0 w=0.87 l=4.73
X944 VSS.t806 VDD VSS.t805 VSS.t804 sky130_fd_pr__nfet_01v8 ad=0.143 pd=1.62 as=0 ps=0 w=0.55 l=1.97
X945 VSS.t2852 VDD VSS.t2851 VSS.t2850 sky130_fd_pr__nfet_01v8 ad=0.143 pd=1.62 as=0 ps=0 w=0.55 l=4.73
X946 VDD VSS.t3680 VDD VDD sky130_fd_pr__pfet_01v8_hvt ad=0.2262 pd=2.26 as=0 ps=0 w=0.87 l=4.73
X947 VSS.t1648 VDD VSS.t1647 VSS.t1646 sky130_fd_pr__nfet_01v8 ad=0.143 pd=1.62 as=0 ps=0 w=0.55 l=4.73
X948 VSS.t3019 VDD VSS.t3018 VSS.t3017 sky130_fd_pr__nfet_01v8 ad=0.143 pd=1.62 as=0 ps=0 w=0.55 l=4.73
X949 VDD a_11413_16341.t34 _75_.CLK VDD sky130_fd_pr__pfet_01v8_hvt ad=0.14 pd=1.28 as=0.14 ps=1.28 w=1 l=0.15
X950 VDD VSS.t3608 VDD VDD sky130_fd_pr__pfet_01v8_hvt ad=0.2262 pd=2.26 as=0 ps=0 w=0.87 l=4.73
X951 VSS.t2929 VDD VSS.t2928 VSS.t2927 sky130_fd_pr__nfet_01v8 ad=0.143 pd=1.62 as=0 ps=0 w=0.55 l=1.97
X952 VSS.t1218 VDD VSS.t1217 VSS.t1216 sky130_fd_pr__nfet_01v8 ad=0.143 pd=1.62 as=0 ps=0 w=0.55 l=4.73
X953 VDD VSS.t4312 VDD VDD sky130_fd_pr__pfet_01v8_hvt ad=0.2262 pd=2.26 as=0 ps=0 w=0.87 l=4.73
X954 VSS.t2613 VDD VSS.t2612 VSS.t2611 sky130_fd_pr__nfet_01v8 ad=0.143 pd=1.62 as=0 ps=0 w=0.55 l=1.97
X955 VSS.t1194 VDD VSS.t1193 VSS.t1192 sky130_fd_pr__nfet_01v8 ad=0.143 pd=1.62 as=0 ps=0 w=0.55 l=4.73
X956 VSS.t22 _50_.A2 a_24777_15939# VSS.t3282 sky130_fd_pr__nfet_01v8 ad=0.0567 pd=0.69 as=0.1092 ps=1.36 w=0.42 l=0.15
X957 a_24859_15939# _50_.A2 a_24777_15939# VDD sky130_fd_pr__pfet_01v8_hvt ad=0.0441 pd=0.63 as=0.1092 ps=1.36 w=0.42 l=0.15
X958 VDD VSS.t3932 VDD VDD sky130_fd_pr__pfet_01v8_hvt ad=0.2262 pd=2.26 as=0 ps=0 w=0.87 l=4.73
X959 VDD VSS.t3641 VDD VDD sky130_fd_pr__pfet_01v8_hvt ad=0.2262 pd=2.26 as=0 ps=0 w=0.87 l=4.73
X960 VSS.t2675 VDD VSS.t2674 VSS.t2566 sky130_fd_pr__nfet_01v8 ad=0.143 pd=1.62 as=0 ps=0 w=0.55 l=4.73
X961 VDD VSS.t3873 VDD VDD sky130_fd_pr__pfet_01v8_hvt ad=0.2262 pd=2.26 as=0 ps=0 w=0.87 l=1.97
X962 VSS.t2759 VDD VSS.t2758 VSS.t2757 sky130_fd_pr__nfet_01v8 ad=0.143 pd=1.62 as=0 ps=0 w=0.55 l=1.97
X963 VDD VSS.t3565 VDD VDD sky130_fd_pr__pfet_01v8_hvt ad=0.2262 pd=2.26 as=0 ps=0 w=0.87 l=4.73
X964 VDD VSS.t3723 VDD VDD sky130_fd_pr__pfet_01v8_hvt ad=0.2262 pd=2.26 as=0 ps=0 w=0.87 l=1.97
X965 VDD a_28787_16885# a_28529_16885# VDD sky130_fd_pr__pfet_01v8_hvt ad=0.0567 pd=0.69 as=0.1092 ps=1.36 w=0.42 l=0.5
X966 VSS.t1565 VDD VSS.t1564 VSS.t1563 sky130_fd_pr__nfet_01v8 ad=0.143 pd=1.62 as=0 ps=0 w=0.55 l=1.97
X967 VDD VSS.t4207 VDD VDD sky130_fd_pr__pfet_01v8_hvt ad=0.2262 pd=2.26 as=0 ps=0 w=0.87 l=4.73
X968 VSS.t3037 VDD VSS.t3036 VSS.t3035 sky130_fd_pr__nfet_01v8 ad=0.143 pd=1.62 as=0 ps=0 w=0.55 l=4.73
X969 VDD VSS.t3726 VDD VDD sky130_fd_pr__pfet_01v8_hvt ad=0.2262 pd=2.26 as=0 ps=0 w=0.87 l=4.73
X970 a_11966_15823# a_11693_15829# a_11881_15823# VDD sky130_fd_pr__pfet_01v8_hvt ad=0.06825 pd=0.745 as=0.05775 ps=0.695 w=0.42 l=0.15
X971 clkbuf_0_clock_i.X a_16762_15823.t9 VDD VDD sky130_fd_pr__pfet_01v8_hvt ad=0.14 pd=1.28 as=0.14 ps=1.28 w=1 l=0.15
X972 VDD VSS.t3605 VDD VDD sky130_fd_pr__pfet_01v8_hvt ad=0.2262 pd=2.26 as=0 ps=0 w=0.87 l=4.73
X973 VSS.t2938 VDD VSS.t2937 VSS.t2936 sky130_fd_pr__nfet_01v8 ad=0.143 pd=1.62 as=0 ps=0 w=0.55 l=4.73
X974 VDD a_23707_15645# a_23875_15547# VDD sky130_fd_pr__pfet_01v8_hvt ad=0.135 pd=1.27 as=0.27 ps=2.54 w=1 l=0.15
X975 VSS.t1962 VDD VSS.t1961 VSS.t1960 sky130_fd_pr__nfet_01v8 ad=0.143 pd=1.62 as=0 ps=0 w=0.55 l=4.73
X976 VDD VSS.t433 VDD VDD sky130_fd_pr__pfet_01v8_hvt ad=0.2262 pd=2.26 as=0 ps=0 w=0.87 l=1.97
X977 VDD VSS.t4244 VDD VDD sky130_fd_pr__pfet_01v8_hvt ad=0.2262 pd=2.26 as=0 ps=0 w=0.87 l=4.73
X978 VDD VSS.t4013 VDD VDD sky130_fd_pr__pfet_01v8_hvt ad=0.2262 pd=2.26 as=0 ps=0 w=0.87 l=1.97
X979 VDD VSS.t4020 VDD VDD sky130_fd_pr__pfet_01v8_hvt ad=0.2262 pd=2.26 as=0 ps=0 w=0.87 l=4.73
X980 _36_.A.t0 a_18723_16635# VSS.t3385 VSS.t3438 sky130_fd_pr__nfet_01v8 ad=0.169 pd=1.82 as=0.08775 ps=0.92 w=0.65 l=0.15
X981 VSS.t1866 VDD VSS.t1865 VSS.t1864 sky130_fd_pr__nfet_01v8 ad=0.143 pd=1.62 as=0 ps=0 w=0.55 l=4.73
X982 VSS.t2481 VDD VSS.t2480 VSS.t2479 sky130_fd_pr__nfet_01v8 ad=0.143 pd=1.62 as=0 ps=0 w=0.55 l=4.73
X983 VSS.t3178 VDD VSS.t3177 VSS.t3176 sky130_fd_pr__nfet_01v8 ad=0.143 pd=1.62 as=0 ps=0 w=0.55 l=4.73
X984 _75_.CLK a_11413_16341.t15 VSS.t217 VSS.t216 sky130_fd_pr__nfet_01v8 ad=0.0588 pd=0.7 as=0.05775 ps=0.695 w=0.42 l=0.15
X985 VDD VSS.t3919 VDD VDD sky130_fd_pr__pfet_01v8_hvt ad=0.2262 pd=2.26 as=0 ps=0 w=0.87 l=4.73
X986 VSS.t1150 VDD VSS.t1149 VSS.t1148 sky130_fd_pr__nfet_01v8 ad=0.143 pd=1.62 as=0 ps=0 w=0.55 l=1.97
X987 VSS.t2795 VDD VSS.t2794 VSS.t2793 sky130_fd_pr__nfet_01v8 ad=0.143 pd=1.62 as=0 ps=0 w=0.55 l=4.73
X988 VDD VSS.t3451 VDD VDD sky130_fd_pr__pfet_01v8_hvt ad=0.2262 pd=2.26 as=0 ps=0 w=0.87 l=0.59
X989 VSS.t686 VDD VSS.t685 VSS.t684 sky130_fd_pr__nfet_01v8 ad=0.143 pd=1.62 as=0 ps=0 w=0.55 l=4.73
X990 VSS.t1173 VDD VSS.t1172 VSS.t1171 sky130_fd_pr__nfet_01v8 ad=0.143 pd=1.62 as=0 ps=0 w=0.55 l=4.73
X991 VSS.t1203 VDD VSS.t1202 VSS.t1201 sky130_fd_pr__nfet_01v8 ad=0.143 pd=1.62 as=0 ps=0 w=0.55 l=4.73
X992 VSS.t2093 VDD VSS.t2092 VSS.t2091 sky130_fd_pr__nfet_01v8 ad=0.143 pd=1.62 as=0 ps=0 w=0.55 l=4.73
X993 VSS.t384 VDD VSS.t383 VSS.t382 sky130_fd_pr__nfet_01v8 ad=0.143 pd=1.62 as=0 ps=0 w=0.55 l=4.73
X994 VDD a_16762_15823.t18 clkbuf_0_clock_i.X VDD sky130_fd_pr__pfet_01v8_hvt ad=0.14 pd=1.28 as=0.14 ps=1.28 w=1 l=0.15
X995 VSS.t2517 VDD VSS.t2516 VSS.t2515 sky130_fd_pr__nfet_01v8 ad=0.143 pd=1.62 as=0 ps=0 w=0.55 l=4.73
X996 a_28560_16367# a_28161_16367# a_28434_16733# VSS.t3273 sky130_fd_pr__special_nfet_01v8 ad=0.0696 pd=0.765 as=0.0621 ps=0.705 w=0.36 l=0.15
X997 VDD VSS.t3624 VDD VDD sky130_fd_pr__pfet_01v8_hvt ad=0.2262 pd=2.26 as=0 ps=0 w=0.87 l=4.73
X998 a_28161_16367# a_27995_16367# VDD VDD sky130_fd_pr__pfet_01v8_hvt ad=0.1664 pd=1.8 as=0.0864 ps=0.91 w=0.64 l=0.15
X999 VDD a_16762_15823.t8 clkbuf_0_clock_i.X VDD sky130_fd_pr__pfet_01v8_hvt ad=0.14 pd=1.28 as=0.14 ps=1.28 w=1 l=0.15
X1000 VDD VSS.t3899 VDD VDD sky130_fd_pr__pfet_01v8_hvt ad=0.2262 pd=2.26 as=0 ps=0 w=0.87 l=4.73
X1001 VDD VSS.t3807 VDD VDD sky130_fd_pr__pfet_01v8_hvt ad=0.2262 pd=2.26 as=0 ps=0 w=0.87 l=1.97
X1002 VSS.t1141 VDD VSS.t1140 VSS.t1139 sky130_fd_pr__nfet_01v8 ad=0.143 pd=1.62 as=0 ps=0 w=0.55 l=4.73
X1003 VSS.t2356 VDD VSS.t2356 VSS.t2351 sky130_fd_pr__nfet_01v8 ad=0.143 pd=1.62 as=0 ps=0 w=0.55 l=0.59
X1004 VSS.t1457 VDD VSS.t1456 VSS.t1455 sky130_fd_pr__nfet_01v8 ad=0.143 pd=1.62 as=0 ps=0 w=0.55 l=4.73
X1005 VDD VSS.t4004 VDD VDD sky130_fd_pr__pfet_01v8_hvt ad=0.2262 pd=2.26 as=0 ps=0 w=0.87 l=4.73
X1006 VDD VSS.t3946 VDD VDD sky130_fd_pr__pfet_01v8_hvt ad=0.2262 pd=2.26 as=0 ps=0 w=0.87 l=4.73
X1007 VSS.t1550 VDD VSS.t1549 VSS.t1548 sky130_fd_pr__nfet_01v8 ad=0.143 pd=1.62 as=0 ps=0 w=0.55 l=1.97
X1008 a_7189_16367# _74_.D.t2 VSS.t3366 VSS.t3365 sky130_fd_pr__nfet_01v8 ad=0.0813 pd=0.83 as=0.1092 ps=1.36 w=0.42 l=0.15
X1009 VDD VSS.t3874 VDD VDD sky130_fd_pr__pfet_01v8_hvt ad=0.2262 pd=2.26 as=0 ps=0 w=0.87 l=4.73
X1010 VSS.t2039 VDD VSS.t2038 VSS.t2037 sky130_fd_pr__nfet_01v8 ad=0.143 pd=1.62 as=0 ps=0 w=0.55 l=4.73
X1011 VSS.t938 VDD VSS.t937 VSS.t936 sky130_fd_pr__nfet_01v8 ad=0.143 pd=1.62 as=0 ps=0 w=0.55 l=4.73
X1012 VDD VSS.t3447 VDD VDD sky130_fd_pr__pfet_01v8_hvt ad=0.2262 pd=2.26 as=0 ps=0 w=0.87 l=4.73
X1013 VDD VSS.t3860 VDD VDD sky130_fd_pr__pfet_01v8_hvt ad=0.2262 pd=2.26 as=0 ps=0 w=0.87 l=4.73
X1014 VSS.t2228 VDD VSS.t2227 VSS.t2226 sky130_fd_pr__nfet_01v8 ad=0.143 pd=1.62 as=0 ps=0 w=0.55 l=1.97
X1015 VDD VSS.t3504 VDD VDD sky130_fd_pr__pfet_01v8_hvt ad=0.2262 pd=2.26 as=0 ps=0 w=0.87 l=4.73
X1016 VSS.t623 VDD VSS.t622 VSS.t621 sky130_fd_pr__nfet_01v8 ad=0.143 pd=1.62 as=0 ps=0 w=0.55 l=4.73
X1017 VDD VSS.t4249 VDD VDD sky130_fd_pr__pfet_01v8_hvt ad=0.2262 pd=2.26 as=0 ps=0 w=0.87 l=4.73
X1018 VSS.t2323 VDD VSS.t2322 VSS.t2321 sky130_fd_pr__nfet_01v8 ad=0.143 pd=1.62 as=0 ps=0 w=0.55 l=4.73
X1019 VDD VSS.t4123 VDD VDD sky130_fd_pr__pfet_01v8_hvt ad=0.2262 pd=2.26 as=0 ps=0 w=0.87 l=1.97
X1020 VSS.t428 VDD VSS.t427 VSS.t426 sky130_fd_pr__nfet_01v8 ad=0.143 pd=1.62 as=0 ps=0 w=0.55 l=2.89
X1021 _40_.Y _77_.Q VDD VDD sky130_fd_pr__pfet_01v8_hvt ad=0.0896 pd=0.92 as=0.1824 ps=1.85 w=0.64 l=0.15
X1022 _48_.A.t2 a_22751_16733# VSS.t46 VSS.t3422 sky130_fd_pr__nfet_01v8 ad=0.143 pd=1.09 as=0.10187 ps=0.99 w=0.65 l=0.15
X1023 VDD VSS.t4268 VDD VDD sky130_fd_pr__pfet_01v8_hvt ad=0.2262 pd=2.26 as=0 ps=0 w=0.87 l=4.73
X1024 VDD VSS.t3585 VDD VDD sky130_fd_pr__pfet_01v8_hvt ad=0.2262 pd=2.26 as=0 ps=0 w=0.87 l=4.73
X1025 VSS.t2550 VDD VSS.t2549 VSS.t2548 sky130_fd_pr__nfet_01v8 ad=0.143 pd=1.62 as=0 ps=0 w=0.55 l=4.73
X1026 VDD VSS.t3938 VDD VDD sky130_fd_pr__pfet_01v8_hvt ad=0.2262 pd=2.26 as=0 ps=0 w=0.87 l=1.05
X1027 VDD VSS.t3737 VDD VDD sky130_fd_pr__pfet_01v8_hvt ad=0.2262 pd=2.26 as=0 ps=0 w=0.87 l=1.97
X1028 VSS.t1018 VDD VSS.t1017 VSS.t1016 sky130_fd_pr__nfet_01v8 ad=0.143 pd=1.62 as=0 ps=0 w=0.55 l=4.73
X1029 VDD VSS.t4126 VDD VDD sky130_fd_pr__pfet_01v8_hvt ad=0.2262 pd=2.26 as=0 ps=0 w=0.87 l=4.73
X1030 VSS.t239 _61_.X.t2 a_5609_16367# VSS.t238 sky130_fd_pr__nfet_01v8 ad=0.1092 pd=1.36 as=0.0813 ps=0.83 w=0.42 l=0.15
X1031 VDD clkbuf_0_clock_i.X a_21914_15823.t4 VDD sky130_fd_pr__pfet_01v8_hvt ad=0.14 pd=1.28 as=0.14 ps=1.28 w=1 l=0.15
X1032 VSS.t79 a_16762_15823.t30 clkbuf_0_clock_i.X VSS.t80 sky130_fd_pr__nfet_01v8 ad=0.05775 pd=0.695 as=0.0588 ps=0.7 w=0.42 l=0.15
X1033 a_8951_16367# _63_.A.t6 a_9369_16367# VSS.t38 sky130_fd_pr__nfet_01v8 ad=0.169 pd=1.82 as=0.08775 ps=0.92 w=0.65 l=0.15
X1034 VSS.t127 _43_.A.t4 a_20359_14735# VSS.t126 sky130_fd_pr__nfet_01v8 ad=0.08775 pd=0.92 as=0.169 ps=1.82 w=0.65 l=0.15
X1035 VSS.t1669 VDD VSS.t1668 VSS.t1667 sky130_fd_pr__nfet_01v8 ad=0.143 pd=1.62 as=0 ps=0 w=0.55 l=4.73
X1036 VDD VSS.t2689 VDD VDD sky130_fd_pr__pfet_01v8_hvt ad=0.2262 pd=2.26 as=0 ps=0 w=0.87 l=4.73
X1037 VSS.t1442 VDD VSS.t1441 VSS.t1440 sky130_fd_pr__nfet_01v8 ad=0.143 pd=1.62 as=0 ps=0 w=0.55 l=4.73
X1038 VDD VSS.t3808 VDD VDD sky130_fd_pr__pfet_01v8_hvt ad=0.2262 pd=2.26 as=0 ps=0 w=0.87 l=4.73
X1039 VSS.t2254 VDD VSS.t2253 VSS.t2252 sky130_fd_pr__nfet_01v8 ad=0.143 pd=1.62 as=0 ps=0 w=0.55 l=4.73
X1040 VDD VSS.t3801 VDD VDD sky130_fd_pr__pfet_01v8_hvt ad=0.2262 pd=2.26 as=0 ps=0 w=0.87 l=4.73
X1041 a_25236_15601# _36_.B.t5 VDD VDD sky130_fd_pr__pfet_01v8_hvt ad=0.0768 pd=0.88 as=0.1696 ps=1.81 w=0.64 l=0.15
X1042 VDD VSS.t4286 VDD VDD sky130_fd_pr__pfet_01v8_hvt ad=0.2262 pd=2.26 as=0 ps=0 w=0.87 l=4.73
X1043 VDD VSS.t4192 VDD VDD sky130_fd_pr__pfet_01v8_hvt ad=0.2262 pd=2.26 as=0 ps=0 w=0.87 l=4.73
X1044 VSS.t2705 VDD VSS.t2704 VSS.t2703 sky130_fd_pr__nfet_01v8 ad=0.143 pd=1.62 as=0 ps=0 w=0.55 l=4.73
X1045 VSS.t2443 VDD VSS.t2442 VSS.t2441 sky130_fd_pr__nfet_01v8 ad=0.143 pd=1.62 as=0 ps=0 w=0.55 l=1.97
X1046 VSS.t551 VDD VSS.t550 VSS.t549 sky130_fd_pr__nfet_01v8 ad=0.143 pd=1.62 as=0 ps=0 w=0.55 l=4.73
X1047 VDD VSS.t3579 VDD VDD sky130_fd_pr__pfet_01v8_hvt ad=0.2262 pd=2.26 as=0 ps=0 w=0.87 l=4.73
X1048 VSS.t2634 VDD VSS.t2633 VSS.t2632 sky130_fd_pr__nfet_01v8 ad=0.143 pd=1.62 as=0 ps=0 w=0.55 l=4.73
X1049 VDD VSS.t3773 VDD VDD sky130_fd_pr__pfet_01v8_hvt ad=0.2262 pd=2.26 as=0 ps=0 w=0.87 l=1.97
X1050 _69_.X.t0 a_10883_15823# VSS.t3290 VSS.t3289 sky130_fd_pr__nfet_01v8 ad=0.1352 pd=1.56 as=0.0754 ps=0.81 w=0.52 l=0.15
X1051 VDD VSS.t4265 VDD VDD sky130_fd_pr__pfet_01v8_hvt ad=0.2262 pd=2.26 as=0 ps=0 w=0.87 l=4.73
X1052 VSS.t3242 a_28433_17143# _54_.A VSS.t3241 sky130_fd_pr__nfet_01v8 ad=0.097 pd=0.975 as=0.169 ps=1.82 w=0.65 l=0.15
X1053 VSS.t833 VDD VSS.t832 VSS.t831 sky130_fd_pr__nfet_01v8 ad=0.143 pd=1.62 as=0 ps=0 w=0.55 l=4.73
X1054 VSS.t2867 VDD VSS.t2866 VSS.t2865 sky130_fd_pr__nfet_01v8 ad=0.143 pd=1.62 as=0 ps=0 w=0.55 l=4.73
X1055 _43_.X a_20359_14735# VSS.t3350 VSS.t3351 sky130_fd_pr__nfet_01v8 ad=0.08775 pd=0.92 as=0.08775 ps=0.92 w=0.65 l=0.15
X1056 _75_.CLK a_11413_16341.t27 VDD VDD sky130_fd_pr__pfet_01v8_hvt ad=0.14 pd=1.28 as=0.14 ps=1.28 w=1 l=0.15
X1057 VDD _50_.B1.t2 _50_.Y VDD sky130_fd_pr__pfet_01v8_hvt ad=0.1824 pd=1.85 as=0.0896 ps=0.92 w=0.64 l=0.15
X1058 VDD a_26339_15279# _53_.X VDD sky130_fd_pr__pfet_01v8_hvt ad=0.135 pd=1.27 as=0.135 ps=1.27 w=1 l=0.15
X1059 VDD VSS.t3450 VDD VDD sky130_fd_pr__pfet_01v8_hvt ad=0.2262 pd=2.26 as=0 ps=0 w=0.87 l=4.73
X1060 VSS.t2780 VDD VSS.t2779 VSS.t2778 sky130_fd_pr__nfet_01v8 ad=0.143 pd=1.62 as=0 ps=0 w=0.55 l=4.73
X1061 VDD VSS.t4053 VDD VDD sky130_fd_pr__pfet_01v8_hvt ad=0.2262 pd=2.26 as=0 ps=0 w=0.87 l=1.97
X1062 VDD VSS.t4318 VDD VDD sky130_fd_pr__pfet_01v8_hvt ad=0.2262 pd=2.26 as=0 ps=0 w=0.87 l=4.73
X1063 VSS.t1245 VDD VSS.t1244 VSS.t1243 sky130_fd_pr__nfet_01v8 ad=0.143 pd=1.62 as=0 ps=0 w=0.55 l=4.73
X1064 VDD VSS.t4325 VDD VDD sky130_fd_pr__pfet_01v8_hvt ad=0.2262 pd=2.26 as=0 ps=0 w=0.87 l=4.73
X1065 VSS.t3005 VDD VSS.t3004 VSS.t3003 sky130_fd_pr__nfet_01v8 ad=0.143 pd=1.62 as=0 ps=0 w=0.55 l=4.73
X1066 VSS.t3088 VDD VSS.t3087 VSS.t3086 sky130_fd_pr__nfet_01v8 ad=0.143 pd=1.62 as=0 ps=0 w=0.55 l=4.73
X1067 VSS.t1707 VDD VSS.t1706 VSS.t1703 sky130_fd_pr__nfet_01v8 ad=0.143 pd=1.62 as=0 ps=0 w=0.55 l=1.97
X1068 a_28433_17143# a_28529_16885# VDD VDD sky130_fd_pr__pfet_01v8_hvt ad=0.1092 pd=1.36 as=0.14075 ps=1.325 w=0.42 l=0.5
X1069 VDD _63_.A.t3 a_7033_15823# VDD sky130_fd_pr__pfet_01v8_hvt ad=0.365 pd=1.73 as=0.105 ps=1.21 w=1 l=0.15
X1070 VDD VSS.t4056 VDD VDD sky130_fd_pr__pfet_01v8_hvt ad=0.2262 pd=2.26 as=0 ps=0 w=0.87 l=4.73
X1071 _74_.D.t0 a_6927_16911# VSS.t3369 VSS.t3371 sky130_fd_pr__nfet_01v8 ad=0.1352 pd=1.56 as=0.0754 ps=0.81 w=0.52 l=0.15
X1072 VSS.t2989 VDD VSS.t2988 VSS.t2987 sky130_fd_pr__nfet_01v8 ad=0.143 pd=1.62 as=0 ps=0 w=0.55 l=1.97
X1073 VSS.t2216 VDD VSS.t2215 VSS.t2214 sky130_fd_pr__nfet_01v8 ad=0.143 pd=1.62 as=0 ps=0 w=0.55 l=4.73
X1074 VSS.t884 VDD VSS.t883 VSS.t882 sky130_fd_pr__nfet_01v8 ad=0.143 pd=1.62 as=0 ps=0 w=0.55 l=4.73
X1075 VSS.t1592 VDD VSS.t1591 VSS.t1590 sky130_fd_pr__nfet_01v8 ad=0.143 pd=1.62 as=0 ps=0 w=0.55 l=4.73
X1076 VSS.t1302 VDD VSS.t1301 VSS.t1300 sky130_fd_pr__nfet_01v8 ad=0.143 pd=1.62 as=0 ps=0 w=0.55 l=4.73
X1077 a_28787_16885# _55_.A_N VSS.t3277 VSS.t3276 sky130_fd_pr__nfet_01v8 ad=0.1092 pd=1.36 as=0.0567 ps=0.69 w=0.42 l=0.15
X1078 VSS.t3052 VDD VSS.t3051 VSS.t3050 sky130_fd_pr__nfet_01v8 ad=0.143 pd=1.62 as=0 ps=0 w=0.55 l=4.73
X1079 VSS.t1887 VDD VSS.t1886 VSS.t1885 sky130_fd_pr__nfet_01v8 ad=0.143 pd=1.62 as=0 ps=0 w=0.55 l=4.73
X1080 VDD a_11413_16341.t36 _75_.CLK VDD sky130_fd_pr__pfet_01v8_hvt ad=0.14 pd=1.28 as=0.14 ps=1.28 w=1 l=0.15
X1081 a_20994_15253# a_20794_15553# a_21143_15279# VSS.t273 sky130_fd_pr__special_nfet_01v8 ad=0.0621 pd=0.705 as=0.0696 ps=0.765 w=0.36 l=0.15
X1082 VDD VSS.t3738 VDD VDD sky130_fd_pr__pfet_01v8_hvt ad=0.2262 pd=2.26 as=0 ps=0 w=0.87 l=4.73
X1083 VSS.t1756 VDD VSS.t1755 VSS.t1754 sky130_fd_pr__nfet_01v8 ad=0.143 pd=1.62 as=0 ps=0 w=0.55 l=4.73
X1084 VDD VSS.t3731 VDD VDD sky130_fd_pr__pfet_01v8_hvt ad=0.2262 pd=2.26 as=0 ps=0 w=0.87 l=4.73
X1085 VDD VSS.t3912 VDD VDD sky130_fd_pr__pfet_01v8_hvt ad=0.2262 pd=2.26 as=0 ps=0 w=0.87 l=4.73
X1086 VDD VSS.t4375 VDD VDD sky130_fd_pr__pfet_01v8_hvt ad=0.2262 pd=2.26 as=0 ps=0 w=0.87 l=1.05
X1087 VSS.t109 _36_.A.t4 a_18069_15279# VSS.t224 sky130_fd_pr__nfet_01v8 ad=0.08775 pd=0.92 as=0.06825 ps=0.86 w=0.65 l=0.15
X1088 VSS.t746 VDD VSS.t745 VSS.t744 sky130_fd_pr__nfet_01v8 ad=0.143 pd=1.62 as=0 ps=0 w=0.55 l=4.73
X1089 VDD VSS.t3703 VDD VDD sky130_fd_pr__pfet_01v8_hvt ad=0.2262 pd=2.26 as=0 ps=0 w=0.87 l=1.97
X1090 VSS.t2042 VDD VSS.t2041 VSS.t2040 sky130_fd_pr__nfet_01v8 ad=0.143 pd=1.62 as=0 ps=0 w=0.55 l=4.73
X1091 VSS.t1977 VDD VSS.t1976 VSS.t1975 sky130_fd_pr__nfet_01v8 ad=0.143 pd=1.62 as=0 ps=0 w=0.55 l=4.73
X1092 VDD VSS.t3836 VDD VDD sky130_fd_pr__pfet_01v8_hvt ad=0.2262 pd=2.26 as=0 ps=0 w=0.87 l=4.73
X1093 VDD VSS.t1385 VDD VDD sky130_fd_pr__pfet_01v8_hvt ad=0.2262 pd=2.26 as=0 ps=0 w=0.87 l=0.59
X1094 a_28161_16367# a_27995_16367# VSS.t14 VSS.t13 sky130_fd_pr__nfet_01v8 ad=0.1092 pd=1.36 as=0.0567 ps=0.69 w=0.42 l=0.15
X1095 VDD VSS.t4235 VDD VDD sky130_fd_pr__pfet_01v8_hvt ad=0.2262 pd=2.26 as=0 ps=0 w=0.87 l=4.73
X1096 VSS.t3097 VDD VSS.t3096 VSS.t3095 sky130_fd_pr__nfet_01v8 ad=0.143 pd=1.62 as=0 ps=0 w=0.55 l=4.73
X1097 VSS.t1600 VDD VSS.t1600 VSS.t1599 sky130_fd_pr__nfet_01v8 ad=0.143 pd=1.62 as=0 ps=0 w=0.55 l=0.59
X1098 VDD VSS.t3688 VDD VDD sky130_fd_pr__pfet_01v8_hvt ad=0.2262 pd=2.26 as=0 ps=0 w=0.87 l=4.73
X1099 VSS.t2022 VDD VSS.t2021 VSS.t2020 sky130_fd_pr__nfet_01v8 ad=0.143 pd=1.62 as=0 ps=0 w=0.55 l=4.73
X1100 VSS.t1185 VDD VSS.t1184 VSS.t1183 sky130_fd_pr__nfet_01v8 ad=0.143 pd=1.62 as=0 ps=0 w=0.55 l=4.73
X1101 VDD VSS.t3691 VDD VDD sky130_fd_pr__pfet_01v8_hvt ad=0.2262 pd=2.26 as=0 ps=0 w=0.87 l=4.73
X1102 VSS.t1230 VDD VSS.t1229 VSS.t1228 sky130_fd_pr__nfet_01v8 ad=0.143 pd=1.62 as=0 ps=0 w=0.55 l=4.73
X1103 VSS.t1925 VDD VSS.t1924 VSS.t1921 sky130_fd_pr__nfet_01v8 ad=0.143 pd=1.62 as=0 ps=0 w=0.55 l=1.97
X1104 VSS.t1630 VDD VSS.t1629 VSS.t1628 sky130_fd_pr__nfet_01v8 ad=0.143 pd=1.62 as=0 ps=0 w=0.55 l=4.73
X1105 VDD VSS.t4351 VDD VDD sky130_fd_pr__pfet_01v8_hvt ad=0.2262 pd=2.26 as=0 ps=0 w=0.87 l=4.73
X1106 VSS.t2039 VDD VSS.t2038 VSS.t2037 sky130_fd_pr__nfet_01v8 ad=0.143 pd=1.62 as=0 ps=0 w=0.55 l=4.73
X1107 VDD VSS.t3962 VDD VDD sky130_fd_pr__pfet_01v8_hvt ad=0.2262 pd=2.26 as=0 ps=0 w=0.87 l=1.97
X1108 VSS.t2431 VDD VSS.t2430 VSS.t2429 sky130_fd_pr__nfet_01v8 ad=0.143 pd=1.62 as=0 ps=0 w=0.55 l=4.73
X1109 VSS.t444 VDD VSS.t443 VSS.t442 sky130_fd_pr__nfet_01v8 ad=0.143 pd=1.62 as=0 ps=0 w=0.55 l=4.73
X1110 VDD VSS.t4210 VDD VDD sky130_fd_pr__pfet_01v8_hvt ad=0.2262 pd=2.26 as=0 ps=0 w=0.87 l=4.73
X1111 VSS.t2514 VDD VSS.t2513 VSS.t2512 sky130_fd_pr__nfet_01v8 ad=0.143 pd=1.62 as=0 ps=0 w=0.55 l=1.97
X1112 VDD VSS.t3777 VDD VDD sky130_fd_pr__pfet_01v8_hvt ad=0.2262 pd=2.26 as=0 ps=0 w=0.87 l=4.73
X1113 VSS.t1167 VDD VSS.t1166 VSS.t1058 sky130_fd_pr__nfet_01v8 ad=0.143 pd=1.62 as=0 ps=0 w=0.55 l=4.73
X1114 VSS.t1484 VDD VSS.t1483 VSS.t1482 sky130_fd_pr__nfet_01v8 ad=0.143 pd=1.62 as=0 ps=0 w=0.55 l=4.73
X1115 VSS.t1705 VDD VSS.t1704 VSS.t1703 sky130_fd_pr__nfet_01v8 ad=0.143 pd=1.62 as=0 ps=0 w=0.55 l=4.73
X1116 VDD VSS.t4398 VDD VDD sky130_fd_pr__pfet_01v8_hvt ad=0.2262 pd=2.26 as=0 ps=0 w=0.87 l=4.73
X1117 VSS.t1577 VDD VSS.t1576 VSS.t1575 sky130_fd_pr__nfet_01v8 ad=0.143 pd=1.62 as=0 ps=0 w=0.55 l=4.73
X1118 VSS.t3246 a_26799_16367# a_27133_16367# VSS.t3245 sky130_fd_pr__nfet_01v8 ad=0.169 pd=1.82 as=0.08775 ps=0.92 w=0.65 l=0.15
X1119 VSS.t705 VDD VSS.t704 VSS.t703 sky130_fd_pr__nfet_01v8 ad=0.143 pd=1.62 as=0 ps=0 w=0.55 l=4.73
X1120 VSS.t2986 VDD VSS.t2985 VSS.t2984 sky130_fd_pr__nfet_01v8 ad=0.143 pd=1.62 as=0 ps=0 w=0.55 l=4.73
X1121 VSS.t2807 VDD VSS.t2806 VSS.t2805 sky130_fd_pr__nfet_01v8 ad=0.143 pd=1.62 as=0 ps=0 w=0.55 l=4.73
X1122 VDD VSS.t3855 VDD VDD sky130_fd_pr__pfet_01v8_hvt ad=0.2262 pd=2.26 as=0 ps=0 w=0.87 l=4.73
X1123 VDD VSS.t3766 VDD VDD sky130_fd_pr__pfet_01v8_hvt ad=0.2262 pd=2.26 as=0 ps=0 w=0.87 l=4.73
X1124 a_18130_16733# a_17857_16367# a_18045_16367# VDD sky130_fd_pr__pfet_01v8_hvt ad=0.06825 pd=0.745 as=0.05775 ps=0.695 w=0.42 l=0.15
X1125 VDD a_16762_15823.t20 clkbuf_0_clock_i.X VDD sky130_fd_pr__pfet_01v8_hvt ad=0.14 pd=1.28 as=0.14 ps=1.28 w=1 l=0.15
X1126 VSS.t2243 VDD VSS.t2242 VSS.t2241 sky130_fd_pr__nfet_01v8 ad=0.143 pd=1.62 as=0 ps=0 w=0.55 l=1.97
X1127 VDD VSS.t3613 VDD VDD sky130_fd_pr__pfet_01v8_hvt ad=0.2262 pd=2.26 as=0 ps=0 w=0.87 l=4.73
X1128 VSS.t2117 VDD VSS.t2116 VSS.t2115 sky130_fd_pr__nfet_01v8 ad=0.143 pd=1.62 as=0 ps=0 w=0.55 l=4.73
X1129 VDD enable_i a_1407_3311# VDD sky130_fd_pr__pfet_01v8_hvt ad=0.149 pd=1.325 as=0.1664 ps=1.8 w=0.64 l=0.15
X1130 VDD _77_.CLK a_27995_16367# VDD sky130_fd_pr__pfet_01v8_hvt ad=0.0864 pd=0.91 as=0.1664 ps=1.8 w=0.64 l=0.15
X1131 VDD VSS.t4240 VDD VDD sky130_fd_pr__pfet_01v8_hvt ad=0.2262 pd=2.26 as=0 ps=0 w=0.87 l=4.73
X1132 VSS.t1385 VDD VSS.t1385 VSS.t1384 sky130_fd_pr__nfet_01v8 ad=0.143 pd=1.62 as=0 ps=0 w=0.55 l=0.59
X1133 VDD VSS.t4294 VDD VDD sky130_fd_pr__pfet_01v8_hvt ad=0.2262 pd=2.26 as=0 ps=0 w=0.87 l=4.73
X1134 VDD VSS.t3840 VDD VDD sky130_fd_pr__pfet_01v8_hvt ad=0.2262 pd=2.26 as=0 ps=0 w=0.87 l=4.73
X1135 VDD VSS.t3539 VDD VDD sky130_fd_pr__pfet_01v8_hvt ad=0.2262 pd=2.26 as=0 ps=0 w=0.87 l=4.73
X1136 VSS.t653 VDD VSS.t652 VSS.t651 sky130_fd_pr__nfet_01v8 ad=0.143 pd=1.62 as=0 ps=0 w=0.55 l=4.73
X1137 VDD VSS.t3987 VDD VDD sky130_fd_pr__pfet_01v8_hvt ad=0.2262 pd=2.26 as=0 ps=0 w=0.87 l=4.73
X1138 VDD VSS.t4364 VDD VDD sky130_fd_pr__pfet_01v8_hvt ad=0.2262 pd=2.26 as=0 ps=0 w=0.87 l=4.73
X1139 a_7400_16367# a_7001_16367# a_7274_16733# VSS.t253 sky130_fd_pr__special_nfet_01v8 ad=0.0696 pd=0.765 as=0.0621 ps=0.705 w=0.36 l=0.15
X1140 a_18555_16733# a_17857_16367# a_18298_16479# VSS.t259 sky130_fd_pr__special_nfet_01v8 ad=0.0684 pd=0.74 as=0.0989 ps=0.995 w=0.36 l=0.15
X1141 VDD a_21914_15823.t15 _77_.CLK VDD sky130_fd_pr__pfet_01v8_hvt ad=0.1375 pd=1.275 as=0.14 ps=1.28 w=1 l=0.15
X1142 VSS.t714 VDD VSS.t713 VSS.t712 sky130_fd_pr__nfet_01v8 ad=0.143 pd=1.62 as=0 ps=0 w=0.55 l=4.73
X1143 VSS.t2825 VDD VSS.t2824 VSS.t2823 sky130_fd_pr__nfet_01v8 ad=0.143 pd=1.62 as=0 ps=0 w=0.55 l=4.73
X1144 VSS.t1848 VDD VSS.t1847 VSS.t1846 sky130_fd_pr__nfet_01v8 ad=0.143 pd=1.62 as=0 ps=0 w=0.55 l=4.73
X1145 VDD VSS.t4389 VDD VDD sky130_fd_pr__pfet_01v8_hvt ad=0.2262 pd=2.26 as=0 ps=0 w=0.87 l=2.89
X1146 VSS.t964 VDD VSS.t963 VSS.t962 sky130_fd_pr__nfet_01v8 ad=0.143 pd=1.62 as=0 ps=0 w=0.55 l=4.73
X1147 VSS.t3139 VDD VSS.t3138 VSS.t3137 sky130_fd_pr__nfet_01v8 ad=0.143 pd=1.62 as=0 ps=0 w=0.55 l=4.73
X1148 VSS.t1096 VDD VSS.t1095 VSS.t1094 sky130_fd_pr__nfet_01v8 ad=0.143 pd=1.62 as=0 ps=0 w=0.55 l=4.73
X1149 VSS.t2156 VDD VSS.t2155 VSS.t2154 sky130_fd_pr__nfet_01v8 ad=0.143 pd=1.62 as=0 ps=0 w=0.55 l=4.73
X1150 VSS.t422 VDD VSS.t421 VSS.t420 sky130_fd_pr__nfet_01v8 ad=0.143 pd=1.62 as=0 ps=0 w=0.55 l=0.59
X1151 VSS.t2069 VDD VSS.t2068 VSS.t2067 sky130_fd_pr__nfet_01v8 ad=0.143 pd=1.62 as=0 ps=0 w=0.55 l=1.97
X1152 VSS.t1514 VDD VSS.t1513 VSS.t1512 sky130_fd_pr__nfet_01v8 ad=0.143 pd=1.62 as=0 ps=0 w=0.55 l=4.73
X1153 _63_.B input1.X.t19 a_6737_17231# VSS.t3367 sky130_fd_pr__nfet_01v8 ad=0.169 pd=1.82 as=0.08775 ps=0.92 w=0.65 l=0.15
X1154 clkbuf_0_clock_i.X a_16762_15823.t23 VSS.t3257 VSS.t3256 sky130_fd_pr__nfet_01v8 ad=0.0588 pd=0.7 as=0.0588 ps=0.7 w=0.42 l=0.15
X1155 VDD VSS.t3443 VDD VDD sky130_fd_pr__pfet_01v8_hvt ad=0.2262 pd=2.26 as=0 ps=0 w=0.87 l=0.59
X1156 VDD VSS.t3707 VDD VDD sky130_fd_pr__pfet_01v8_hvt ad=0.2262 pd=2.26 as=0 ps=0 w=0.87 l=4.73
X1157 VSS.t1045 VDD VSS.t1044 VSS.t1043 sky130_fd_pr__nfet_01v8 ad=0.143 pd=1.62 as=0 ps=0 w=0.55 l=4.73
X1158 VDD VSS.t3590 VDD VDD sky130_fd_pr__pfet_01v8_hvt ad=0.2262 pd=2.26 as=0 ps=0 w=0.87 l=4.73
X1159 VDD VSS.t3572 VDD VDD sky130_fd_pr__pfet_01v8_hvt ad=0.2262 pd=2.26 as=0 ps=0 w=0.87 l=4.73
X1160 VDD VSS.t3825 VDD VDD sky130_fd_pr__pfet_01v8_hvt ad=0.2262 pd=2.26 as=0 ps=0 w=0.87 l=4.73
X1161 VDD VSS.t4117 VDD VDD sky130_fd_pr__pfet_01v8_hvt ad=0.2262 pd=2.26 as=0 ps=0 w=0.87 l=4.73
X1162 VDD VSS.t4349 VDD VDD sky130_fd_pr__pfet_01v8_hvt ad=0.2262 pd=2.26 as=0 ps=0 w=0.87 l=1.97
X1163 VSS.t24 output3.A.t5 a_8951_16367# VSS.t205 sky130_fd_pr__nfet_01v8 ad=0.08775 pd=0.92 as=0.169 ps=1.82 w=0.65 l=0.15
X1164 VSS.t1923 VDD VSS.t1922 VSS.t1921 sky130_fd_pr__nfet_01v8 ad=0.143 pd=1.62 as=0 ps=0 w=0.55 l=4.73
X1165 VDD VSS.t4022 VDD VDD sky130_fd_pr__pfet_01v8_hvt ad=0.2262 pd=2.26 as=0 ps=0 w=0.87 l=1.97
X1166 _36_.A.t1 a_18723_16635# VDD VDD sky130_fd_pr__pfet_01v8_hvt ad=0.26 pd=2.52 as=0.135 ps=1.27 w=1 l=0.15
X1167 VSS.t531 VDD VSS.t530 VSS.t529 sky130_fd_pr__nfet_01v8 ad=0.143 pd=1.62 as=0 ps=0 w=0.55 l=4.73
X1168 VDD VSS.t4287 VDD VDD sky130_fd_pr__pfet_01v8_hvt ad=0.2262 pd=2.26 as=0 ps=0 w=0.87 l=1.05
X1169 VDD a_17987_15279# _36_.Y VDD sky130_fd_pr__pfet_01v8_hvt ad=0.36 pd=2.72 as=0.165 ps=1.33 w=1 l=0.15
X1170 VDD VSS.t3978 VDD VDD sky130_fd_pr__pfet_01v8_hvt ad=0.2262 pd=2.26 as=0 ps=0 w=0.87 l=1.97
X1171 VDD VSS.t1493 VDD VDD sky130_fd_pr__pfet_01v8_hvt ad=0.2262 pd=2.26 as=0 ps=0 w=0.87 l=0.59
X1172 VDD _56_.Y a_25309_16617# VDD sky130_fd_pr__pfet_01v8_hvt ad=0.26 pd=2.52 as=0.135 ps=1.27 w=1 l=0.15
X1173 a_23487_16617# _70_.Q VDD VDD sky130_fd_pr__pfet_01v8_hvt ad=0.0693 pd=0.75 as=0.14825 ps=1.34 w=0.42 l=0.15
X1174 VSS.t2458 VDD VSS.t2457 VSS.t2456 sky130_fd_pr__nfet_01v8 ad=0.143 pd=1.62 as=0 ps=0 w=0.55 l=1.97
X1175 VDD VSS.t3768 VDD VDD sky130_fd_pr__pfet_01v8_hvt ad=0.2262 pd=2.26 as=0 ps=0 w=0.87 l=1.97
X1176 VDD VSS.t3882 VDD VDD sky130_fd_pr__pfet_01v8_hvt ad=0.2262 pd=2.26 as=0 ps=0 w=0.87 l=1.97
X1177 a_8951_16367# output3.A.t2 VSS.t1 VSS.t0 sky130_fd_pr__nfet_01v8 ad=0.08775 pd=0.92 as=0.08775 ps=0.92 w=0.65 l=0.15
X1178 _50_.A2 _70_.Q VDD VDD sky130_fd_pr__pfet_01v8_hvt ad=0.26 pd=2.52 as=0.165 ps=1.33 w=1 l=0.15
X1179 VSS.t3356 enable_i a_1407_3311# VSS.t3355 sky130_fd_pr__nfet_01v8 ad=0.097 pd=0.975 as=0.1092 ps=1.36 w=0.42 l=0.15
X1180 VSS.t2174 VDD VSS.t2173 VSS.t2172 sky130_fd_pr__nfet_01v8 ad=0.143 pd=1.62 as=0 ps=0 w=0.55 l=4.73
X1181 VDD VSS.t3457 VDD VDD sky130_fd_pr__pfet_01v8_hvt ad=0.2262 pd=2.26 as=0 ps=0 w=0.87 l=0.59
X1182 _38_.A a_18183_17249# VDD VDD sky130_fd_pr__pfet_01v8_hvt ad=0.475 pd=2.95 as=0.16655 ps=1.39 w=1 l=0.15
X1183 VDD VSS.t3934 VDD VDD sky130_fd_pr__pfet_01v8_hvt ad=0.2262 pd=2.26 as=0 ps=0 w=0.87 l=4.73
X1184 VDD VSS.t3444 VDD VDD sky130_fd_pr__pfet_01v8_hvt ad=0.2262 pd=2.26 as=0 ps=0 w=0.87 l=4.73
X1185 VSS.t2078 VDD VSS.t2077 VSS.t2076 sky130_fd_pr__nfet_01v8 ad=0.143 pd=1.62 as=0 ps=0 w=0.55 l=4.73
X1186 _50_.Y _50_.B1.t2 a_25148_15279# VSS.t90 sky130_fd_pr__nfet_01v8 ad=0.1113 pd=1.37 as=0.0588 ps=0.7 w=0.42 l=0.15
X1187 VDD VSS.t1708 VDD VDD sky130_fd_pr__pfet_01v8_hvt ad=0.2262 pd=2.26 as=0 ps=0 w=0.87 l=0.59
X1188 a_27330_15645# a_26891_15279# a_27245_15279# VSS.t3346 sky130_fd_pr__special_nfet_01v8 ad=0.0621 pd=0.705 as=0.0813 ps=0.83 w=0.36 l=0.15
X1189 VDD VSS.t4383 VDD VDD sky130_fd_pr__pfet_01v8_hvt ad=0.2262 pd=2.26 as=0 ps=0 w=0.87 l=4.73
X1190 VSS.t1272 VDD VSS.t1271 VSS.t1270 sky130_fd_pr__nfet_01v8 ad=0.143 pd=1.62 as=0 ps=0 w=0.55 l=4.73
X1191 a_9853_15823# _67_.A.t2 VDD VDD sky130_fd_pr__pfet_01v8_hvt ad=0.105 pd=1.21 as=0.365 ps=1.73 w=1 l=0.15
X1192 VDD VSS.t4292 VDD VDD sky130_fd_pr__pfet_01v8_hvt ad=0.2262 pd=2.26 as=0 ps=0 w=0.87 l=1.97
X1193 VSS.t1114 VDD VSS.t1113 VSS.t1112 sky130_fd_pr__nfet_01v8 ad=0.143 pd=1.62 as=0 ps=0 w=0.55 l=4.73
X1194 VSS.t363 VDD VSS.t362 VSS.t361 sky130_fd_pr__nfet_01v8 ad=0.143 pd=1.62 as=0 ps=0 w=0.55 l=1.05
X1195 VDD VSS.t4299 VDD VDD sky130_fd_pr__pfet_01v8_hvt ad=0.2262 pd=2.26 as=0 ps=0 w=0.87 l=4.73
X1196 VDD VSS.t4036 VDD VDD sky130_fd_pr__pfet_01v8_hvt ad=0.2262 pd=2.26 as=0 ps=0 w=0.87 l=4.73
X1197 VSS.t2371 VDD VSS.t2370 VSS.t2369 sky130_fd_pr__nfet_01v8 ad=0.143 pd=1.62 as=0 ps=0 w=0.55 l=4.73
X1198 VSS.t2305 VDD VSS.t2304 VSS.t2303 sky130_fd_pr__nfet_01v8 ad=0.143 pd=1.62 as=0 ps=0 w=0.55 l=4.73
X1199 VDD VSS.t4141 VDD VDD sky130_fd_pr__pfet_01v8_hvt ad=0.2262 pd=2.26 as=0 ps=0 w=0.87 l=4.73
X1200 VSS.t958 VDD VSS.t957 VSS.t956 sky130_fd_pr__nfet_01v8 ad=0.143 pd=1.62 as=0 ps=0 w=0.55 l=4.73
X1201 VDD VSS.t3797 VDD VDD sky130_fd_pr__pfet_01v8_hvt ad=0.2262 pd=2.26 as=0 ps=0 w=0.87 l=4.73
X1202 a_9369_16367# input1.X.t5 a_9727_16367# VSS.t3370 sky130_fd_pr__nfet_01v8 ad=0.08775 pd=0.92 as=0.08775 ps=0.92 w=0.65 l=0.15
X1203 VSS.t439 VDD VSS.t438 VSS.t437 sky130_fd_pr__nfet_01v8 ad=0.143 pd=1.62 as=0 ps=0 w=0.55 l=2.89
X1204 VDD VSS.t3755 VDD VDD sky130_fd_pr__pfet_01v8_hvt ad=0.2262 pd=2.26 as=0 ps=0 w=0.87 l=4.73
X1205 VDD VSS.t4047 VDD VDD sky130_fd_pr__pfet_01v8_hvt ad=0.2262 pd=2.26 as=0 ps=0 w=0.87 l=4.73
X1206 VSS.t2526 VDD VSS.t2525 VSS.t2524 sky130_fd_pr__nfet_01v8 ad=0.143 pd=1.62 as=0 ps=0 w=0.55 l=4.73
X1207 _75_.CLK a_11413_16341.t39 VDD VDD sky130_fd_pr__pfet_01v8_hvt ad=0.14 pd=1.28 as=0.265 ps=2.53 w=1 l=0.15
X1208 VDD VSS.t3928 VDD VDD sky130_fd_pr__pfet_01v8_hvt ad=0.2262 pd=2.26 as=0 ps=0 w=0.87 l=1.97
X1209 a_23352_16519# _44_.Y VSS.t236 VSS.t248 sky130_fd_pr__nfet_01v8 ad=0.1092 pd=1.36 as=0.0567 ps=0.69 w=0.42 l=0.15
X1210 a_11966_15823# a_11527_15829# a_11881_15823# VSS.t3390 sky130_fd_pr__special_nfet_01v8 ad=0.0621 pd=0.705 as=0.0813 ps=0.83 w=0.36 l=0.15
X1211 VSS.t857 VDD VSS.t856 VSS.t855 sky130_fd_pr__nfet_01v8 ad=0.143 pd=1.62 as=0 ps=0 w=0.55 l=4.73
X1212 VSS.t911 VDD VSS.t910 VSS.t909 sky130_fd_pr__nfet_01v8 ad=0.143 pd=1.62 as=0 ps=0 w=0.55 l=4.73
X1213 _75_.CLK a_11413_16341.t29 VDD VDD sky130_fd_pr__pfet_01v8_hvt ad=0.14 pd=1.28 as=0.14 ps=1.28 w=1 l=0.15
X1214 VSS.t3350 a_20359_14735# _43_.X VSS.t3349 sky130_fd_pr__nfet_01v8 ad=0.08775 pd=0.92 as=0.08775 ps=0.92 w=0.65 l=0.15
X1215 VSS.t1051 VDD VSS.t1050 VSS.t1049 sky130_fd_pr__nfet_01v8 ad=0.143 pd=1.62 as=0 ps=0 w=0.55 l=1.97
X1216 a_9761_16143# _67_.B VSS.t52 VSS.t51 sky130_fd_pr__nfet_01v8 ad=0.08775 pd=0.92 as=0.169 ps=1.82 w=0.65 l=0.15
X1217 VDD VSS.t4042 VDD VDD sky130_fd_pr__pfet_01v8_hvt ad=0.2262 pd=2.26 as=0 ps=0 w=0.87 l=1.97
X1218 hold12.X a_28359_15823# VSS.t3328 VSS.t3392 sky130_fd_pr__nfet_01v8 ad=0.169 pd=1.82 as=0.097 ps=0.975 w=0.65 l=0.15
X1219 VDD VSS.t3907 VDD VDD sky130_fd_pr__pfet_01v8_hvt ad=0.2262 pd=2.26 as=0 ps=0 w=0.87 l=4.73
X1220 VDD VSS.t4027 VDD VDD sky130_fd_pr__pfet_01v8_hvt ad=0.2262 pd=2.26 as=0 ps=0 w=0.87 l=1.97
X1221 VDD VSS.t3698 VDD VDD sky130_fd_pr__pfet_01v8_hvt ad=0.2262 pd=2.26 as=0 ps=0 w=0.87 l=1.97
X1222 VSS.t2389 VDD VSS.t2388 VSS.t2387 sky130_fd_pr__nfet_01v8 ad=0.143 pd=1.62 as=0 ps=0 w=0.55 l=4.73
X1223 VDD VSS.t3791 VDD VDD sky130_fd_pr__pfet_01v8_hvt ad=0.2262 pd=2.26 as=0 ps=0 w=0.87 l=4.73
X1224 VDD VSS.t4226 VDD VDD sky130_fd_pr__pfet_01v8_hvt ad=0.2262 pd=2.26 as=0 ps=0 w=0.87 l=4.73
X1225 VSS.t1493 VDD VSS.t1493 VSS.t1488 sky130_fd_pr__nfet_01v8 ad=0.143 pd=1.62 as=0 ps=0 w=0.55 l=0.59
X1226 VSS.t288 VDD VSS.t287 VSS.t286 sky130_fd_pr__nfet_01v8 ad=0.143 pd=1.62 as=0 ps=0 w=0.55 l=4.73
X1227 VSS.t2535 VDD VSS.t2534 VSS.t2533 sky130_fd_pr__nfet_01v8 ad=0.143 pd=1.62 as=0 ps=0 w=0.55 l=4.73
X1228 VDD VSS.t4135 VDD VDD sky130_fd_pr__pfet_01v8_hvt ad=0.2262 pd=2.26 as=0 ps=0 w=0.87 l=4.73
X1229 VDD VSS.t3566 VDD VDD sky130_fd_pr__pfet_01v8_hvt ad=0.2262 pd=2.26 as=0 ps=0 w=0.87 l=4.73
X1230 VSS.t590 VDD VSS.t589 VSS.t588 sky130_fd_pr__nfet_01v8 ad=0.143 pd=1.62 as=0 ps=0 w=0.55 l=4.73
X1231 VSS.t1353 VDD VSS.t1352 VSS.t1351 sky130_fd_pr__nfet_01v8 ad=0.143 pd=1.62 as=0 ps=0 w=0.55 l=4.73
X1232 VSS.t1277 VDD VSS.t1276 VSS.t1273 sky130_fd_pr__nfet_01v8 ad=0.143 pd=1.62 as=0 ps=0 w=0.55 l=1.97
X1233 VDD VSS.t3513 VDD VDD sky130_fd_pr__pfet_01v8_hvt ad=0.2262 pd=2.26 as=0 ps=0 w=0.87 l=1.97
X1234 VDD VSS.t4071 VDD VDD sky130_fd_pr__pfet_01v8_hvt ad=0.2262 pd=2.26 as=0 ps=0 w=0.87 l=4.73
X1235 VSS.t1257 VDD VSS.t1256 VSS.t1255 sky130_fd_pr__nfet_01v8 ad=0.143 pd=1.62 as=0 ps=0 w=0.55 l=4.73
X1236 VSS.t3034 VDD VSS.t3033 VSS.t3032 sky130_fd_pr__nfet_01v8 ad=0.143 pd=1.62 as=0 ps=0 w=0.55 l=4.73
X1237 VDD VSS.t3727 VDD VDD sky130_fd_pr__pfet_01v8_hvt ad=0.2262 pd=2.26 as=0 ps=0 w=0.87 l=4.73
X1238 VSS.t1436 VDD VSS.t1435 VSS.t1434 sky130_fd_pr__nfet_01v8 ad=0.143 pd=1.62 as=0 ps=0 w=0.55 l=1.97
X1239 VSS.t3333 a_23352_16519# _46_.X VSS.t3332 sky130_fd_pr__nfet_01v8 ad=0.10187 pd=0.99 as=0.182 ps=1.86 w=0.65 l=0.15
X1240 VSS.t98 a_32503_16919# counter_value_o[6] VSS.t97 sky130_fd_pr__nfet_01v8 ad=0.17225 pd=1.83 as=0.08775 ps=0.92 w=0.65 l=0.15
X1241 VDD VSS.t3516 VDD VDD sky130_fd_pr__pfet_01v8_hvt ad=0.2262 pd=2.26 as=0 ps=0 w=0.87 l=4.73
X1242 VDD VSS.t1611 VDD VDD sky130_fd_pr__pfet_01v8_hvt ad=0.2262 pd=2.26 as=0 ps=0 w=0.87 l=4.73
X1243 VSS.t257 a_7867_16635# a_7825_16367# VSS.t256 sky130_fd_pr__nfet_01v8 ad=0.1092 pd=1.36 as=0.066 ps=0.745 w=0.42 l=0.15
X1244 a_10633_16395# input2.X.t14 a_10547_16395# VSS.t87 sky130_fd_pr__nfet_01v8 ad=0.0567 pd=0.69 as=0.1176 ps=1.4 w=0.42 l=0.15
X1245 a_27432_16143# a_27366_16055# _55_.Y VSS.t37 sky130_fd_pr__nfet_01v8 ad=0.08775 pd=0.92 as=0.169 ps=1.82 w=0.65 l=0.15
X1246 VDD VSS.t3606 VDD VDD sky130_fd_pr__pfet_01v8_hvt ad=0.2262 pd=2.26 as=0 ps=0 w=0.87 l=4.73
X1247 VDD VSS.t3813 VDD VDD sky130_fd_pr__pfet_01v8_hvt ad=0.2262 pd=2.26 as=0 ps=0 w=0.87 l=4.73
X1248 VDD VSS.t3953 VDD VDD sky130_fd_pr__pfet_01v8_hvt ad=0.2262 pd=2.26 as=0 ps=0 w=0.87 l=4.73
X1249 VSS.t14 _77_.CLK a_27995_16367# VSS.t263 sky130_fd_pr__nfet_01v8 ad=0.0567 pd=0.69 as=0.1092 ps=1.36 w=0.42 l=0.15
X1250 VDD VSS.t4344 VDD VDD sky130_fd_pr__pfet_01v8_hvt ad=0.2262 pd=2.26 as=0 ps=0 w=0.87 l=4.73
X1251 VSS.t2935 VDD VSS.t2934 VSS.t2933 sky130_fd_pr__nfet_01v8 ad=0.143 pd=1.62 as=0 ps=0 w=0.55 l=4.73
X1252 VDD VSS.t4219 VDD VDD sky130_fd_pr__pfet_01v8_hvt ad=0.2262 pd=2.26 as=0 ps=0 w=0.87 l=4.73
X1253 VDD VSS.t4201 VDD VDD sky130_fd_pr__pfet_01v8_hvt ad=0.2262 pd=2.26 as=0 ps=0 w=0.87 l=4.73
X1254 VSS.t1768 VDD VSS.t1767 VSS.t1766 sky130_fd_pr__nfet_01v8 ad=0.143 pd=1.62 as=0 ps=0 w=0.55 l=1.97
X1255 a_11881_15823# _69_.X.t2 VDD VDD sky130_fd_pr__pfet_01v8_hvt ad=0.05775 pd=0.695 as=0.1092 ps=1.36 w=0.42 l=0.15
X1256 VSS.t917 VDD VSS.t916 VSS.t915 sky130_fd_pr__nfet_01v8 ad=0.143 pd=1.62 as=0 ps=0 w=0.55 l=4.73
X1257 VDD VSS.t4367 VDD VDD sky130_fd_pr__pfet_01v8_hvt ad=0.2262 pd=2.26 as=0 ps=0 w=0.87 l=0.59
X1258 VDD VSS.t2901 VDD VDD sky130_fd_pr__pfet_01v8_hvt ad=0.2262 pd=2.26 as=0 ps=0 w=0.87 l=4.73
X1259 VSS.t2478 VDD VSS.t2477 VSS.t2476 sky130_fd_pr__nfet_01v8 ad=0.143 pd=1.62 as=0 ps=0 w=0.55 l=4.73
X1260 VSS.t315 VDD VSS.t314 VSS.t313 sky130_fd_pr__nfet_01v8 ad=0.143 pd=1.62 as=0 ps=0 w=0.55 l=2.89
X1261 VSS.t1380 VDD VSS.t1379 VSS.t1378 sky130_fd_pr__nfet_01v8 ad=0.143 pd=1.62 as=0 ps=0 w=0.55 l=1.97
X1262 VDD VSS.t3721 VDD VDD sky130_fd_pr__pfet_01v8_hvt ad=0.2262 pd=2.26 as=0 ps=0 w=0.87 l=4.73
X1263 VDD VSS.t3629 VDD VDD sky130_fd_pr__pfet_01v8_hvt ad=0.2262 pd=2.26 as=0 ps=0 w=0.87 l=4.73
X1264 VSS.t2792 VDD VSS.t2791 VSS.t2790 sky130_fd_pr__nfet_01v8 ad=0.143 pd=1.62 as=0 ps=0 w=0.55 l=4.73
X1265 VSS.t2846 VDD VSS.t2845 VSS.t2844 sky130_fd_pr__nfet_01v8 ad=0.143 pd=1.62 as=0 ps=0 w=0.55 l=4.73
X1266 VSS.t3073 VDD VSS.t3072 VSS.t3071 sky130_fd_pr__nfet_01v8 ad=0.143 pd=1.62 as=0 ps=0 w=0.55 l=4.73
X1267 VDD VSS.t3832 VDD VDD sky130_fd_pr__pfet_01v8_hvt ad=0.2262 pd=2.26 as=0 ps=0 w=0.87 l=1.97
X1268 VDD VSS.t4010 VDD VDD sky130_fd_pr__pfet_01v8_hvt ad=0.2262 pd=2.26 as=0 ps=0 w=0.87 l=4.73
X1269 VSS.t650 VDD VSS.t649 VSS.t648 sky130_fd_pr__nfet_01v8 ad=0.143 pd=1.62 as=0 ps=0 w=0.55 l=1.05
X1270 VDD VSS.t3900 VDD VDD sky130_fd_pr__pfet_01v8_hvt ad=0.2262 pd=2.26 as=0 ps=0 w=0.87 l=4.73
X1271 VDD VSS.t4065 VDD VDD sky130_fd_pr__pfet_01v8_hvt ad=0.2262 pd=2.26 as=0 ps=0 w=0.87 l=4.73
X1272 VSS.t785 VDD VSS.t784 VSS.t783 sky130_fd_pr__nfet_01v8 ad=0.143 pd=1.62 as=0 ps=0 w=0.55 l=4.73
X1273 VSS.t1777 VDD VSS.t1776 VSS.t1775 sky130_fd_pr__nfet_01v8 ad=0.143 pd=1.62 as=0 ps=0 w=0.55 l=4.73
X1274 _77_.CLK a_21914_15823.t8 VDD VDD sky130_fd_pr__pfet_01v8_hvt ad=0.14 pd=1.28 as=0.14 ps=1.28 w=1 l=0.15
X1275 VDD VSS.t3593 VDD VDD sky130_fd_pr__pfet_01v8_hvt ad=0.2262 pd=2.26 as=0 ps=0 w=0.87 l=1.97
X1276 VSS.t1998 VDD VSS.t1997 VSS.t1996 sky130_fd_pr__nfet_01v8 ad=0.143 pd=1.62 as=0 ps=0 w=0.55 l=1.97
X1277 VDD VSS.t4272 VDD VDD sky130_fd_pr__pfet_01v8_hvt ad=0.2262 pd=2.26 as=0 ps=0 w=0.87 l=2.89
X1278 VSS.t575 VDD VSS.t574 VSS.t573 sky130_fd_pr__nfet_01v8 ad=0.143 pd=1.62 as=0 ps=0 w=0.55 l=4.73
X1279 VSS.t1123 VDD VSS.t1122 VSS.t1121 sky130_fd_pr__nfet_01v8 ad=0.143 pd=1.62 as=0 ps=0 w=0.55 l=4.73
X1280 a_28529_16733# a_27995_16367# a_28434_16733# VDD sky130_fd_pr__pfet_01v8_hvt ad=0.07665 pd=0.785 as=0.06825 ps=0.745 w=0.42 l=0.15
X1281 input1.X.t0 a_1407_3311# VSS.t3356 VSS.t3431 sky130_fd_pr__nfet_01v8 ad=0.08775 pd=0.92 as=0.097 ps=0.975 w=0.65 l=0.15
X1282 VDD _77_.Q a_22843_16919# VDD sky130_fd_pr__pfet_01v8_hvt ad=0.149 pd=1.325 as=0.1664 ps=1.8 w=0.64 l=0.15
X1283 VDD VSS.t3461 VDD VDD sky130_fd_pr__pfet_01v8_hvt ad=0.2262 pd=2.26 as=0 ps=0 w=0.87 l=4.73
X1284 VDD VSS.t3743 VDD VDD sky130_fd_pr__pfet_01v8_hvt ad=0.2262 pd=2.26 as=0 ps=0 w=0.87 l=4.73
X1285 VDD VSS.t3875 VDD VDD sky130_fd_pr__pfet_01v8_hvt ad=0.2262 pd=2.26 as=0 ps=0 w=0.87 l=4.73
X1286 a_9727_16367# input1.X.t4 a_9369_16367# VSS.t114 sky130_fd_pr__nfet_01v8 ad=0.10725 pd=0.98 as=0.08775 ps=0.92 w=0.65 l=0.15
X1287 VSS.t2036 VDD VSS.t2035 VSS.t2034 sky130_fd_pr__nfet_01v8 ad=0.143 pd=1.62 as=0 ps=0 w=0.55 l=4.73
X1288 VDD VSS.t3973 VDD VDD sky130_fd_pr__pfet_01v8_hvt ad=0.2262 pd=2.26 as=0 ps=0 w=0.87 l=4.73
X1289 VDD a_23027_14735# _48_.X VDD sky130_fd_pr__pfet_01v8_hvt ad=0.26 pd=2.52 as=0.135 ps=1.27 w=1 l=0.15
X1290 VSS.t2225 VDD VSS.t2224 VSS.t2223 sky130_fd_pr__nfet_01v8 ad=0.143 pd=1.62 as=0 ps=0 w=0.55 l=4.73
X1291 VDD a_12684_16885# counter_value_o[2] VDD sky130_fd_pr__pfet_01v8_hvt ad=0.149 pd=1.325 as=0.135 ps=1.27 w=1 l=0.15
X1292 VSS.t336 VDD VSS.t335 VSS.t334 sky130_fd_pr__nfet_01v8 ad=0.143 pd=1.62 as=0 ps=0 w=0.55 l=4.73
X1293 VDD VSS.t4199 VDD VDD sky130_fd_pr__pfet_01v8_hvt ad=0.2262 pd=2.26 as=0 ps=0 w=0.87 l=4.73
X1294 VDD VSS.t4177 VDD VDD sky130_fd_pr__pfet_01v8_hvt ad=0.2262 pd=2.26 as=0 ps=0 w=0.87 l=1.97
X1295 _67_.Y a_9523_16143# a_9761_16143# VSS.t17 sky130_fd_pr__nfet_01v8 ad=0.195 pd=1.9 as=0.08775 ps=0.92 w=0.65 l=0.15
X1296 a_20540_16617# a_20267_16733# _43_.A.t2 VDD sky130_fd_pr__pfet_01v8_hvt ad=0.14 pd=1.28 as=0.265 ps=2.53 w=1 l=0.15
X1297 VSS.t902 VDD VSS.t901 VSS.t900 sky130_fd_pr__nfet_01v8 ad=0.143 pd=1.62 as=0 ps=0 w=0.55 l=4.73
X1298 VSS.t2129 VDD VSS.t2128 VSS.t2127 sky130_fd_pr__nfet_01v8 ad=0.143 pd=1.62 as=0 ps=0 w=0.55 l=1.97
X1299 VSS.t1681 VDD VSS.t1680 VSS.t1679 sky130_fd_pr__nfet_01v8 ad=0.143 pd=1.62 as=0 ps=0 w=0.55 l=1.97
X1300 hold12.A _55_.Y a_26965_16367# VSS.t3387 sky130_fd_pr__nfet_01v8 ad=0.29575 pd=2.21 as=0.08937 ps=0.925 w=0.65 l=0.15
X1301 VDD VSS.t3531 VDD VDD sky130_fd_pr__pfet_01v8_hvt ad=0.2262 pd=2.26 as=0 ps=0 w=0.87 l=4.73
X1302 VSS.t2189 VDD VSS.t2188 VSS.t2187 sky130_fd_pr__nfet_01v8 ad=0.143 pd=1.62 as=0 ps=0 w=0.55 l=4.73
X1303 VSS.t1523 VDD VSS.t1522 VSS.t1521 sky130_fd_pr__nfet_01v8 ad=0.143 pd=1.62 as=0 ps=0 w=0.55 l=4.73
X1304 clkbuf_0_clock_i.X a_16762_15823.t35 VSS.t165 VSS.t164 sky130_fd_pr__nfet_01v8 ad=0.0588 pd=0.7 as=0.0588 ps=0.7 w=0.42 l=0.15
X1305 VDD VSS.t3961 VDD VDD sky130_fd_pr__pfet_01v8_hvt ad=0.2262 pd=2.26 as=0 ps=0 w=0.87 l=4.73
X1306 VSS.t2475 VDD VSS.t2474 VSS.t2473 sky130_fd_pr__nfet_01v8 ad=0.143 pd=1.62 as=0 ps=0 w=0.55 l=4.73
X1307 _75_.CLK a_11413_16341.t17 VSS.t220 VSS.t219 sky130_fd_pr__nfet_01v8 ad=0.0588 pd=0.7 as=0.0588 ps=0.7 w=0.42 l=0.15
X1308 VDD VSS.t3762 VDD VDD sky130_fd_pr__pfet_01v8_hvt ad=0.2262 pd=2.26 as=0 ps=0 w=0.87 l=1.97
X1309 a_11413_16341.t0 clkbuf_0_clock_i.X VSS.t116 VSS.t3301 sky130_fd_pr__nfet_01v8 ad=0.0588 pd=0.7 as=0.0588 ps=0.7 w=0.42 l=0.15
X1310 VDD VSS.t545 VDD VDD sky130_fd_pr__pfet_01v8_hvt ad=0.2262 pd=2.26 as=0 ps=0 w=0.87 l=0.59
X1311 VDD VSS.t3921 VDD VDD sky130_fd_pr__pfet_01v8_hvt ad=0.2262 pd=2.26 as=0 ps=0 w=0.87 l=4.73
X1312 VDD VSS.t3619 VDD VDD sky130_fd_pr__pfet_01v8_hvt ad=0.2262 pd=2.26 as=0 ps=0 w=0.87 l=4.73
X1313 VSS.t2234 VDD VSS.t2233 VSS.t2232 sky130_fd_pr__nfet_01v8 ad=0.143 pd=1.62 as=0 ps=0 w=0.55 l=4.73
X1314 VDD VSS.t3848 VDD VDD sky130_fd_pr__pfet_01v8_hvt ad=0.2262 pd=2.26 as=0 ps=0 w=0.87 l=1.97
X1315 VSS.t770 VDD VSS.t769 VSS.t768 sky130_fd_pr__nfet_01v8 ad=0.143 pd=1.62 as=0 ps=0 w=0.55 l=4.73
X1316 VDD VSS.t3547 VDD VDD sky130_fd_pr__pfet_01v8_hvt ad=0.2262 pd=2.26 as=0 ps=0 w=0.87 l=1.97
X1317 VSS.t3016 VDD VSS.t3015 VSS.t3014 sky130_fd_pr__nfet_01v8 ad=0.143 pd=1.62 as=0 ps=0 w=0.55 l=1.05
X1318 VDD VSS.t4132 VDD VDD sky130_fd_pr__pfet_01v8_hvt ad=0.2262 pd=2.26 as=0 ps=0 w=0.87 l=4.73
X1319 a_25309_16617# _36_.B.t17 a_25225_16617# VDD sky130_fd_pr__pfet_01v8_hvt ad=0.135 pd=1.27 as=0.135 ps=1.27 w=1 l=0.15
X1320 VSS.t2251 VDD VSS.t2250 VSS.t2249 sky130_fd_pr__nfet_01v8 ad=0.143 pd=1.62 as=0 ps=0 w=0.55 l=4.73
X1321 VDD VSS.t3809 VDD VDD sky130_fd_pr__pfet_01v8_hvt ad=0.2262 pd=2.26 as=0 ps=0 w=0.87 l=4.73
X1322 VSS.t1720 VDD VSS.t1719 VSS.t1718 sky130_fd_pr__nfet_01v8 ad=0.143 pd=1.62 as=0 ps=0 w=0.55 l=4.73
X1323 VSS.t1129 VDD VSS.t1128 VSS.t1127 sky130_fd_pr__nfet_01v8 ad=0.143 pd=1.62 as=0 ps=0 w=0.55 l=4.73
X1324 VDD VSS.t3594 VDD VDD sky130_fd_pr__pfet_01v8_hvt ad=0.2262 pd=2.26 as=0 ps=0 w=0.87 l=4.73
X1325 VSS.t2971 VDD VSS.t2970 VSS.t2969 sky130_fd_pr__nfet_01v8 ad=0.143 pd=1.62 as=0 ps=0 w=0.55 l=4.73
X1326 VDD VSS.t3802 VDD VDD sky130_fd_pr__pfet_01v8_hvt ad=0.2262 pd=2.26 as=0 ps=0 w=0.87 l=4.73
X1327 VSS.t2440 VDD VSS.t2439 VSS.t2438 sky130_fd_pr__nfet_01v8 ad=0.143 pd=1.62 as=0 ps=0 w=0.55 l=4.73
X1328 _54_.Y input2.X.t18 VDD VDD sky130_fd_pr__pfet_01v8_hvt ad=0.135 pd=1.27 as=0.26 ps=2.52 w=1 l=0.15
X1329 VDD VSS.t3580 VDD VDD sky130_fd_pr__pfet_01v8_hvt ad=0.2262 pd=2.26 as=0 ps=0 w=0.87 l=4.73
X1330 VDD VSS.t3774 VDD VDD sky130_fd_pr__pfet_01v8_hvt ad=0.2262 pd=2.26 as=0 ps=0 w=0.87 l=4.73
X1331 VDD VSS.t4107 VDD VDD sky130_fd_pr__pfet_01v8_hvt ad=0.2262 pd=2.26 as=0 ps=0 w=0.87 l=1.97
X1332 VSS.t2864 VDD VSS.t2863 VSS.t2862 sky130_fd_pr__nfet_01v8 ad=0.143 pd=1.62 as=0 ps=0 w=0.55 l=4.73
X1333 VDD VSS.t4361 VDD VDD sky130_fd_pr__pfet_01v8_hvt ad=0.2262 pd=2.26 as=0 ps=0 w=0.87 l=4.73
X1334 VDD a_18723_16635# a_18639_16733# VDD sky130_fd_pr__pfet_01v8_hvt ad=0.1113 pd=1.37 as=0.0882 ps=0.84 w=0.42 l=0.15
X1335 VDD VSS.t4242 VDD VDD sky130_fd_pr__pfet_01v8_hvt ad=0.2262 pd=2.26 as=0 ps=0 w=0.87 l=1.97
X1336 VSS.t1899 VDD VSS.t1898 VSS.t1897 sky130_fd_pr__nfet_01v8 ad=0.143 pd=1.62 as=0 ps=0 w=0.55 l=1.97
X1337 VDD VSS.t4204 VDD VDD sky130_fd_pr__pfet_01v8_hvt ad=0.2262 pd=2.26 as=0 ps=0 w=0.87 l=4.73
X1338 counter_value_o[3] a_17652_16885# VDD VDD sky130_fd_pr__pfet_01v8_hvt ad=0.135 pd=1.27 as=0.265 ps=2.53 w=1 l=0.15
X1339 VDD VSS.t4018 VDD VDD sky130_fd_pr__pfet_01v8_hvt ad=0.2262 pd=2.26 as=0 ps=0 w=0.87 l=4.73
X1340 VDD VSS.t4259 VDD VDD sky130_fd_pr__pfet_01v8_hvt ad=0.2262 pd=2.26 as=0 ps=0 w=0.87 l=4.73
X1341 VSS.t2404 VDD VSS.t2403 VSS.t2402 sky130_fd_pr__nfet_01v8 ad=0.143 pd=1.62 as=0 ps=0 w=0.55 l=4.73
X1342 VDD VSS.t3786 VDD VDD sky130_fd_pr__pfet_01v8_hvt ad=0.2262 pd=2.26 as=0 ps=0 w=0.87 l=4.73
X1343 _45_.Y _70_.Q a_22480_17277# VSS.t3434 sky130_fd_pr__nfet_01v8 ad=0.1113 pd=1.37 as=0.0588 ps=0.7 w=0.42 l=0.15
X1344 VSS.t400 VDD VSS.t399 VSS.t398 sky130_fd_pr__nfet_01v8 ad=0.143 pd=1.62 as=0 ps=0 w=0.55 l=4.73
X1345 VDD VSS.t4333 VDD VDD sky130_fd_pr__pfet_01v8_hvt ad=0.2262 pd=2.26 as=0 ps=0 w=0.87 l=4.73
X1346 VDD VSS.t3544 VDD VDD sky130_fd_pr__pfet_01v8_hvt ad=0.2262 pd=2.26 as=0 ps=0 w=0.87 l=4.73
X1347 VDD VSS.t3996 VDD VDD sky130_fd_pr__pfet_01v8_hvt ad=0.2262 pd=2.26 as=0 ps=0 w=0.87 l=4.73
X1348 VSS.t2126 VDD VSS.t2125 VSS.t2124 sky130_fd_pr__nfet_01v8 ad=0.143 pd=1.62 as=0 ps=0 w=0.55 l=4.73
X1349 _67_.B output3.A.t11 VDD VDD sky130_fd_pr__pfet_01v8_hvt ad=0.135 pd=1.27 as=0.26 ps=2.52 w=1 l=0.15
X1350 VDD VSS.t3806 VDD VDD sky130_fd_pr__pfet_01v8_hvt ad=0.2262 pd=2.26 as=0 ps=0 w=0.87 l=4.73
X1351 a_21914_15823.t0 clkbuf_0_clock_i.X VSS.t3300 VSS.t3299 sky130_fd_pr__nfet_01v8 ad=0.0588 pd=0.7 as=0.1113 ps=1.37 w=0.42 l=0.15
X1352 VSS.t1284 VDD VSS.t1283 VSS.t1282 sky130_fd_pr__nfet_01v8 ad=0.143 pd=1.62 as=0 ps=0 w=0.55 l=4.73
X1353 VSS.t2914 VDD VSS.t2913 VSS.t2912 sky130_fd_pr__nfet_01v8 ad=0.143 pd=1.62 as=0 ps=0 w=0.55 l=1.97
X1354 VSS.t390 VDD VSS.t389 VSS.t388 sky130_fd_pr__nfet_01v8 ad=0.143 pd=1.62 as=0 ps=0 w=0.55 l=0.59
X1355 a_27425_15645# a_26891_15279# a_27330_15645# VDD sky130_fd_pr__pfet_01v8_hvt ad=0.07665 pd=0.785 as=0.06825 ps=0.745 w=0.42 l=0.15
X1356 VSS.t2449 VDD VSS.t2448 VSS.t2447 sky130_fd_pr__nfet_01v8 ad=0.143 pd=1.62 as=0 ps=0 w=0.55 l=4.73
X1357 VSS.t1170 VDD VSS.t1170 VSS.t1169 sky130_fd_pr__nfet_01v8 ad=0.143 pd=1.62 as=0 ps=0 w=0.55 l=0.59
X1358 VDD VSS.t3771 VDD VDD sky130_fd_pr__pfet_01v8_hvt ad=0.2262 pd=2.26 as=0 ps=0 w=0.87 l=4.73
X1359 VSS.t608 VDD VSS.t607 VSS.t606 sky130_fd_pr__nfet_01v8 ad=0.143 pd=1.62 as=0 ps=0 w=0.55 l=2.89
X1360 VDD VSS.t3464 VDD VDD sky130_fd_pr__pfet_01v8_hvt ad=0.2262 pd=2.26 as=0 ps=0 w=0.87 l=4.73
X1361 VSS.t2670 VDD VSS.t2669 VSS.t2668 sky130_fd_pr__nfet_01v8 ad=0.143 pd=1.62 as=0 ps=0 w=0.55 l=4.73
X1362 VSS.t1397 VDD VSS.t1396 VSS.t1395 sky130_fd_pr__nfet_01v8 ad=0.143 pd=1.62 as=0 ps=0 w=0.55 l=4.73
X1363 VDD VSS.t4062 VDD VDD sky130_fd_pr__pfet_01v8_hvt ad=0.2262 pd=2.26 as=0 ps=0 w=0.87 l=4.73
X1364 VSS.t1463 VDD VSS.t1462 VSS.t1461 sky130_fd_pr__nfet_01v8 ad=0.143 pd=1.62 as=0 ps=0 w=0.55 l=4.73
X1365 VDD VSS.t3739 VDD VDD sky130_fd_pr__pfet_01v8_hvt ad=0.2262 pd=2.26 as=0 ps=0 w=0.87 l=4.73
X1366 VDD VSS.t4130 VDD VDD sky130_fd_pr__pfet_01v8_hvt ad=0.2262 pd=2.26 as=0 ps=0 w=0.87 l=4.73
X1367 VDD VSS.t3732 VDD VDD sky130_fd_pr__pfet_01v8_hvt ad=0.2262 pd=2.26 as=0 ps=0 w=0.87 l=4.73
X1368 VSS.t2281 VDD VSS.t2280 VSS.t2279 sky130_fd_pr__nfet_01v8 ad=0.143 pd=1.62 as=0 ps=0 w=0.55 l=4.73
X1369 VDD VSS.t3944 VDD VDD sky130_fd_pr__pfet_01v8_hvt ad=0.2262 pd=2.26 as=0 ps=0 w=0.87 l=4.73
X1370 VDD VSS.t3521 VDD VDD sky130_fd_pr__pfet_01v8_hvt ad=0.2262 pd=2.26 as=0 ps=0 w=0.87 l=4.73
X1371 VDD VSS.t2463 VDD VDD sky130_fd_pr__pfet_01v8_hvt ad=0.2262 pd=2.26 as=0 ps=0 w=0.87 l=0.59
X1372 VDD VSS.t3704 VDD VDD sky130_fd_pr__pfet_01v8_hvt ad=0.2262 pd=2.26 as=0 ps=0 w=0.87 l=4.73
X1373 VSS.t2272 VDD VSS.t2271 VSS.t2270 sky130_fd_pr__nfet_01v8 ad=0.143 pd=1.62 as=0 ps=0 w=0.55 l=4.73
X1374 VDD VSS.t3493 VDD VDD sky130_fd_pr__pfet_01v8_hvt ad=0.2262 pd=2.26 as=0 ps=0 w=0.87 l=1.97
X1375 VSS.t944 VDD VSS.t943 VSS.t942 sky130_fd_pr__nfet_01v8 ad=0.143 pd=1.62 as=0 ps=0 w=0.55 l=4.73
X1376 VSS.t3094 VDD VSS.t3093 VSS.t3092 sky130_fd_pr__nfet_01v8 ad=0.143 pd=1.62 as=0 ps=0 w=0.55 l=4.73
X1377 VDD VSS.t4045 VDD VDD sky130_fd_pr__pfet_01v8_hvt ad=0.2262 pd=2.26 as=0 ps=0 w=0.87 l=4.73
X1378 VSS.t694 VDD VSS.t693 VSS.t692 sky130_fd_pr__nfet_01v8 ad=0.143 pd=1.62 as=0 ps=0 w=0.55 l=2.89
X1379 a_28349_16367# hold12.X VDD VDD sky130_fd_pr__pfet_01v8_hvt ad=0.05775 pd=0.695 as=0.1092 ps=1.36 w=0.42 l=0.15
X1380 VSS.t997 VDD VSS.t996 VSS.t995 sky130_fd_pr__nfet_01v8 ad=0.143 pd=1.62 as=0 ps=0 w=0.55 l=4.73
X1381 VDD VSS.t3716 VDD VDD sky130_fd_pr__pfet_01v8_hvt ad=0.2262 pd=2.26 as=0 ps=0 w=0.87 l=4.73
X1382 VDD VSS.t4264 VDD VDD sky130_fd_pr__pfet_01v8_hvt ad=0.2262 pd=2.26 as=0 ps=0 w=0.87 l=4.73
X1383 VDD a_27498_15391# a_27425_15645# VDD sky130_fd_pr__pfet_01v8_hvt ad=0.17887 pd=1.26 as=0.07665 ps=0.785 w=0.42 l=0.15
X1384 VDD VSS.t3736 VDD VDD sky130_fd_pr__pfet_01v8_hvt ad=0.2262 pd=2.26 as=0 ps=0 w=0.87 l=4.73
X1385 VDD VSS.t638 VDD VDD sky130_fd_pr__pfet_01v8_hvt ad=0.2262 pd=2.26 as=0 ps=0 w=0.87 l=0.59
X1386 VSS.t1627 VDD VSS.t1626 VSS.t1625 sky130_fd_pr__nfet_01v8 ad=0.143 pd=1.62 as=0 ps=0 w=0.55 l=4.73
X1387 VSS.t2036 VDD VSS.t2035 VSS.t2034 sky130_fd_pr__nfet_01v8 ad=0.143 pd=1.62 as=0 ps=0 w=0.55 l=4.73
X1388 VSS.t1792 VDD VSS.t1791 VSS.t1790 sky130_fd_pr__nfet_01v8 ad=0.143 pd=1.62 as=0 ps=0 w=0.55 l=4.73
X1389 VDD VSS.t3701 VDD VDD sky130_fd_pr__pfet_01v8_hvt ad=0.2262 pd=2.26 as=0 ps=0 w=0.87 l=4.73
X1390 VSS.t812 VDD VSS.t811 VSS.t810 sky130_fd_pr__nfet_01v8 ad=0.143 pd=1.62 as=0 ps=0 w=0.55 l=4.73
X1391 VSS.t2511 VDD VSS.t2510 VSS.t2509 sky130_fd_pr__nfet_01v8 ad=0.143 pd=1.62 as=0 ps=0 w=0.55 l=4.73
X1392 VDD a_1407_3311# input1.X.t3 VDD sky130_fd_pr__pfet_01v8_hvt ad=0.265 pd=2.53 as=0.135 ps=1.27 w=1 l=0.15
X1393 VDD VSS.t545 VDD VDD sky130_fd_pr__pfet_01v8_hvt ad=0.2262 pd=2.26 as=0 ps=0 w=0.87 l=0.59
X1394 VSS.t3166 VDD VSS.t3165 VSS.t3164 sky130_fd_pr__nfet_01v8 ad=0.143 pd=1.62 as=0 ps=0 w=0.55 l=4.73
X1395 VSS.t1702 VDD VSS.t1701 VSS.t1700 sky130_fd_pr__nfet_01v8 ad=0.143 pd=1.62 as=0 ps=0 w=0.55 l=4.73
X1396 VSS.t1403 VDD VSS.t1402 VSS.t1401 sky130_fd_pr__nfet_01v8 ad=0.143 pd=1.62 as=0 ps=0 w=0.55 l=4.73
X1397 VDD VSS.t4060 VDD VDD sky130_fd_pr__pfet_01v8_hvt ad=0.2262 pd=2.26 as=0 ps=0 w=0.87 l=4.73
X1398 VSS.t462 VDD VSS.t461 VSS.t460 sky130_fd_pr__nfet_01v8 ad=0.143 pd=1.62 as=0 ps=0 w=0.55 l=4.73
X1399 VSS.t2983 VDD VSS.t2982 VSS.t2981 sky130_fd_pr__nfet_01v8 ad=0.143 pd=1.62 as=0 ps=0 w=0.55 l=4.73
X1400 VDD VSS.t3686 VDD VDD sky130_fd_pr__pfet_01v8_hvt ad=0.2262 pd=2.26 as=0 ps=0 w=0.87 l=4.73
X1401 VDD VSS.t4310 VDD VDD sky130_fd_pr__pfet_01v8_hvt ad=0.2262 pd=2.26 as=0 ps=0 w=0.87 l=4.73
X1402 VSS.t2738 VDD VSS.t2737 VSS.t2736 sky130_fd_pr__nfet_01v8 ad=0.143 pd=1.62 as=0 ps=0 w=0.55 l=4.73
X1403 VSS.t3112 VDD VSS.t3111 VSS.t3110 sky130_fd_pr__nfet_01v8 ad=0.143 pd=1.62 as=0 ps=0 w=0.55 l=0.59
X1404 VDD VSS.t4190 VDD VDD sky130_fd_pr__pfet_01v8_hvt ad=0.2262 pd=2.26 as=0 ps=0 w=0.87 l=4.73
X1405 VDD VSS.t4168 VDD VDD sky130_fd_pr__pfet_01v8_hvt ad=0.2262 pd=2.26 as=0 ps=0 w=0.87 l=4.73
X1406 _77_.CLK a_21914_15823.t20 VDD VDD sky130_fd_pr__pfet_01v8_hvt ad=0.14 pd=1.28 as=0.14 ps=1.28 w=1 l=0.15
X1407 VDD VSS.t4284 VDD VDD sky130_fd_pr__pfet_01v8_hvt ad=0.2262 pd=2.26 as=0 ps=0 w=0.87 l=4.73
X1408 VSS.t1439 VDD VSS.t1438 VSS.t1437 sky130_fd_pr__nfet_01v8 ad=0.143 pd=1.62 as=0 ps=0 w=0.55 l=4.73
X1409 VDD VSS.t4334 VDD VDD sky130_fd_pr__pfet_01v8_hvt ad=0.2262 pd=2.26 as=0 ps=0 w=0.87 l=4.73
X1410 VSS.t982 VDD VSS.t981 VSS.t980 sky130_fd_pr__nfet_01v8 ad=0.143 pd=1.62 as=0 ps=0 w=0.55 l=4.73
X1411 VSS.t1391 VDD VSS.t1390 VSS.t1389 sky130_fd_pr__nfet_01v8 ad=0.143 pd=1.62 as=0 ps=0 w=0.55 l=4.73
X1412 a_28602_16479# a_28434_16733# VSS.t12 VSS.t3388 sky130_fd_pr__nfet_01v8 ad=0.0989 pd=0.995 as=0.12095 ps=1.085 w=0.64 l=0.15
X1413 VDD VSS.t4316 VDD VDD sky130_fd_pr__pfet_01v8_hvt ad=0.2262 pd=2.26 as=0 ps=0 w=0.87 l=1.97
X1414 VSS.t1326 VDD VSS.t1325 VSS.t1324 sky130_fd_pr__nfet_01v8 ad=0.143 pd=1.62 as=0 ps=0 w=0.55 l=4.73
X1415 VSS.t1251 VDD VSS.t1250 VSS.t1249 sky130_fd_pr__nfet_01v8 ad=0.143 pd=1.62 as=0 ps=0 w=0.55 l=1.97
X1416 clkbuf_0_clock_i.X a_16762_15823.t11 VDD VDD sky130_fd_pr__pfet_01v8_hvt ad=0.14 pd=1.28 as=0.14 ps=1.28 w=1 l=0.15
X1417 VSS.t2822 VDD VSS.t2821 VSS.t2820 sky130_fd_pr__nfet_01v8 ad=0.143 pd=1.62 as=0 ps=0 w=0.55 l=4.73
X1418 VSS.t1845 VDD VSS.t1844 VSS.t1843 sky130_fd_pr__nfet_01v8 ad=0.143 pd=1.62 as=0 ps=0 w=0.55 l=4.73
X1419 VDD VSS.t4376 VDD VDD sky130_fd_pr__pfet_01v8_hvt ad=0.2262 pd=2.26 as=0 ps=0 w=0.87 l=1.05
X1420 a_21170_15645# a_20923_15279# VDD VDD sky130_fd_pr__pfet_01v8_hvt ad=0.07665 pd=0.785 as=0.17887 ps=1.26 w=0.42 l=0.15
X1421 VSS.t2992 VDD VSS.t2991 VSS.t2990 sky130_fd_pr__nfet_01v8 ad=0.143 pd=1.62 as=0 ps=0 w=0.55 l=4.73
X1422 VSS.t1278 VDD VSS.t1278 VSS.t1273 sky130_fd_pr__nfet_01v8 ad=0.143 pd=1.62 as=0 ps=0 w=0.55 l=0.59
X1423 a_26965_16367# _57_.Y VSS.t104 VSS.t105 sky130_fd_pr__nfet_01v8 ad=0.08775 pd=0.92 as=0.08775 ps=0.92 w=0.65 l=0.15
X1424 VSS.t209 a_21914_15823.t23 _77_.CLK VSS.t208 sky130_fd_pr__nfet_01v8 ad=0.1113 pd=1.37 as=0.0588 ps=0.7 w=0.42 l=0.15
X1425 VSS.t67 _53_.A.t3 a_26339_15279# VSS.t3363 sky130_fd_pr__nfet_01v8 ad=0.08775 pd=0.92 as=0.169 ps=1.82 w=0.65 l=0.15
X1426 VSS.t732 VDD VSS.t731 VSS.t730 sky130_fd_pr__nfet_01v8 ad=0.143 pd=1.62 as=0 ps=0 w=0.55 l=4.73
X1427 VDD VSS.t3497 VDD VDD sky130_fd_pr__pfet_01v8_hvt ad=0.2262 pd=2.26 as=0 ps=0 w=0.87 l=4.73
X1428 VSS.t1920 VDD VSS.t1919 VSS.t1918 sky130_fd_pr__nfet_01v8 ad=0.143 pd=1.62 as=0 ps=0 w=0.55 l=4.73
X1429 VSS.t797 VDD VSS.t796 VSS.t795 sky130_fd_pr__nfet_01v8 ad=0.143 pd=1.62 as=0 ps=0 w=0.55 l=4.73
X1430 VSS.t890 VDD VSS.t889 VSS.t888 sky130_fd_pr__nfet_01v8 ad=0.143 pd=1.62 as=0 ps=0 w=0.55 l=1.97
X1431 VSS.t502 VDD VSS.t501 VSS.t500 sky130_fd_pr__nfet_01v8 ad=0.143 pd=1.62 as=0 ps=0 w=0.55 l=4.73
X1432 clkbuf_0_clock_i.X a_16762_15823.t37 VSS.t168 VSS.t167 sky130_fd_pr__nfet_01v8 ad=0.0588 pd=0.7 as=0.0588 ps=0.7 w=0.42 l=0.15
X1433 VDD VSS.t3647 VDD VDD sky130_fd_pr__pfet_01v8_hvt ad=0.2262 pd=2.26 as=0 ps=0 w=0.87 l=4.73
X1434 VSS.t1156 VDD VSS.t1155 VSS.t1154 sky130_fd_pr__nfet_01v8 ad=0.143 pd=1.62 as=0 ps=0 w=0.55 l=4.73
X1435 VSS.t866 VDD VSS.t865 VSS.t864 sky130_fd_pr__nfet_01v8 ad=0.143 pd=1.62 as=0 ps=0 w=0.55 l=4.73
X1436 VSS.t467 VDD VSS.t466 VSS.t463 sky130_fd_pr__nfet_01v8 ad=0.143 pd=1.62 as=0 ps=0 w=0.55 l=1.97
X1437 _75_.CLK a_11413_16341.t19 VSS.t151 VSS.t150 sky130_fd_pr__nfet_01v8 ad=0.0588 pd=0.7 as=0.0588 ps=0.7 w=0.42 l=0.15
X1438 VSS.t447 VDD VSS.t446 VSS.t445 sky130_fd_pr__nfet_01v8 ad=0.143 pd=1.62 as=0 ps=0 w=0.55 l=4.73
X1439 VDD VSS.t3575 VDD VDD sky130_fd_pr__pfet_01v8_hvt ad=0.2262 pd=2.26 as=0 ps=0 w=0.87 l=4.73
X1440 VSS.t3157 VDD VSS.t3156 VSS.t3155 sky130_fd_pr__nfet_01v8 ad=0.143 pd=1.62 as=0 ps=0 w=0.55 l=4.73
X1441 VSS.t1209 VDD VSS.t1208 VSS.t1207 sky130_fd_pr__nfet_01v8 ad=0.143 pd=1.62 as=0 ps=0 w=0.55 l=4.73
X1442 a_27245_15279# _53_.X VDD VDD sky130_fd_pr__pfet_01v8_hvt ad=0.05775 pd=0.695 as=0.1092 ps=1.36 w=0.42 l=0.15
X1443 VSS.t2171 VDD VSS.t2170 VSS.t2169 sky130_fd_pr__nfet_01v8 ad=0.143 pd=1.62 as=0 ps=0 w=0.55 l=4.73
X1444 VSS.t1980 VDD VSS.t1979 VSS.t1978 sky130_fd_pr__nfet_01v8 ad=0.143 pd=1.62 as=0 ps=0 w=0.55 l=4.73
X1445 VDD VSS.t4098 VDD VDD sky130_fd_pr__pfet_01v8_hvt ad=0.2262 pd=2.26 as=0 ps=0 w=0.87 l=4.73
X1446 VDD VSS.t3527 VDD VDD sky130_fd_pr__pfet_01v8_hvt ad=0.2262 pd=2.26 as=0 ps=0 w=0.87 l=1.97
X1447 VDD VSS.t4355 VDD VDD sky130_fd_pr__pfet_01v8_hvt ad=0.2262 pd=2.26 as=0 ps=0 w=0.87 l=2.89
X1448 VDD VSS.t751 VDD VDD sky130_fd_pr__pfet_01v8_hvt ad=0.2262 pd=2.26 as=0 ps=0 w=0.87 l=4.73
X1449 VDD VSS.t2463 VDD VDD sky130_fd_pr__pfet_01v8_hvt ad=0.2262 pd=2.26 as=0 ps=0 w=0.87 l=0.59
X1450 VDD VSS.t4233 VDD VDD sky130_fd_pr__pfet_01v8_hvt ad=0.2262 pd=2.26 as=0 ps=0 w=0.87 l=4.73
X1451 a_9761_16143# _67_.A.t4 VSS.t3269 VSS.t3268 sky130_fd_pr__nfet_01v8 ad=0.169 pd=1.82 as=0.08775 ps=0.92 w=0.65 l=0.15
X1452 VSS.t2075 VDD VSS.t2074 VSS.t2073 sky130_fd_pr__nfet_01v8 ad=0.143 pd=1.62 as=0 ps=0 w=0.55 l=4.73
X1453 _77_.CLK a_21914_15823.t32 VSS.t3411 VSS.t3410 sky130_fd_pr__nfet_01v8 ad=0.0588 pd=0.7 as=0.0588 ps=0.7 w=0.42 l=0.15
X1454 a_20994_15253# a_20787_15253.t6 a_21170_15645# VDD sky130_fd_pr__pfet_01v8_hvt ad=0.06825 pd=0.745 as=0.07665 ps=0.785 w=0.42 l=0.15
X1455 VDD VSS.t3677 VDD VDD sky130_fd_pr__pfet_01v8_hvt ad=0.2262 pd=2.26 as=0 ps=0 w=0.87 l=1.97
X1456 _44_.Y _77_.Q a_22469_15279# VSS.t8 sky130_fd_pr__nfet_01v8 ad=0.169 pd=1.82 as=0.08775 ps=0.92 w=0.65 l=0.15
X1457 VDD VSS.t3560 VDD VDD sky130_fd_pr__pfet_01v8_hvt ad=0.2262 pd=2.26 as=0 ps=0 w=0.87 l=4.73
X1458 VSS.t3028 VDD VSS.t3027 VSS.t3026 sky130_fd_pr__nfet_01v8 ad=0.143 pd=1.62 as=0 ps=0 w=0.55 l=4.73
X1459 VSS.t1191 VDD VSS.t1190 VSS.t1189 sky130_fd_pr__nfet_01v8 ad=0.143 pd=1.62 as=0 ps=0 w=0.55 l=1.97
X1460 VDD a_26339_15279# _53_.X VDD sky130_fd_pr__pfet_01v8_hvt ad=0.26 pd=2.52 as=0.135 ps=1.27 w=1 l=0.15
X1461 VSS.t3001 VDD VSS.t3001 VSS.t2996 sky130_fd_pr__nfet_01v8 ad=0.143 pd=1.62 as=0 ps=0 w=0.55 l=0.59
X1462 VSS.t1732 VDD VSS.t1731 VSS.t1730 sky130_fd_pr__nfet_01v8 ad=0.143 pd=1.62 as=0 ps=0 w=0.55 l=4.73
X1463 a_23583_16617# _36_.B.t18 a_23487_16617# VDD sky130_fd_pr__pfet_01v8_hvt ad=0.0441 pd=0.63 as=0.0693 ps=0.75 w=0.42 l=0.15
X1464 a_12092_16201# a_11693_15829# a_11966_15823# VSS.t33 sky130_fd_pr__special_nfet_01v8 ad=0.0696 pd=0.765 as=0.0621 ps=0.705 w=0.36 l=0.15
X1465 a_7001_16367# a_6835_16367# VDD VDD sky130_fd_pr__pfet_01v8_hvt ad=0.1664 pd=1.8 as=0.0864 ps=0.91 w=0.64 l=0.15
X1466 VSS.t1236 VDD VSS.t1235 VSS.t1234 sky130_fd_pr__nfet_01v8 ad=0.143 pd=1.62 as=0 ps=0 w=0.55 l=1.97
X1467 VDD VSS.t638 VDD VDD sky130_fd_pr__pfet_01v8_hvt ad=0.2262 pd=2.26 as=0 ps=0 w=0.87 l=0.59
X1468 a_23108_16367# _45_.Y _48_.A.t0 VSS.t249 sky130_fd_pr__nfet_01v8 ad=0.091 pd=0.93 as=0.143 ps=1.09 w=0.65 l=0.15
X1469 VSS.t629 VDD VSS.t628 VSS.t627 sky130_fd_pr__nfet_01v8 ad=0.143 pd=1.62 as=0 ps=0 w=0.55 l=4.73
X1470 VDD VSS.t4208 VDD VDD sky130_fd_pr__pfet_01v8_hvt ad=0.2262 pd=2.26 as=0 ps=0 w=0.87 l=1.97
X1471 VSS.t2210 VDD VSS.t2209 VSS.t2208 sky130_fd_pr__nfet_01v8 ad=0.143 pd=1.62 as=0 ps=0 w=0.55 l=4.73
X1472 VSS.t717 VDD VSS.t716 VSS.t715 sky130_fd_pr__nfet_01v8 ad=0.143 pd=1.62 as=0 ps=0 w=0.55 l=4.73
X1473 VSS.t1490 VDD VSS.t1489 VSS.t1488 sky130_fd_pr__nfet_01v8 ad=0.143 pd=1.62 as=0 ps=0 w=0.55 l=4.73
X1474 VSS.t63 _36_.B.t21 a_22480_17277# VSS.t62 sky130_fd_pr__nfet_01v8 ad=0.0588 pd=0.7 as=0.1113 ps=1.37 w=0.42 l=0.15
X1475 a_28253_15823# a_28017_15823# VDD VDD sky130_fd_pr__pfet_01v8_hvt ad=0.1092 pd=1.36 as=0.0567 ps=0.69 w=0.42 l=0.5
X1476 VSS.t875 VDD VSS.t874 VSS.t873 sky130_fd_pr__nfet_01v8 ad=0.143 pd=1.62 as=0 ps=0 w=0.55 l=1.97
X1477 VDD VSS.t4216 VDD VDD sky130_fd_pr__pfet_01v8_hvt ad=0.2262 pd=2.26 as=0 ps=0 w=0.87 l=4.73
X1478 VSS.t3046 VDD VSS.t3045 VSS.t3044 sky130_fd_pr__nfet_01v8 ad=0.143 pd=1.62 as=0 ps=0 w=0.55 l=1.97
X1479 VDD VSS.t4121 VDD VDD sky130_fd_pr__pfet_01v8_hvt ad=0.2262 pd=2.26 as=0 ps=0 w=0.87 l=4.73
X1480 VDD VSS.t514 VDD VDD sky130_fd_pr__pfet_01v8_hvt ad=0.2262 pd=2.26 as=0 ps=0 w=0.87 l=0.59
X1481 VSS.t1750 VDD VSS.t1749 VSS.t1748 sky130_fd_pr__nfet_01v8 ad=0.143 pd=1.62 as=0 ps=0 w=0.55 l=4.73
X1482 VSS.t2386 VDD VSS.t2385 VSS.t2384 sky130_fd_pr__nfet_01v8 ad=0.143 pd=1.62 as=0 ps=0 w=0.55 l=4.73
X1483 a_26965_16617# _54_.Y hold12.A VDD sky130_fd_pr__pfet_01v8_hvt ad=0.135 pd=1.27 as=0.26 ps=2.52 w=1 l=0.15
X1484 VDD VSS.t3602 VDD VDD sky130_fd_pr__pfet_01v8_hvt ad=0.2262 pd=2.26 as=0 ps=0 w=0.87 l=1.97
X1485 VDD VSS.t3488 VDD VDD sky130_fd_pr__pfet_01v8_hvt ad=0.2262 pd=2.26 as=0 ps=0 w=0.87 l=1.97
X1486 VDD VSS.t3792 VDD VDD sky130_fd_pr__pfet_01v8_hvt ad=0.2262 pd=2.26 as=0 ps=0 w=0.87 l=4.73
X1487 VDD VSS.t3854 VDD VDD sky130_fd_pr__pfet_01v8_hvt ad=0.2262 pd=2.26 as=0 ps=0 w=0.87 l=4.73
X1488 a_23282_15645# a_23009_15279# a_23197_15279# VDD sky130_fd_pr__pfet_01v8_hvt ad=0.06825 pd=0.745 as=0.05775 ps=0.695 w=0.42 l=0.15
X1489 a_9605_16143# _67_.B a_9523_16143# VSS.t50 sky130_fd_pr__nfet_01v8 ad=0.06825 pd=0.86 as=0.169 ps=1.82 w=0.65 l=0.15
X1490 VSS.t3108 VDD VSS.t3107 VSS.t2996 sky130_fd_pr__nfet_01v8 ad=0.143 pd=1.62 as=0 ps=0 w=0.55 l=4.73
X1491 VDD VSS.t2141 VDD VDD sky130_fd_pr__pfet_01v8_hvt ad=0.2262 pd=2.26 as=0 ps=0 w=0.87 l=0.59
X1492 a_7281_16143# _63_.A.t4 VSS.t129 VSS.t3264 sky130_fd_pr__nfet_01v8 ad=0.06825 pd=0.86 as=0.08775 ps=0.92 w=0.65 l=0.15
X1493 a_27498_15391# a_27330_15645# VSS.t3316 VSS.t3315 sky130_fd_pr__nfet_01v8 ad=0.0989 pd=0.995 as=0.12095 ps=1.085 w=0.64 l=0.15
X1494 VSS.t545 VDD VSS.t545 VSS.t544 sky130_fd_pr__nfet_01v8 ad=0.143 pd=1.62 as=0 ps=0 w=0.55 l=0.59
X1495 VDD VSS.t4253 VDD VDD sky130_fd_pr__pfet_01v8_hvt ad=0.2262 pd=2.26 as=0 ps=0 w=0.87 l=4.73
X1496 VSS.t1024 VDD VSS.t1023 VSS.t1022 sky130_fd_pr__nfet_01v8 ad=0.143 pd=1.62 as=0 ps=0 w=0.55 l=4.73
X1497 VSS.t1538 VDD VSS.t1537 VSS.t1536 sky130_fd_pr__nfet_01v8 ad=0.143 pd=1.62 as=0 ps=0 w=0.55 l=4.73
X1498 VSS.t2532 VDD VSS.t2531 VSS.t2530 sky130_fd_pr__nfet_01v8 ad=0.143 pd=1.62 as=0 ps=0 w=0.55 l=4.73
X1499 VDD VSS.t3528 VDD VDD sky130_fd_pr__pfet_01v8_hvt ad=0.2262 pd=2.26 as=0 ps=0 w=0.87 l=4.73
X1500 VDD VSS.t4322 VDD VDD sky130_fd_pr__pfet_01v8_hvt ad=0.2262 pd=2.26 as=0 ps=0 w=0.87 l=1.97
X1501 VSS.t2687 VDD VSS.t2686 VSS.t2685 sky130_fd_pr__nfet_01v8 ad=0.143 pd=1.62 as=0 ps=0 w=0.55 l=4.73
X1502 VDD VSS.t4007 VDD VDD sky130_fd_pr__pfet_01v8_hvt ad=0.2262 pd=2.26 as=0 ps=0 w=0.87 l=4.73
X1503 a_17652_16885# _36_.A.t10 VSS.t94 VSS.t110 sky130_fd_pr__nfet_01v8 ad=0.1092 pd=1.36 as=0.097 ps=0.975 w=0.42 l=0.15
X1504 a_23707_15645# a_23009_15279# a_23450_15391# VSS.t123 sky130_fd_pr__special_nfet_01v8 ad=0.0684 pd=0.74 as=0.0989 ps=0.995 w=0.36 l=0.15
X1505 VDD VSS.t3985 VDD VDD sky130_fd_pr__pfet_01v8_hvt ad=0.2262 pd=2.26 as=0 ps=0 w=0.87 l=4.73
X1506 VSS.t659 VDD VSS.t658 VSS.t657 sky130_fd_pr__nfet_01v8 ad=0.143 pd=1.62 as=0 ps=0 w=0.55 l=4.73
X1507 VDD VSS.t3693 VDD VDD sky130_fd_pr__pfet_01v8_hvt ad=0.2262 pd=2.26 as=0 ps=0 w=0.87 l=4.73
X1508 VDD VSS.t3517 VDD VDD sky130_fd_pr__pfet_01v8_hvt ad=0.2262 pd=2.26 as=0 ps=0 w=0.87 l=4.73
X1509 VDD VSS.t4241 VDD VDD sky130_fd_pr__pfet_01v8_hvt ad=0.2262 pd=2.26 as=0 ps=0 w=0.87 l=4.73
X1510 VDD VSS.t3814 VDD VDD sky130_fd_pr__pfet_01v8_hvt ad=0.2262 pd=2.26 as=0 ps=0 w=0.87 l=4.73
X1511 VSS.t1102 VDD VSS.t1101 VSS.t1100 sky130_fd_pr__nfet_01v8 ad=0.143 pd=1.62 as=0 ps=0 w=0.55 l=4.73
X1512 VSS.t839 VDD VSS.t838 VSS.t837 sky130_fd_pr__nfet_01v8 ad=0.143 pd=1.62 as=0 ps=0 w=0.55 l=4.73
X1513 VSS.t2425 VDD VSS.t2424 VSS.t2423 sky130_fd_pr__nfet_01v8 ad=0.143 pd=1.62 as=0 ps=0 w=0.55 l=4.73
X1514 VSS.t416 VDD VSS.t415 VSS.t414 sky130_fd_pr__nfet_01v8 ad=0.143 pd=1.62 as=0 ps=0 w=0.55 l=4.73
X1515 VDD VSS.t3779 VDD VDD sky130_fd_pr__pfet_01v8_hvt ad=0.2262 pd=2.26 as=0 ps=0 w=0.87 l=4.73
X1516 a_27133_16367# a_26799_16367# VSS.t107 VSS.t3244 sky130_fd_pr__nfet_01v8 ad=0.08775 pd=0.92 as=0.08775 ps=0.92 w=0.65 l=0.15
X1517 _70_.Q a_23875_15547# VDD VDD sky130_fd_pr__pfet_01v8_hvt ad=0.26 pd=2.52 as=0.135 ps=1.27 w=1 l=0.15
X1518 VDD VSS.t4051 VDD VDD sky130_fd_pr__pfet_01v8_hvt ad=0.2262 pd=2.26 as=0 ps=0 w=0.87 l=4.73
X1519 VDD VSS.t4213 VDD VDD sky130_fd_pr__pfet_01v8_hvt ad=0.2262 pd=2.26 as=0 ps=0 w=0.87 l=1.97
X1520 VDD VSS.t3681 VDD VDD sky130_fd_pr__pfet_01v8_hvt ad=0.2262 pd=2.26 as=0 ps=0 w=0.87 l=4.73
X1521 VSS.t360 VDD VSS.t359 VSS.t358 sky130_fd_pr__nfet_01v8 ad=0.143 pd=1.62 as=0 ps=0 w=0.55 l=1.05
X1522 VDD VSS.t963 VDD VDD sky130_fd_pr__pfet_01v8_hvt ad=0.2262 pd=2.26 as=0 ps=0 w=0.87 l=4.73
X1523 VDD VSS.t3477 VDD VDD sky130_fd_pr__pfet_01v8_hvt ad=0.2262 pd=2.26 as=0 ps=0 w=0.87 l=4.73
X1524 VSS.t2570 VDD VSS.t2569 VSS.t2566 sky130_fd_pr__nfet_01v8 ad=0.143 pd=1.62 as=0 ps=0 w=0.55 l=1.97
X1525 VDD a_21914_15823.t13 _77_.CLK VDD sky130_fd_pr__pfet_01v8_hvt ad=0.14 pd=1.28 as=0.14 ps=1.28 w=1 l=0.15
X1526 VDD VSS.t3722 VDD VDD sky130_fd_pr__pfet_01v8_hvt ad=0.2262 pd=2.26 as=0 ps=0 w=0.87 l=4.73
X1527 VDD _77_.CLK a_26891_15279# VDD sky130_fd_pr__pfet_01v8_hvt ad=0.0864 pd=0.91 as=0.1664 ps=1.8 w=0.64 l=0.15
X1528 VSS.t2153 VDD VSS.t2152 VSS.t2151 sky130_fd_pr__nfet_01v8 ad=0.143 pd=1.62 as=0 ps=0 w=0.55 l=1.05
X1529 VDD VSS.t4159 VDD VDD sky130_fd_pr__pfet_01v8_hvt ad=0.2262 pd=2.26 as=0 ps=0 w=0.87 l=4.73
X1530 VDD VSS.t3511 VDD VDD sky130_fd_pr__pfet_01v8_hvt ad=0.2262 pd=2.26 as=0 ps=0 w=0.87 l=4.73
X1531 VDD VSS.t2356 VDD VDD sky130_fd_pr__pfet_01v8_hvt ad=0.2262 pd=2.26 as=0 ps=0 w=0.87 l=0.59
X1532 a_7189_16367# _74_.D.t3 VDD VDD sky130_fd_pr__pfet_01v8_hvt ad=0.05775 pd=0.695 as=0.1092 ps=1.36 w=0.42 l=0.15
X1533 VSS.t2684 VDD VSS.t2683 VSS.t2682 sky130_fd_pr__nfet_01v8 ad=0.143 pd=1.62 as=0 ps=0 w=0.55 l=4.73
X1534 _40_.A1 _36_.A.t7 VSS.t207 VSS.t206 sky130_fd_pr__nfet_01v8 ad=0.169 pd=1.82 as=0.169 ps=1.82 w=0.65 l=0.15
X1535 VSS.t2111 VDD VSS.t2110 VSS.t2109 sky130_fd_pr__nfet_01v8 ad=0.143 pd=1.62 as=0 ps=0 w=0.55 l=4.73
X1536 VSS.t2616 VDD VSS.t2615 VSS.t2614 sky130_fd_pr__nfet_01v8 ad=0.143 pd=1.62 as=0 ps=0 w=0.55 l=4.73
X1537 VSS.t2837 VDD VSS.t2836 VSS.t2835 sky130_fd_pr__nfet_01v8 ad=0.143 pd=1.62 as=0 ps=0 w=0.55 l=4.73
X1538 VDD VSS.t4297 VDD VDD sky130_fd_pr__pfet_01v8_hvt ad=0.2262 pd=2.26 as=0 ps=0 w=0.87 l=4.73
X1539 VDD VSS.t4034 VDD VDD sky130_fd_pr__pfet_01v8_hvt ad=0.2262 pd=2.26 as=0 ps=0 w=0.87 l=4.73
X1540 VDD VSS.t4281 VDD VDD sky130_fd_pr__pfet_01v8_hvt ad=0.2262 pd=2.26 as=0 ps=0 w=0.87 l=4.73
X1541 VSS.t2762 VDD VSS.t2761 VSS.t2760 sky130_fd_pr__nfet_01v8 ad=0.143 pd=1.62 as=0 ps=0 w=0.55 l=4.73
X1542 VSS.t2463 VDD VSS.t2463 VSS.t2462 sky130_fd_pr__nfet_01v8 ad=0.143 pd=1.62 as=0 ps=0 w=0.55 l=0.59
X1543 VDD VSS.t3744 VDD VDD sky130_fd_pr__pfet_01v8_hvt ad=0.2262 pd=2.26 as=0 ps=0 w=0.87 l=4.73
X1544 VDD VSS.t4139 VDD VDD sky130_fd_pr__pfet_01v8_hvt ad=0.2262 pd=2.26 as=0 ps=0 w=0.87 l=4.73
X1545 VDD a_28602_16479# a_28529_16733# VDD sky130_fd_pr__pfet_01v8_hvt ad=0.17887 pd=1.26 as=0.07665 ps=0.785 w=0.42 l=0.15
X1546 VDD VSS.t4357 VDD VDD sky130_fd_pr__pfet_01v8_hvt ad=0.2262 pd=2.26 as=0 ps=0 w=0.87 l=2.89
X1547 VDD VSS.t3709 VDD VDD sky130_fd_pr__pfet_01v8_hvt ad=0.2262 pd=2.26 as=0 ps=0 w=0.87 l=4.73
X1548 a_4193_16161# input2.X.t9 a_4107_16161# VSS.t179 sky130_fd_pr__nfet_01v8 ad=0.0567 pd=0.69 as=0.1176 ps=1.4 w=0.42 l=0.15
X1549 VSS.t2882 VDD VSS.t2881 VSS.t2880 sky130_fd_pr__nfet_01v8 ad=0.143 pd=1.62 as=0 ps=0 w=0.55 l=4.73
X1550 VSS.t2054 VDD VSS.t2053 VSS.t2052 sky130_fd_pr__nfet_01v8 ad=0.143 pd=1.62 as=0 ps=0 w=0.55 l=1.97
X1551 VSS.t397 VDD VSS.t397 VSS.t396 sky130_fd_pr__nfet_01v8 ad=0.143 pd=1.62 as=0 ps=0 w=0.55 l=0.59
X1552 a_16762_15823.t4 clock_i VDD VDD sky130_fd_pr__pfet_01v8_hvt ad=0.14 pd=1.28 as=0.14 ps=1.28 w=1 l=0.15
X1553 VDD _61_.X.t3 a_5609_16367# VDD sky130_fd_pr__pfet_01v8_hvt ad=0.1092 pd=1.36 as=0.05775 ps=0.695 w=0.42 l=0.15
X1554 VSS.t3380 a_3807_16617# _60_.B VSS.t3379 sky130_fd_pr__nfet_01v8 ad=0.208 pd=1.94 as=0.25025 ps=1.42 w=0.65 l=0.15
X1555 VSS.t140 a_11413_16341.t12 _75_.CLK VSS.t141 sky130_fd_pr__nfet_01v8 ad=0.0588 pd=0.7 as=0.0588 ps=0.7 w=0.42 l=0.15
X1556 VDD VSS.t3670 VDD VDD sky130_fd_pr__pfet_01v8_hvt ad=0.2262 pd=2.26 as=0 ps=0 w=0.87 l=4.73
X1557 VDD VSS.t1178 VDD VDD sky130_fd_pr__pfet_01v8_hvt ad=0.2262 pd=2.26 as=0 ps=0 w=0.87 l=4.73
X1558 clkbuf_0_clock_i.X a_16762_15823.t13 VDD VDD sky130_fd_pr__pfet_01v8_hvt ad=0.14 pd=1.28 as=0.1375 ps=1.275 w=1 l=0.15
X1559 VSS.t2493 VDD VSS.t2492 VSS.t2491 sky130_fd_pr__nfet_01v8 ad=0.143 pd=1.62 as=0 ps=0 w=0.55 l=4.73
X1560 a_7001_16367# a_6835_16367# VSS.t193 VSS.t3417 sky130_fd_pr__nfet_01v8 ad=0.1092 pd=1.36 as=0.0567 ps=0.69 w=0.42 l=0.15
X1561 VDD VSS.t4186 VDD VDD sky130_fd_pr__pfet_01v8_hvt ad=0.2262 pd=2.26 as=0 ps=0 w=0.87 l=4.73
X1562 VSS.t3175 VDD VSS.t3174 VSS.t3173 sky130_fd_pr__nfet_01v8 ad=0.143 pd=1.62 as=0 ps=0 w=0.55 l=4.73
X1563 VSS.t2368 VDD VSS.t2367 VSS.t2366 sky130_fd_pr__nfet_01v8 ad=0.143 pd=1.62 as=0 ps=0 w=0.55 l=1.05
X1564 VDD VSS.t3798 VDD VDD sky130_fd_pr__pfet_01v8_hvt ad=0.2262 pd=2.26 as=0 ps=0 w=0.87 l=1.05
X1565 VDD VSS.t4089 VDD VDD sky130_fd_pr__pfet_01v8_hvt ad=0.2262 pd=2.26 as=0 ps=0 w=0.87 l=4.73
X1566 VSS.t2714 VDD VSS.t2713 VSS.t2712 sky130_fd_pr__nfet_01v8 ad=0.143 pd=1.62 as=0 ps=0 w=0.55 l=1.97
X1567 VSS.t638 VDD VSS.t638 VSS.t633 sky130_fd_pr__nfet_01v8 ad=0.143 pd=1.62 as=0 ps=0 w=0.55 l=0.59
X1568 VDD VSS.t4157 VDD VDD sky130_fd_pr__pfet_01v8_hvt ad=0.2262 pd=2.26 as=0 ps=0 w=0.87 l=1.97
X1569 VSS.t3001 VDD VSS.t3001 VSS.t2996 sky130_fd_pr__nfet_01v8 ad=0.143 pd=1.62 as=0 ps=0 w=0.55 l=0.59
X1570 a_26965_16367# _55_.Y hold12.A VSS.t3386 sky130_fd_pr__nfet_01v8 ad=0.08937 pd=0.925 as=0.10075 ps=0.96 w=0.65 l=0.15
X1571 VSS.t211 a_21914_15823.t25 _77_.CLK VSS.t212 sky130_fd_pr__nfet_01v8 ad=0.0588 pd=0.7 as=0.0588 ps=0.7 w=0.42 l=0.15
X1572 VDD VSS.t4224 VDD VDD sky130_fd_pr__pfet_01v8_hvt ad=0.2262 pd=2.26 as=0 ps=0 w=0.87 l=4.73
X1573 VSS.t3190 VDD VSS.t3189 VSS.t3188 sky130_fd_pr__nfet_01v8 ad=0.143 pd=1.62 as=0 ps=0 w=0.55 l=0.59
X1574 a_23352_16519# _44_.Y a_23583_16617# VDD sky130_fd_pr__pfet_01v8_hvt ad=0.1092 pd=1.36 as=0.0441 ps=0.63 w=0.42 l=0.15
X1575 VDD VSS.t4341 VDD VDD sky130_fd_pr__pfet_01v8_hvt ad=0.2262 pd=2.26 as=0 ps=0 w=0.87 l=4.73
X1576 VSS.t2568 VDD VSS.t2567 VSS.t2566 sky130_fd_pr__nfet_01v8 ad=0.143 pd=1.62 as=0 ps=0 w=0.55 l=4.73
X1577 a_7442_16479# a_7274_16733# VSS.t3319 VSS.t3420 sky130_fd_pr__nfet_01v8 ad=0.0989 pd=0.995 as=0.12095 ps=1.085 w=0.64 l=0.15
X1578 a_8951_16367# _63_.A.t8 a_9369_16367# VSS.t237 sky130_fd_pr__nfet_01v8 ad=0.08775 pd=0.92 as=0.08775 ps=0.92 w=0.65 l=0.15
X1579 VDD VSS.t3620 VDD VDD sky130_fd_pr__pfet_01v8_hvt ad=0.2262 pd=2.26 as=0 ps=0 w=0.87 l=4.73
X1580 VSS.t514 VDD VSS.t514 VSS.t513 sky130_fd_pr__nfet_01v8 ad=0.143 pd=1.62 as=0 ps=0 w=0.55 l=0.59
X1581 VDD VSS.t4319 VDD VDD sky130_fd_pr__pfet_01v8_hvt ad=0.2262 pd=2.26 as=0 ps=0 w=0.87 l=4.73
X1582 VSS.t2231 VDD VSS.t2230 VSS.t2229 sky130_fd_pr__nfet_01v8 ad=0.143 pd=1.62 as=0 ps=0 w=0.55 l=4.73
X1583 _45_.Y _44_.Y a_22568_16911# VDD sky130_fd_pr__pfet_01v8_hvt ad=0.0896 pd=0.92 as=0.0768 ps=0.88 w=0.64 l=0.15
X1584 a_18045_16367# _38_.X VSS.t54 VSS.t53 sky130_fd_pr__nfet_01v8 ad=0.0813 pd=0.83 as=0.1092 ps=1.36 w=0.42 l=0.15
X1585 VSS.t1583 VDD VSS.t1582 VSS.t1581 sky130_fd_pr__nfet_01v8 ad=0.143 pd=1.62 as=0 ps=0 w=0.55 l=4.73
X1586 VSS.t1293 VDD VSS.t1292 VSS.t1291 sky130_fd_pr__nfet_01v8 ad=0.143 pd=1.62 as=0 ps=0 w=0.55 l=4.73
X1587 VSS.t3067 VDD VSS.t3066 VSS.t3065 sky130_fd_pr__nfet_01v8 ad=0.143 pd=1.62 as=0 ps=0 w=0.55 l=4.73
X1588 VSS.t1359 VDD VSS.t1358 VSS.t1357 sky130_fd_pr__nfet_01v8 ad=0.143 pd=1.62 as=0 ps=0 w=0.55 l=4.73
X1589 _75_.CLK a_11413_16341.t21 VSS.t154 VSS.t153 sky130_fd_pr__nfet_01v8 ad=0.0588 pd=0.7 as=0.0588 ps=0.7 w=0.42 l=0.15
X1590 VDD clock_i a_16762_15823.t5 VDD sky130_fd_pr__pfet_01v8_hvt ad=0.14 pd=1.28 as=0.14 ps=1.28 w=1 l=0.15
X1591 VDD VSS.t4069 VDD VDD sky130_fd_pr__pfet_01v8_hvt ad=0.2262 pd=2.26 as=0 ps=0 w=0.87 l=4.73
X1592 VSS.t1263 VDD VSS.t1262 VSS.t1261 sky130_fd_pr__nfet_01v8 ad=0.143 pd=1.62 as=0 ps=0 w=0.55 l=4.73
X1593 VSS.t1771 VDD VSS.t1770 VSS.t1769 sky130_fd_pr__nfet_01v8 ad=0.143 pd=1.62 as=0 ps=0 w=0.55 l=4.73
X1594 VSS.t1717 VDD VSS.t1716 VSS.t1715 sky130_fd_pr__nfet_01v8 ad=0.143 pd=1.62 as=0 ps=0 w=0.55 l=4.73
X1595 VDD VSS.t4039 VDD VDD sky130_fd_pr__pfet_01v8_hvt ad=0.2262 pd=2.26 as=0 ps=0 w=0.87 l=4.73
X1596 VSS.t243 a_2748_16885# counter_value_o[0] VSS.t242 sky130_fd_pr__nfet_01v8 ad=0.097 pd=0.975 as=0.08775 ps=0.92 w=0.65 l=0.15
X1597 VDD VSS.t3595 VDD VDD sky130_fd_pr__pfet_01v8_hvt ad=0.2262 pd=2.26 as=0 ps=0 w=0.87 l=4.73
X1598 VSS.t2968 VDD VSS.t2967 VSS.t2966 sky130_fd_pr__nfet_01v8 ad=0.143 pd=1.62 as=0 ps=0 w=0.55 l=4.73
X1599 VSS.t2723 VDD VSS.t2722 VSS.t2721 sky130_fd_pr__nfet_01v8 ad=0.143 pd=1.62 as=0 ps=0 w=0.55 l=4.73
X1600 VDD VSS.t3643 VDD VDD sky130_fd_pr__pfet_01v8_hvt ad=0.2262 pd=2.26 as=0 ps=0 w=0.87 l=1.97
X1601 VDD VSS.t4342 VDD VDD sky130_fd_pr__pfet_01v8_hvt ad=0.2262 pd=2.26 as=0 ps=0 w=0.87 l=1.05
X1602 VSS.t3269 _67_.A.t5 a_9605_16143# VSS.t3295 sky130_fd_pr__nfet_01v8 ad=0.08775 pd=0.92 as=0.06825 ps=0.86 w=0.65 l=0.15
X1603 _77_.CLK a_21914_15823.t34 VSS.t170 VSS.t169 sky130_fd_pr__nfet_01v8 ad=0.0588 pd=0.7 as=0.0588 ps=0.7 w=0.42 l=0.15
X1604 a_6883_16055# _63_.B a_7281_16143# VSS.t49 sky130_fd_pr__nfet_01v8 ad=0.169 pd=1.82 as=0.06825 ps=0.86 w=0.65 l=0.15
X1605 VSS.t540 VDD VSS.t539 VSS.t538 sky130_fd_pr__nfet_01v8 ad=0.143 pd=1.62 as=0 ps=0 w=0.55 l=1.97
X1606 a_22568_16911# _36_.B.t20 VDD VDD sky130_fd_pr__pfet_01v8_hvt ad=0.0768 pd=0.88 as=0.1696 ps=1.81 w=0.64 l=0.15
X1607 VSS.t3214 VDD VSS.t3213 VSS.t3212 sky130_fd_pr__nfet_01v8 ad=0.143 pd=1.62 as=0 ps=0 w=0.55 l=4.73
X1608 VDD VSS.t4116 VDD VDD sky130_fd_pr__pfet_01v8_hvt ad=0.2262 pd=2.26 as=0 ps=0 w=0.87 l=4.73
X1609 a_22469_15279# _36_.A.t2 VSS.t223 VSS.t222 sky130_fd_pr__nfet_01v8 ad=0.08775 pd=0.92 as=0.169 ps=1.82 w=0.65 l=0.15
X1610 VSS.t3353 a_20359_14735# _43_.X VSS.t3352 sky130_fd_pr__nfet_01v8 ad=0.169 pd=1.82 as=0.08775 ps=0.92 w=0.65 l=0.15
X1611 VDD VSS.t3728 VDD VDD sky130_fd_pr__pfet_01v8_hvt ad=0.2262 pd=2.26 as=0 ps=0 w=0.87 l=1.05
X1612 VDD VSS.t3909 VDD VDD sky130_fd_pr__pfet_01v8_hvt ad=0.2262 pd=2.26 as=0 ps=0 w=0.87 l=4.73
X1613 VDD VSS.t3545 VDD VDD sky130_fd_pr__pfet_01v8_hvt ad=0.2262 pd=2.26 as=0 ps=0 w=0.87 l=4.73
X1614 VDD VSS.t4087 VDD VDD sky130_fd_pr__pfet_01v8_hvt ad=0.2262 pd=2.26 as=0 ps=0 w=0.87 l=1.97
X1615 VDD _75_.CLK a_6835_16367# VDD sky130_fd_pr__pfet_01v8_hvt ad=0.0864 pd=0.91 as=0.1664 ps=1.8 w=0.64 l=0.15
X1616 VSS.t958 VDD VSS.t957 VSS.t956 sky130_fd_pr__nfet_01v8 ad=0.143 pd=1.62 as=0 ps=0 w=0.55 l=4.73
X1617 VSS.t2123 VDD VSS.t2122 VSS.t2121 sky130_fd_pr__nfet_01v8 ad=0.143 pd=1.62 as=0 ps=0 w=0.55 l=4.73
X1618 VSS.t2248 VDD VSS.t2248 VSS.t2247 sky130_fd_pr__nfet_01v8 ad=0.143 pd=1.62 as=0 ps=0 w=0.55 l=0.59
X1619 VDD VSS.t3889 VDD VDD sky130_fd_pr__pfet_01v8_hvt ad=0.2262 pd=2.26 as=0 ps=0 w=0.87 l=4.73
X1620 VDD VSS.t3640 VDD VDD sky130_fd_pr__pfet_01v8_hvt ad=0.2262 pd=2.26 as=0 ps=0 w=0.87 l=4.73
X1621 VSS.t2446 VDD VSS.t2445 VSS.t2444 sky130_fd_pr__nfet_01v8 ad=0.143 pd=1.62 as=0 ps=0 w=0.55 l=4.73
X1622 VDD VSS.t4008 VDD VDD sky130_fd_pr__pfet_01v8_hvt ad=0.2262 pd=2.26 as=0 ps=0 w=0.87 l=1.05
X1623 a_12684_16885# _67_.A.t14 VDD VDD sky130_fd_pr__pfet_01v8_hvt ad=0.1664 pd=1.8 as=0.149 ps=1.325 w=0.64 l=0.15
X1624 a_5609_16367# a_5055_16341.t3 a_5262_16341# VSS.t3262 sky130_fd_pr__special_nfet_01v8 ad=0.0813 pd=0.83 as=0.0621 ps=0.705 w=0.36 l=0.15
X1625 VDD VSS.t3772 VDD VDD sky130_fd_pr__pfet_01v8_hvt ad=0.2262 pd=2.26 as=0 ps=0 w=0.87 l=4.73
X1626 a_5191_16367# a_5062_16641# a_4771_16341# VSS.t31 sky130_fd_pr__special_nfet_01v8 ad=0.0989 pd=0.995 as=0.0684 ps=0.74 w=0.36 l=0.15
X1627 VSS.t791 VDD VSS.t790 VSS.t789 sky130_fd_pr__nfet_01v8 ad=0.143 pd=1.62 as=0 ps=0 w=0.55 l=1.97
X1628 VSS.t1176 VDD VSS.t1175 VSS.t1174 sky130_fd_pr__nfet_01v8 ad=0.143 pd=1.62 as=0 ps=0 w=0.55 l=4.73
X1629 VDD hold12.A a_28017_15823# VDD sky130_fd_pr__pfet_01v8_hvt ad=0.0567 pd=0.69 as=0.1092 ps=1.36 w=0.42 l=0.15
X1630 _43_.X a_20359_14735# VDD VDD sky130_fd_pr__pfet_01v8_hvt ad=0.135 pd=1.27 as=0.135 ps=1.27 w=1 l=0.15
X1631 VDD VSS.t3568 VDD VDD sky130_fd_pr__pfet_01v8_hvt ad=0.2262 pd=2.26 as=0 ps=0 w=0.87 l=1.97
X1632 VSS.t268 _77_.CLK a_26891_15279# VSS.t267 sky130_fd_pr__nfet_01v8 ad=0.0567 pd=0.69 as=0.1092 ps=1.36 w=0.42 l=0.15
X1633 a_20627_16189# _40_.A1 VSS.t20 VSS.t3248 sky130_fd_pr__nfet_01v8 ad=0.1113 pd=1.37 as=0.0588 ps=0.7 w=0.42 l=0.15
X1634 VDD VSS.t3522 VDD VDD sky130_fd_pr__pfet_01v8_hvt ad=0.2262 pd=2.26 as=0 ps=0 w=0.87 l=4.73
X1635 VSS.t129 _63_.A.t5 a_6925_16143# VSS.t128 sky130_fd_pr__nfet_01v8 ad=0.08775 pd=0.92 as=0.169 ps=1.82 w=0.65 l=0.15
X1636 VDD VSS.t3494 VDD VDD sky130_fd_pr__pfet_01v8_hvt ad=0.2262 pd=2.26 as=0 ps=0 w=0.87 l=4.73
X1637 VSS.t2132 VDD VSS.t2131 VSS.t2130 sky130_fd_pr__nfet_01v8 ad=0.143 pd=1.62 as=0 ps=0 w=0.55 l=4.73
X1638 VSS.t468 VDD VSS.t468 VSS.t463 sky130_fd_pr__nfet_01v8 ad=0.143 pd=1.62 as=0 ps=0 w=0.55 l=0.59
X1639 VSS.t668 VDD VSS.t667 VSS.t666 sky130_fd_pr__nfet_01v8 ad=0.143 pd=1.62 as=0 ps=0 w=0.55 l=4.73
X1640 VDD VSS.t4353 VDD VDD sky130_fd_pr__pfet_01v8_hvt ad=0.2262 pd=2.26 as=0 ps=0 w=0.87 l=4.73
X1641 VDD VSS.t3506 VDD VDD sky130_fd_pr__pfet_01v8_hvt ad=0.2262 pd=2.26 as=0 ps=0 w=0.87 l=4.73
X1642 VDD VSS.t3682 VDD VDD sky130_fd_pr__pfet_01v8_hvt ad=0.2262 pd=2.26 as=0 ps=0 w=0.87 l=1.97
X1643 VDD VSS.t4380 VDD VDD sky130_fd_pr__pfet_01v8_hvt ad=0.2262 pd=2.26 as=0 ps=0 w=0.87 l=4.73
X1644 VSS.t1529 VDD VSS.t1528 VSS.t1527 sky130_fd_pr__nfet_01v8 ad=0.143 pd=1.62 as=0 ps=0 w=0.55 l=4.73
X1645 _64_.X.t1 a_6407_16395# VDD VDD sky130_fd_pr__pfet_01v8_hvt ad=0.475 pd=2.95 as=0.16655 ps=1.39 w=1 l=0.15
X1646 a_22273_16367# _77_.Q a_22189_16367# VSS.t6 sky130_fd_pr__nfet_01v8 ad=0.10725 pd=0.98 as=0.08775 ps=0.92 w=0.65 l=0.15
X1647 VDD VSS.t4152 VDD VDD sky130_fd_pr__pfet_01v8_hvt ad=0.2262 pd=2.26 as=0 ps=0 w=0.87 l=4.73
X1648 VSS.t2287 VDD VSS.t2286 VSS.t2285 sky130_fd_pr__nfet_01v8 ad=0.143 pd=1.62 as=0 ps=0 w=0.55 l=4.73
X1649 counter_value_o[6] a_32503_16919# VDD VDD sky130_fd_pr__pfet_01v8_hvt ad=0.135 pd=1.27 as=0.149 ps=1.325 w=1 l=0.15
X1650 VSS.t413 VDD VSS.t412 VSS.t411 sky130_fd_pr__nfet_01v8 ad=0.143 pd=1.62 as=0 ps=0 w=0.55 l=4.73
X1651 a_5262_16341# a_5055_16341.t6 a_5438_16733# VDD sky130_fd_pr__pfet_01v8_hvt ad=0.06825 pd=0.745 as=0.07665 ps=0.785 w=0.42 l=0.15
X1652 VSS.t1789 VDD VSS.t1788 VSS.t1787 sky130_fd_pr__nfet_01v8 ad=0.143 pd=1.62 as=0 ps=0 w=0.55 l=4.73
X1653 VDD VSS.t3702 VDD VDD sky130_fd_pr__pfet_01v8_hvt ad=0.2262 pd=2.26 as=0 ps=0 w=0.87 l=4.73
X1654 a_21341_15279# a_20787_15253.t3 a_20994_15253# VSS.t3250 sky130_fd_pr__special_nfet_01v8 ad=0.0813 pd=0.83 as=0.0621 ps=0.705 w=0.36 l=0.15
X1655 VDD VSS.t3491 VDD VDD sky130_fd_pr__pfet_01v8_hvt ad=0.2262 pd=2.26 as=0 ps=0 w=0.87 l=4.73
X1656 VSS.t1953 VDD VSS.t1952 VSS.t1951 sky130_fd_pr__nfet_01v8 ad=0.143 pd=1.62 as=0 ps=0 w=0.55 l=1.97
X1657 VDD VSS.t3988 VDD VDD sky130_fd_pr__pfet_01v8_hvt ad=0.2262 pd=2.26 as=0 ps=0 w=0.87 l=1.97
X1658 VSS.t107 _57_.Y a_26965_16367# VSS.t106 sky130_fd_pr__nfet_01v8 ad=0.08775 pd=0.92 as=0.08775 ps=0.92 w=0.65 l=0.15
X1659 VDD VSS.t4332 VDD VDD sky130_fd_pr__pfet_01v8_hvt ad=0.2262 pd=2.26 as=0 ps=0 w=0.87 l=1.05
X1660 VSS.t1944 VDD VSS.t1943 VSS.t1942 sky130_fd_pr__nfet_01v8 ad=0.143 pd=1.62 as=0 ps=0 w=0.55 l=4.73
X1661 VDD VSS.t4025 VDD VDD sky130_fd_pr__pfet_01v8_hvt ad=0.2262 pd=2.26 as=0 ps=0 w=0.87 l=4.73
X1662 VDD VSS.t4290 VDD VDD sky130_fd_pr__pfet_01v8_hvt ad=0.2262 pd=2.26 as=0 ps=0 w=0.87 l=4.73
X1663 VDD VSS.t3659 VDD VDD sky130_fd_pr__pfet_01v8_hvt ad=0.2262 pd=2.26 as=0 ps=0 w=0.87 l=4.73
X1664 VSS.t2165 VDD VSS.t2164 VSS.t2163 sky130_fd_pr__nfet_01v8 ad=0.143 pd=1.62 as=0 ps=0 w=0.55 l=4.73
X1665 VSS.t477 VDD VSS.t476 VSS.t475 sky130_fd_pr__nfet_01v8 ad=0.143 pd=1.62 as=0 ps=0 w=0.55 l=4.73
X1666 counter_value_o[5] a_27535_16919# VSS.t3373 VSS.t3372 sky130_fd_pr__nfet_01v8 ad=0.08775 pd=0.92 as=0.097 ps=0.975 w=0.65 l=0.15
X1667 a_18069_15279# _36_.B.t7 a_17987_15279# VSS.t3341 sky130_fd_pr__nfet_01v8 ad=0.06825 pd=0.86 as=0.169 ps=1.82 w=0.65 l=0.15
X1668 VSS.t2141 VDD VSS.t2141 VSS.t2136 sky130_fd_pr__nfet_01v8 ad=0.143 pd=1.62 as=0 ps=0 w=0.55 l=0.59
X1669 VDD a_23875_15547# a_23791_15645# VDD sky130_fd_pr__pfet_01v8_hvt ad=0.1113 pd=1.37 as=0.0882 ps=0.84 w=0.42 l=0.15
X1670 VDD VSS.t3820 VDD VDD sky130_fd_pr__pfet_01v8_hvt ad=0.2262 pd=2.26 as=0 ps=0 w=0.87 l=4.73
X1671 VDD VSS.t4359 VDD VDD sky130_fd_pr__pfet_01v8_hvt ad=0.2262 pd=2.26 as=0 ps=0 w=0.87 l=0.59
X1672 VDD VSS.t344 VDD VDD sky130_fd_pr__pfet_01v8_hvt ad=0.2262 pd=2.26 as=0 ps=0 w=0.87 l=1.97
X1673 VDD VSS.t3533 VDD VDD sky130_fd_pr__pfet_01v8_hvt ad=0.2262 pd=2.26 as=0 ps=0 w=0.87 l=4.73
X1674 VSS.t1039 VDD VSS.t1038 VSS.t1037 sky130_fd_pr__nfet_01v8 ad=0.143 pd=1.62 as=0 ps=0 w=0.55 l=4.73
X1675 a_20868_16519# _77_.Q VSS.t3 VSS.t2 sky130_fd_pr__nfet_01v8 ad=0.0567 pd=0.69 as=0.10187 ps=0.99 w=0.42 l=0.15
X1676 VSS.t2628 VDD VSS.t2627 VSS.t2626 sky130_fd_pr__nfet_01v8 ad=0.143 pd=1.62 as=0 ps=0 w=0.55 l=1.97
X1677 VSS.t2183 VDD VSS.t2182 VSS.t2181 sky130_fd_pr__nfet_01v8 ad=0.143 pd=1.62 as=0 ps=0 w=0.55 l=1.97
X1678 VDD VSS.t4082 VDD VDD sky130_fd_pr__pfet_01v8_hvt ad=0.2262 pd=2.26 as=0 ps=0 w=0.87 l=4.73
X1679 VSS.t474 VDD VSS.t473 VSS.t472 sky130_fd_pr__nfet_01v8 ad=0.143 pd=1.62 as=0 ps=0 w=0.55 l=1.05
X1680 VSS.t3208 VDD VSS.t3207 VSS.t3206 sky130_fd_pr__nfet_01v8 ad=0.143 pd=1.62 as=0 ps=0 w=0.55 l=0.59
X1681 VDD _36_.Y a_18183_17249# VDD sky130_fd_pr__pfet_01v8_hvt ad=0.16655 pd=1.39 as=0.0567 ps=0.69 w=0.42 l=0.15
X1682 VSS.t431 VDD VSS.t430 VSS.t429 sky130_fd_pr__nfet_01v8 ad=0.143 pd=1.62 as=0 ps=0 w=0.55 l=0.59
X1683 VSS.t1290 VDD VSS.t1289 VSS.t1288 sky130_fd_pr__nfet_01v8 ad=0.143 pd=1.62 as=0 ps=0 w=0.55 l=1.05
X1684 VSS.t2245 VDD VSS.t2244 VSS.t2136 sky130_fd_pr__nfet_01v8 ad=0.143 pd=1.62 as=0 ps=0 w=0.55 l=4.73
X1685 a_16762_15823.t2 clock_i VDD VDD sky130_fd_pr__pfet_01v8_hvt ad=0.14 pd=1.28 as=0.265 ps=2.53 w=1 l=0.15
X1686 VDD VSS.t3863 VDD VDD sky130_fd_pr__pfet_01v8_hvt ad=0.2262 pd=2.26 as=0 ps=0 w=0.87 l=1.97
X1687 VSS.t143 a_11413_16341.t14 _75_.CLK VSS.t144 sky130_fd_pr__nfet_01v8 ad=0.0588 pd=0.7 as=0.0588 ps=0.7 w=0.42 l=0.15
X1688 VSS.t2774 VDD VSS.t2773 VSS.t2772 sky130_fd_pr__nfet_01v8 ad=0.143 pd=1.62 as=0 ps=0 w=0.55 l=1.97
X1689 VSS.t557 VDD VSS.t556 VSS.t555 sky130_fd_pr__nfet_01v8 ad=0.143 pd=1.62 as=0 ps=0 w=0.55 l=4.73
X1690 VSS.t1087 VDD VSS.t1086 VSS.t1085 sky130_fd_pr__nfet_01v8 ad=0.143 pd=1.62 as=0 ps=0 w=0.55 l=4.73
X1691 VDD a_7442_16479# a_7369_16733# VDD sky130_fd_pr__pfet_01v8_hvt ad=0.17887 pd=1.26 as=0.07665 ps=0.785 w=0.42 l=0.15
X1692 VDD VSS.t3866 VDD VDD sky130_fd_pr__pfet_01v8_hvt ad=0.2262 pd=2.26 as=0 ps=0 w=0.87 l=4.73
X1693 VDD VSS.t3993 VDD VDD sky130_fd_pr__pfet_01v8_hvt ad=0.2262 pd=2.26 as=0 ps=0 w=0.87 l=1.97
X1694 VSS.t193 _75_.CLK a_6835_16367# VSS.t192 sky130_fd_pr__nfet_01v8 ad=0.0567 pd=0.69 as=0.1092 ps=1.36 w=0.42 l=0.15
X1695 VSS.t2380 VDD VSS.t2379 VSS.t2378 sky130_fd_pr__nfet_01v8 ad=0.143 pd=1.62 as=0 ps=0 w=0.55 l=4.73
X1696 VSS.t2314 VDD VSS.t2313 VSS.t2312 sky130_fd_pr__nfet_01v8 ad=0.143 pd=1.62 as=0 ps=0 w=0.55 l=1.97
X1697 VDD VSS.t3794 VDD VDD sky130_fd_pr__pfet_01v8_hvt ad=0.2262 pd=2.26 as=0 ps=0 w=0.87 l=4.73
X1698 VSS.t173 a_21914_15823.t37 _77_.CLK VSS.t174 sky130_fd_pr__nfet_01v8 ad=0.0588 pd=0.7 as=0.0588 ps=0.7 w=0.42 l=0.15
X1699 VDD VSS.t4030 VDD VDD sky130_fd_pr__pfet_01v8_hvt ad=0.2262 pd=2.26 as=0 ps=0 w=0.87 l=4.73
X1700 VSS.t214 a_21914_15823.t27 _77_.CLK VSS.t215 sky130_fd_pr__nfet_01v8 ad=0.0588 pd=0.7 as=0.0588 ps=0.7 w=0.42 l=0.15
X1701 VDD VSS.t3552 VDD VDD sky130_fd_pr__pfet_01v8_hvt ad=0.2262 pd=2.26 as=0 ps=0 w=0.87 l=1.97
X1702 VSS.t2356 VDD VSS.t2356 VSS.t2351 sky130_fd_pr__nfet_01v8 ad=0.143 pd=1.62 as=0 ps=0 w=0.55 l=0.59
X1703 VDD VSS.t2141 VDD VDD sky130_fd_pr__pfet_01v8_hvt ad=0.2262 pd=2.26 as=0 ps=0 w=0.87 l=0.59
X1704 VSS.t2637 VDD VSS.t2636 VSS.t2635 sky130_fd_pr__nfet_01v8 ad=0.143 pd=1.62 as=0 ps=0 w=0.55 l=4.73
X1705 VDD VSS.t1826 VDD VDD sky130_fd_pr__pfet_01v8_hvt ad=0.2262 pd=2.26 as=0 ps=0 w=0.87 l=4.73
X1706 a_9369_16367# _63_.A.t9 a_8951_16367# VSS.t3297 sky130_fd_pr__nfet_01v8 ad=0.08775 pd=0.92 as=0.08775 ps=0.92 w=0.65 l=0.15
X1707 VDD VSS.t3750 VDD VDD sky130_fd_pr__pfet_01v8_hvt ad=0.2262 pd=2.26 as=0 ps=0 w=0.87 l=4.73
X1708 VSS.t2858 VDD VSS.t2857 VSS.t2856 sky130_fd_pr__nfet_01v8 ad=0.143 pd=1.62 as=0 ps=0 w=0.55 l=1.97
X1709 VSS.t76 a_16762_15823.t28 clkbuf_0_clock_i.X VSS.t77 sky130_fd_pr__nfet_01v8 ad=0.0588 pd=0.7 as=0.0588 ps=0.7 w=0.42 l=0.15
X1710 VDD VSS.t4354 VDD VDD sky130_fd_pr__pfet_01v8_hvt ad=0.2262 pd=2.26 as=0 ps=0 w=0.87 l=2.89
X1711 VSS.t1003 VDD VSS.t1002 VSS.t1001 sky130_fd_pr__nfet_01v8 ad=0.143 pd=1.62 as=0 ps=0 w=0.55 l=4.73
X1712 VDD VSS.t3678 VDD VDD sky130_fd_pr__pfet_01v8_hvt ad=0.2262 pd=2.26 as=0 ps=0 w=0.87 l=4.73
X1713 _36_.B _67_.A.t7 a_9727_16367# VSS.t3270 sky130_fd_pr__nfet_01v8 ad=0.08775 pd=0.92 as=0.08775 ps=0.92 w=0.65 l=0.15
X1714 VDD _40_.A1 a_20716_15823# VDD sky130_fd_pr__pfet_01v8_hvt ad=0.1696 pd=1.81 as=0.0768 ps=0.88 w=0.64 l=0.15
X1715 a_20923_15279# a_20794_15553# a_20503_15253# VSS.t272 sky130_fd_pr__special_nfet_01v8 ad=0.0989 pd=0.995 as=0.0684 ps=0.74 w=0.36 l=0.15
X1716 VSS.t2398 VDD VSS.t2397 VSS.t2396 sky130_fd_pr__nfet_01v8 ad=0.143 pd=1.62 as=0 ps=0 w=0.55 l=1.97
X1717 VSS.t979 VDD VSS.t978 VSS.t977 sky130_fd_pr__nfet_01v8 ad=0.143 pd=1.62 as=0 ps=0 w=0.55 l=4.73
X1718 VDD VSS.t3788 VDD VDD sky130_fd_pr__pfet_01v8_hvt ad=0.2262 pd=2.26 as=0 ps=0 w=0.87 l=1.97
X1719 VSS.t1660 VDD VSS.t1659 VSS.t1658 sky130_fd_pr__nfet_01v8 ad=0.143 pd=1.62 as=0 ps=0 w=0.55 l=4.73
X1720 counter_value_o[0] a_2748_16885# VSS.t241 VSS.t240 sky130_fd_pr__nfet_01v8 ad=0.08775 pd=0.92 as=0.17225 ps=1.83 w=0.65 l=0.15
X1721 VSS.t2460 VDD VSS.t2459 VSS.t2351 sky130_fd_pr__nfet_01v8 ad=0.143 pd=1.62 as=0 ps=0 w=0.55 l=4.73
X1722 VDD VSS.t4175 VDD VDD sky130_fd_pr__pfet_01v8_hvt ad=0.2262 pd=2.26 as=0 ps=0 w=0.87 l=4.73
X1723 VDD VSS.t3635 VDD VDD sky130_fd_pr__pfet_01v8_hvt ad=0.2262 pd=2.26 as=0 ps=0 w=0.87 l=4.73
X1724 VSS.t2544 VDD VSS.t2543 VSS.t2542 sky130_fd_pr__nfet_01v8 ad=0.143 pd=1.62 as=0 ps=0 w=0.55 l=1.97
X1725 VDD VSS.t3767 VDD VDD sky130_fd_pr__pfet_01v8_hvt ad=0.2262 pd=2.26 as=0 ps=0 w=0.87 l=4.73
X1726 VSS.t1350 VDD VSS.t1349 VSS.t1348 sky130_fd_pr__nfet_01v8 ad=0.143 pd=1.62 as=0 ps=0 w=0.55 l=1.97
X1727 VSS.t752 VDD VSS.t751 VSS.t750 sky130_fd_pr__nfet_01v8 ad=0.143 pd=1.62 as=0 ps=0 w=0.55 l=4.73
X1728 VDD VSS.t3905 VDD VDD sky130_fd_pr__pfet_01v8_hvt ad=0.2262 pd=2.26 as=0 ps=0 w=0.87 l=4.73
X1729 VDD VSS.t4276 VDD VDD sky130_fd_pr__pfet_01v8_hvt ad=0.2262 pd=2.26 as=0 ps=0 w=0.87 l=4.73
X1730 VSS.t818 VDD VSS.t817 VSS.t816 sky130_fd_pr__nfet_01v8 ad=0.143 pd=1.62 as=0 ps=0 w=0.55 l=4.73
X1731 VDD VSS.t4144 VDD VDD sky130_fd_pr__pfet_01v8_hvt ad=0.2262 pd=2.26 as=0 ps=0 w=0.87 l=4.73
X1732 VSS.t348 VDD VSS.t347 VSS.t346 sky130_fd_pr__nfet_01v8 ad=0.143 pd=1.62 as=0 ps=0 w=0.55 l=4.73
X1733 VSS.t563 VDD VSS.t562 VSS.t561 sky130_fd_pr__nfet_01v8 ad=0.143 pd=1.62 as=0 ps=0 w=0.55 l=4.73
X1734 a_20716_15823# _36_.B.t11 _40_.Y VDD sky130_fd_pr__pfet_01v8_hvt ad=0.0768 pd=0.88 as=0.0896 ps=0.92 w=0.64 l=0.15
X1735 VDD VSS.t3724 VDD VDD sky130_fd_pr__pfet_01v8_hvt ad=0.2262 pd=2.26 as=0 ps=0 w=0.87 l=4.73
X1736 VDD VSS.t3675 VDD VDD sky130_fd_pr__pfet_01v8_hvt ad=0.2262 pd=2.26 as=0 ps=0 w=0.87 l=4.73
X1737 VSS.t2771 VDD VSS.t2770 VSS.t2769 sky130_fd_pr__nfet_01v8 ad=0.143 pd=1.62 as=0 ps=0 w=0.55 l=4.73
X1738 VDD VSS.t2356 VDD VDD sky130_fd_pr__pfet_01v8_hvt ad=0.2262 pd=2.26 as=0 ps=0 w=0.87 l=0.59
X1739 VSS.t1747 VDD VSS.t1746 VSS.t1745 sky130_fd_pr__nfet_01v8 ad=0.143 pd=1.62 as=0 ps=0 w=0.55 l=4.73
X1740 a_25235_15823# _50_.Y VDD VDD sky130_fd_pr__pfet_01v8_hvt ad=0.14 pd=1.28 as=0.14 ps=1.28 w=1 l=0.15
X1741 VDD VSS.t4308 VDD VDD sky130_fd_pr__pfet_01v8_hvt ad=0.2262 pd=2.26 as=0 ps=0 w=0.87 l=4.73
X1742 a_27456_15279# a_27057_15279# a_27330_15645# VSS.t3343 sky130_fd_pr__special_nfet_01v8 ad=0.0696 pd=0.765 as=0.0621 ps=0.705 w=0.36 l=0.15
X1743 VSS.t2266 VDD VSS.t2265 VSS.t2264 sky130_fd_pr__nfet_01v8 ad=0.143 pd=1.62 as=0 ps=0 w=0.55 l=4.73
X1744 VSS.t505 VDD VSS.t504 VSS.t503 sky130_fd_pr__nfet_01v8 ad=0.143 pd=1.62 as=0 ps=0 w=0.55 l=1.05
X1745 a_27057_15279# a_26891_15279# VDD VDD sky130_fd_pr__pfet_01v8_hvt ad=0.1664 pd=1.8 as=0.0864 ps=0.91 w=0.64 l=0.15
X1746 VDD VSS.t3881 VDD VDD sky130_fd_pr__pfet_01v8_hvt ad=0.2262 pd=2.26 as=0 ps=0 w=0.87 l=4.73
X1747 VDD VSS.t3468 VDD VDD sky130_fd_pr__pfet_01v8_hvt ad=0.2262 pd=2.26 as=0 ps=0 w=0.87 l=4.73
X1748 VSS.t599 VDD VSS.t598 VSS.t597 sky130_fd_pr__nfet_01v8 ad=0.143 pd=1.62 as=0 ps=0 w=0.55 l=4.73
X1749 VSS.t2950 VDD VSS.t2949 VSS.t2948 sky130_fd_pr__nfet_01v8 ad=0.143 pd=1.62 as=0 ps=0 w=0.55 l=4.73
X1750 a_11413_16341.t6 clkbuf_0_clock_i.X VDD VDD sky130_fd_pr__pfet_01v8_hvt ad=0.14 pd=1.28 as=0.14 ps=1.28 w=1 l=0.15
X1751 a_12391_15823# a_11527_15829# a_12134_15797# VDD sky130_fd_pr__pfet_01v8_hvt ad=0.0567 pd=0.69 as=0.1095 ps=1.075 w=0.42 l=0.15
X1752 VSS.t551 VDD VSS.t550 VSS.t549 sky130_fd_pr__nfet_01v8 ad=0.143 pd=1.62 as=0 ps=0 w=0.55 l=4.73
X1753 VSS.t935 VDD VSS.t934 VSS.t933 sky130_fd_pr__nfet_01v8 ad=0.143 pd=1.62 as=0 ps=0 w=0.55 l=1.97
X1754 VDD VSS.t3529 VDD VDD sky130_fd_pr__pfet_01v8_hvt ad=0.2262 pd=2.26 as=0 ps=0 w=0.87 l=4.73
X1755 VSS.t2580 VDD VSS.t2579 VSS.t2578 sky130_fd_pr__nfet_01v8 ad=0.143 pd=1.62 as=0 ps=0 w=0.55 l=4.73
X1756 VSS.t3136 VDD VSS.t3135 VSS.t3134 sky130_fd_pr__nfet_01v8 ad=0.143 pd=1.62 as=0 ps=0 w=0.55 l=0.59
X1757 a_20627_16189# _77_.Q _40_.Y VSS.t7 sky130_fd_pr__nfet_01v8 ad=0.0588 pd=0.7 as=0.1113 ps=1.37 w=0.42 l=0.15
X1758 a_20923_15279# a_20787_15253.t7 a_20503_15253# VDD sky130_fd_pr__pfet_01v8_hvt ad=0.1095 pd=1.075 as=0.0567 ps=0.69 w=0.42 l=0.15
X1759 VSS.t3313 _43_.X a_21341_15279# VSS.t3312 sky130_fd_pr__nfet_01v8 ad=0.1092 pd=1.36 as=0.0813 ps=0.83 w=0.42 l=0.15
X1760 VSS.t988 VDD VSS.t987 VSS.t986 sky130_fd_pr__nfet_01v8 ad=0.143 pd=1.62 as=0 ps=0 w=0.55 l=4.73
X1761 VDD VSS.t3718 VDD VDD sky130_fd_pr__pfet_01v8_hvt ad=0.2262 pd=2.26 as=0 ps=0 w=0.87 l=1.97
X1762 VSS.t1556 VDD VSS.t1555 VSS.t1554 sky130_fd_pr__nfet_01v8 ad=0.143 pd=1.62 as=0 ps=0 w=0.55 l=4.73
X1763 _69_.A a_10547_16395# VDD VDD sky130_fd_pr__pfet_01v8_hvt ad=0.475 pd=2.95 as=0.16655 ps=1.39 w=1 l=0.15
X1764 a_12061_15823# a_11527_15829# a_11966_15823# VDD sky130_fd_pr__pfet_01v8_hvt ad=0.07665 pd=0.785 as=0.06825 ps=0.745 w=0.42 l=0.15
X1765 VDD VSS.t3486 VDD VDD sky130_fd_pr__pfet_01v8_hvt ad=0.2262 pd=2.26 as=0 ps=0 w=0.87 l=0.59
X1766 VSS.t1878 VDD VSS.t1877 VSS.t1876 sky130_fd_pr__nfet_01v8 ad=0.143 pd=1.62 as=0 ps=0 w=0.55 l=4.73
X1767 VSS.t1502 VDD VSS.t1501 VSS.t1500 sky130_fd_pr__nfet_01v8 ad=0.143 pd=1.62 as=0 ps=0 w=0.55 l=4.73
X1768 VSS.t2302 VDD VSS.t2301 VSS.t2300 sky130_fd_pr__nfet_01v8 ad=0.143 pd=1.62 as=0 ps=0 w=0.55 l=4.73
X1769 VDD VSS.t3694 VDD VDD sky130_fd_pr__pfet_01v8_hvt ad=0.2262 pd=2.26 as=0 ps=0 w=0.87 l=4.73
X1770 a_6407_16395# input2.X.t17 VDD VDD sky130_fd_pr__pfet_01v8_hvt ad=0.0567 pd=0.69 as=0.1176 ps=1.4 w=0.42 l=0.15
X1771 VDD VSS.t3697 VDD VDD sky130_fd_pr__pfet_01v8_hvt ad=0.2262 pd=2.26 as=0 ps=0 w=0.87 l=4.73
X1772 VDD VSS.t4105 VDD VDD sky130_fd_pr__pfet_01v8_hvt ad=0.2262 pd=2.26 as=0 ps=0 w=0.87 l=4.73
X1773 VSS.t926 VDD VSS.t925 VSS.t924 sky130_fd_pr__nfet_01v8 ad=0.143 pd=1.62 as=0 ps=0 w=0.55 l=4.73
X1774 a_20868_16519# _36_.B.t16 VSS.t234 VSS.t233 sky130_fd_pr__nfet_01v8 ad=0.1092 pd=1.36 as=0.0567 ps=0.69 w=0.42 l=0.15
X1775 VSS.t2141 VDD VSS.t2141 VSS.t2136 sky130_fd_pr__nfet_01v8 ad=0.143 pd=1.62 as=0 ps=0 w=0.55 l=0.59
X1776 VSS.t345 VDD VSS.t344 VSS.t343 sky130_fd_pr__nfet_01v8 ad=0.143 pd=1.62 as=0 ps=0 w=0.55 l=1.97
X1777 VDD VSS.t3897 VDD VDD sky130_fd_pr__pfet_01v8_hvt ad=0.2262 pd=2.26 as=0 ps=0 w=0.87 l=1.97
X1778 VDD VSS.t3979 VDD VDD sky130_fd_pr__pfet_01v8_hvt ad=0.2262 pd=2.26 as=0 ps=0 w=0.87 l=4.73
X1779 VDD VSS.t4074 VDD VDD sky130_fd_pr__pfet_01v8_hvt ad=0.2262 pd=2.26 as=0 ps=0 w=0.87 l=4.73
X1780 VSS.t758 VDD VSS.t757 VSS.t756 sky130_fd_pr__nfet_01v8 ad=0.143 pd=1.62 as=0 ps=0 w=0.55 l=4.73
X1781 VDD VSS.t4180 VDD VDD sky130_fd_pr__pfet_01v8_hvt ad=0.2262 pd=2.26 as=0 ps=0 w=0.87 l=4.73
X1782 VDD VSS.t4016 VDD VDD sky130_fd_pr__pfet_01v8_hvt ad=0.2262 pd=2.26 as=0 ps=0 w=0.87 l=4.73
X1783 VSS.t1335 VDD VSS.t1334 VSS.t1333 sky130_fd_pr__nfet_01v8 ad=0.143 pd=1.62 as=0 ps=0 w=0.55 l=1.97
X1784 VDD _38_.A a_18611_15831# VDD sky130_fd_pr__pfet_01v8_hvt ad=0.149 pd=1.325 as=0.1664 ps=1.8 w=0.64 l=0.15
X1785 VDD VSS.t3927 VDD VDD sky130_fd_pr__pfet_01v8_hvt ad=0.2262 pd=2.26 as=0 ps=0 w=0.87 l=4.73
X1786 VSS.t1824 VDD VSS.t1823 VSS.t1822 sky130_fd_pr__nfet_01v8 ad=0.143 pd=1.62 as=0 ps=0 w=0.55 l=4.73
X1787 VDD VSS.t3526 VDD VDD sky130_fd_pr__pfet_01v8_hvt ad=0.2262 pd=2.26 as=0 ps=0 w=0.87 l=4.73
X1788 VSS.t3196 VDD VSS.t3195 VSS.t3194 sky130_fd_pr__nfet_01v8 ad=0.143 pd=1.62 as=0 ps=0 w=0.55 l=4.73
X1789 VSS.t2013 VDD VSS.t2012 VSS.t2011 sky130_fd_pr__nfet_01v8 ad=0.143 pd=1.62 as=0 ps=0 w=0.55 l=1.97
X1790 VSS.t2204 VDD VSS.t2203 VSS.t2202 sky130_fd_pr__nfet_01v8 ad=0.143 pd=1.62 as=0 ps=0 w=0.55 l=4.73
X1791 a_22189_16367# _36_.A.t6 VSS.t138 VSS.t137 sky130_fd_pr__nfet_01v8 ad=0.08775 pd=0.92 as=0.169 ps=1.82 w=0.65 l=0.15
X1792 VSS.t453 VDD VSS.t452 VSS.t451 sky130_fd_pr__nfet_01v8 ad=0.143 pd=1.62 as=0 ps=0 w=0.55 l=4.73
X1793 VDD VSS.t3574 VDD VDD sky130_fd_pr__pfet_01v8_hvt ad=0.2262 pd=2.26 as=0 ps=0 w=0.87 l=4.73
X1794 VDD VSS.t3512 VDD VDD sky130_fd_pr__pfet_01v8_hvt ad=0.2262 pd=2.26 as=0 ps=0 w=0.87 l=4.73
X1795 VSS.t2681 VDD VSS.t2680 VSS.t2679 sky130_fd_pr__nfet_01v8 ad=0.143 pd=1.62 as=0 ps=0 w=0.55 l=4.73
X1796 VDD VSS.t1600 VDD VDD sky130_fd_pr__pfet_01v8_hvt ad=0.2262 pd=2.26 as=0 ps=0 w=0.87 l=0.59
X1797 VSS.t1215 VDD VSS.t1214 VSS.t1213 sky130_fd_pr__nfet_01v8 ad=0.143 pd=1.62 as=0 ps=0 w=0.55 l=4.73
X1798 VDD VSS.t4313 VDD VDD sky130_fd_pr__pfet_01v8_hvt ad=0.2262 pd=2.26 as=0 ps=0 w=0.87 l=4.73
X1799 VDD a_12134_15797# a_12061_15823# VDD sky130_fd_pr__pfet_01v8_hvt ad=0.17887 pd=1.26 as=0.07665 ps=0.785 w=0.42 l=0.15
X1800 VSS.t794 VDD VSS.t793 VSS.t792 sky130_fd_pr__nfet_01v8 ad=0.143 pd=1.62 as=0 ps=0 w=0.55 l=4.73
X1801 VSS.t2108 VDD VSS.t2107 VSS.t2106 sky130_fd_pr__nfet_01v8 ad=0.143 pd=1.62 as=0 ps=0 w=0.55 l=4.73
X1802 VSS.t96 _50_.B1.t8 a_32503_16919# VSS.t3292 sky130_fd_pr__nfet_01v8 ad=0.097 pd=0.975 as=0.1092 ps=1.36 w=0.42 l=0.15
X1803 VDD VSS.t4193 VDD VDD sky130_fd_pr__pfet_01v8_hvt ad=0.2262 pd=2.26 as=0 ps=0 w=0.87 l=1.97
X1804 VDD VSS.t3894 VDD VDD sky130_fd_pr__pfet_01v8_hvt ad=0.2262 pd=2.26 as=0 ps=0 w=0.87 l=4.73
X1805 VDD VSS.t3471 VDD VDD sky130_fd_pr__pfet_01v8_hvt ad=0.2262 pd=2.26 as=0 ps=0 w=0.87 l=4.73
X1806 VSS.t3306 clkbuf_0_clock_i.X a_11413_16341.t3 VSS.t3305 sky130_fd_pr__nfet_01v8 ad=0.1113 pd=1.37 as=0.0588 ps=0.7 w=0.42 l=0.15
X1807 VDD VSS.t4329 VDD VDD sky130_fd_pr__pfet_01v8_hvt ad=0.2262 pd=2.26 as=0 ps=0 w=0.87 l=4.73
X1808 VDD VSS.t3655 VDD VDD sky130_fd_pr__pfet_01v8_hvt ad=0.2262 pd=2.26 as=0 ps=0 w=0.87 l=4.73
X1809 VSS.t2335 VDD VSS.t2334 VSS.t2333 sky130_fd_pr__nfet_01v8 ad=0.143 pd=1.62 as=0 ps=0 w=0.55 l=4.73
X1810 VSS.t1562 VDD VSS.t1561 VSS.t1560 sky130_fd_pr__nfet_01v8 ad=0.143 pd=1.62 as=0 ps=0 w=0.55 l=4.73
X1811 a_4107_16161# input2.X.t8 VDD VDD sky130_fd_pr__pfet_01v8_hvt ad=0.0567 pd=0.69 as=0.1176 ps=1.4 w=0.42 l=0.15
X1812 VDD input2.X.t4 _55_.Y VDD sky130_fd_pr__pfet_01v8_hvt ad=0.14575 pd=1.335 as=0.135 ps=1.27 w=1 l=0.15
X1813 VDD VSS.t4196 VDD VDD sky130_fd_pr__pfet_01v8_hvt ad=0.2262 pd=2.26 as=0 ps=0 w=0.87 l=4.73
X1814 VSS.t3127 VDD VSS.t3126 VSS.t3125 sky130_fd_pr__nfet_01v8 ad=0.143 pd=1.62 as=0 ps=0 w=0.55 l=0.59
X1815 VDD VSS.t4110 VDD VDD sky130_fd_pr__pfet_01v8_hvt ad=0.2262 pd=2.26 as=0 ps=0 w=0.87 l=4.73
X1816 VSS.t635 VDD VSS.t634 VSS.t633 sky130_fd_pr__nfet_01v8 ad=0.143 pd=1.62 as=0 ps=0 w=0.55 l=4.73
X1817 VDD VSS.t3499 VDD VDD sky130_fd_pr__pfet_01v8_hvt ad=0.2262 pd=2.26 as=0 ps=0 w=0.87 l=4.73
X1818 VDD VSS.t2474 VDD VDD sky130_fd_pr__pfet_01v8_hvt ad=0.2262 pd=2.26 as=0 ps=0 w=0.87 l=4.73
X1819 VSS.t3377 a_37471_16919# counter_value_o[7] VSS.t391 sky130_fd_pr__nfet_01v8 ad=0.17225 pd=1.83 as=0.08775 ps=0.92 w=0.65 l=0.15
X1820 VDD VSS.t3984 VDD VDD sky130_fd_pr__pfet_01v8_hvt ad=0.2262 pd=2.26 as=0 ps=0 w=0.87 l=4.73
X1821 VDD VSS.t3871 VDD VDD sky130_fd_pr__pfet_01v8_hvt ad=0.2262 pd=2.26 as=0 ps=0 w=0.87 l=4.73
X1822 VSS.t2490 VDD VSS.t2489 VSS.t2488 sky130_fd_pr__nfet_01v8 ad=0.143 pd=1.62 as=0 ps=0 w=0.55 l=4.73
X1823 VSS.t403 VDD VSS.t402 VSS.t401 sky130_fd_pr__nfet_01v8 ad=0.143 pd=1.62 as=0 ps=0 w=0.55 l=4.73
X1824 VDD VSS.t4340 VDD VDD sky130_fd_pr__pfet_01v8_hvt ad=0.2262 pd=2.26 as=0 ps=0 w=0.87 l=1.05
X1825 VDD VSS.t4262 VDD VDD sky130_fd_pr__pfet_01v8_hvt ad=0.2262 pd=2.26 as=0 ps=0 w=0.87 l=4.73
X1826 VSS.t1609 VDD VSS.t1608 VSS.t1607 sky130_fd_pr__nfet_01v8 ad=0.143 pd=1.62 as=0 ps=0 w=0.55 l=4.73
X1827 a_4675_16519# a_4771_16341# VDD VDD sky130_fd_pr__pfet_01v8_hvt ad=0.27 pd=2.54 as=0.135 ps=1.27 w=1 l=0.15
X1828 VDD VSS.t3649 VDD VDD sky130_fd_pr__pfet_01v8_hvt ad=0.2262 pd=2.26 as=0 ps=0 w=0.87 l=4.73
X1829 VSS.t2419 VDD VSS.t2418 VSS.t2417 sky130_fd_pr__nfet_01v8 ad=0.143 pd=1.62 as=0 ps=0 w=0.55 l=4.73
X1830 VDD VSS.t3781 VDD VDD sky130_fd_pr__pfet_01v8_hvt ad=0.2262 pd=2.26 as=0 ps=0 w=0.87 l=4.73
X1831 VDD VSS.t3843 VDD VDD sky130_fd_pr__pfet_01v8_hvt ad=0.2262 pd=2.26 as=0 ps=0 w=0.87 l=1.97
X1832 VDD a_5262_16341# a_5191_16367# VDD sky130_fd_pr__pfet_01v8_hvt ad=0.17887 pd=1.26 as=0.1095 ps=1.075 w=0.75 l=0.15
X1833 VSS.t2652 VDD VSS.t2651 VSS.t2650 sky130_fd_pr__nfet_01v8 ad=0.143 pd=1.62 as=0 ps=0 w=0.55 l=4.73
X1834 a_18183_17249# input2.X.t20 VDD VDD sky130_fd_pr__pfet_01v8_hvt ad=0.0567 pd=0.69 as=0.1176 ps=1.4 w=0.42 l=0.15
X1835 VSS.t683 VDD VSS.t682 VSS.t681 sky130_fd_pr__nfet_01v8 ad=0.143 pd=1.62 as=0 ps=0 w=0.55 l=4.73
X1836 VDD VSS.t1385 VDD VDD sky130_fd_pr__pfet_01v8_hvt ad=0.2262 pd=2.26 as=0 ps=0 w=0.87 l=0.59
X1837 a_18130_16733# a_17691_16367# a_18045_16367# VSS.t3382 sky130_fd_pr__special_nfet_01v8 ad=0.0621 pd=0.705 as=0.0813 ps=0.83 w=0.36 l=0.15
X1838 VSS.t2565 VDD VSS.t2564 VSS.t2563 sky130_fd_pr__nfet_01v8 ad=0.143 pd=1.62 as=0 ps=0 w=0.55 l=4.73
X1839 VSS.t1200 VDD VSS.t1199 VSS.t1198 sky130_fd_pr__nfet_01v8 ad=0.143 pd=1.62 as=0 ps=0 w=0.55 l=4.73
X1840 VSS.t708 a_27923_15547# a_27881_15279# VSS.t3329 sky130_fd_pr__nfet_01v8 ad=0.1092 pd=1.36 as=0.066 ps=0.745 w=0.42 l=0.15
X1841 VSS.t1030 VDD VSS.t1029 VSS.t1028 sky130_fd_pr__nfet_01v8 ad=0.143 pd=1.62 as=0 ps=0 w=0.55 l=4.73
X1842 VDD VSS.t3828 VDD VDD sky130_fd_pr__pfet_01v8_hvt ad=0.2262 pd=2.26 as=0 ps=0 w=0.87 l=4.73
X1843 _60_.X a_4107_16161# VDD VDD sky130_fd_pr__pfet_01v8_hvt ad=0.475 pd=2.95 as=0.16655 ps=1.39 w=1 l=0.15
X1844 VDD _69_.A a_10883_15823# VDD sky130_fd_pr__pfet_01v8_hvt ad=0.11455 pd=1.08 as=0.2054 ps=2.1 w=0.79 l=0.15
X1845 VSS.t176 clkbuf_0_clock_i.X a_21914_15823.t2 VSS.t3310 sky130_fd_pr__nfet_01v8 ad=0.0588 pd=0.7 as=0.0588 ps=0.7 w=0.42 l=0.15
X1846 VDD VSS.t3831 VDD VDD sky130_fd_pr__pfet_01v8_hvt ad=0.2262 pd=2.26 as=0 ps=0 w=0.87 l=4.73
X1847 VSS.t1138 VDD VSS.t1137 VSS.t1136 sky130_fd_pr__nfet_01v8 ad=0.143 pd=1.62 as=0 ps=0 w=0.55 l=4.73
X1848 VDD VSS.t3967 VDD VDD sky130_fd_pr__pfet_01v8_hvt ad=0.2262 pd=2.26 as=0 ps=0 w=0.87 l=1.97
X1849 VDD VSS.t4005 VDD VDD sky130_fd_pr__pfet_01v8_hvt ad=0.2262 pd=2.26 as=0 ps=0 w=0.87 l=4.73
X1850 a_27057_15279# a_26891_15279# VSS.t268 VSS.t3345 sky130_fd_pr__nfet_01v8 ad=0.1092 pd=1.36 as=0.0567 ps=0.69 w=0.42 l=0.15
X1851 VDD VSS.t4166 VDD VDD sky130_fd_pr__pfet_01v8_hvt ad=0.2262 pd=2.26 as=0 ps=0 w=0.87 l=4.73
X1852 VSS.t2001 VDD VSS.t2000 VSS.t1999 sky130_fd_pr__nfet_01v8 ad=0.143 pd=1.62 as=0 ps=0 w=0.55 l=4.73
X1853 VSS.t1547 VDD VSS.t1546 VSS.t1545 sky130_fd_pr__nfet_01v8 ad=0.143 pd=1.62 as=0 ps=0 w=0.55 l=4.73
X1854 VSS.t3360 clock_i a_16762_15823.t0 VSS.t3359 sky130_fd_pr__nfet_01v8 ad=0.0588 pd=0.7 as=0.0588 ps=0.7 w=0.42 l=0.15
X1855 VSS.t2720 VDD VSS.t2719 VSS.t2718 sky130_fd_pr__nfet_01v8 ad=0.143 pd=1.62 as=0 ps=0 w=0.55 l=4.73
X1856 VSS.t1377 VDD VSS.t1376 VSS.t1375 sky130_fd_pr__nfet_01v8 ad=0.143 pd=1.62 as=0 ps=0 w=0.55 l=4.73
X1857 VSS.t845 VDD VSS.t844 VSS.t843 sky130_fd_pr__nfet_01v8 ad=0.143 pd=1.62 as=0 ps=0 w=0.55 l=4.73
X1858 VDD _54_.A _54_.Y VDD sky130_fd_pr__pfet_01v8_hvt ad=0.26 pd=2.52 as=0.135 ps=1.27 w=1 l=0.15
X1859 VSS.t3124 VDD VSS.t3123 VSS.t3122 sky130_fd_pr__nfet_01v8 ad=0.143 pd=1.62 as=0 ps=0 w=0.55 l=4.73
X1860 VSS.t1827 VDD VSS.t1826 VSS.t1825 sky130_fd_pr__nfet_01v8 ad=0.143 pd=1.62 as=0 ps=0 w=0.55 l=4.73
X1861 VSS.t1762 VDD VSS.t1761 VSS.t1760 sky130_fd_pr__nfet_01v8 ad=0.143 pd=1.62 as=0 ps=0 w=0.55 l=4.73
X1862 VSS.t1165 VDD VSS.t1164 VSS.t1163 sky130_fd_pr__nfet_01v8 ad=0.143 pd=1.62 as=0 ps=0 w=0.55 l=1.97
X1863 VDD VSS.t3711 VDD VDD sky130_fd_pr__pfet_01v8_hvt ad=0.2262 pd=2.26 as=0 ps=0 w=0.87 l=4.73
X1864 VDD _64_.X.t2 a_6927_16911# VDD sky130_fd_pr__pfet_01v8_hvt ad=0.11455 pd=1.08 as=0.2054 ps=2.1 w=0.79 l=0.15
X1865 VDD VSS.t4302 VDD VDD sky130_fd_pr__pfet_01v8_hvt ad=0.2262 pd=2.26 as=0 ps=0 w=0.87 l=2.89
X1866 VDD a_17652_16885# counter_value_o[3] VDD sky130_fd_pr__pfet_01v8_hvt ad=0.149 pd=1.325 as=0.135 ps=1.27 w=1 l=0.15
X1867 VDD VSS.t3518 VDD VDD sky130_fd_pr__pfet_01v8_hvt ad=0.2262 pd=2.26 as=0 ps=0 w=0.87 l=1.05
X1868 VSS.t1684 VDD VSS.t1683 VSS.t1682 sky130_fd_pr__nfet_01v8 ad=0.143 pd=1.62 as=0 ps=0 w=0.55 l=4.73
X1869 VDD a_11413_16341.t24 _75_.CLK VDD sky130_fd_pr__pfet_01v8_hvt ad=0.14 pd=1.28 as=0.14 ps=1.28 w=1 l=0.15
X1870 VSS.t57 a_12391_15823# a_12559_15797# VSS.t56 sky130_fd_pr__nfet_01v8 ad=0.08775 pd=0.92 as=0.169 ps=1.82 w=0.65 l=0.15
X1871 VSS.t3103 VDD VSS.t3102 VSS.t3101 sky130_fd_pr__nfet_01v8 ad=0.143 pd=1.62 as=0 ps=0 w=0.55 l=4.73
X1872 VDD VSS.t4269 VDD VDD sky130_fd_pr__pfet_01v8_hvt ad=0.2262 pd=2.26 as=0 ps=0 w=0.87 l=4.73
X1873 VDD VSS.t3758 VDD VDD sky130_fd_pr__pfet_01v8_hvt ad=0.2262 pd=2.26 as=0 ps=0 w=0.87 l=4.73
X1874 VSS.t1807 VDD VSS.t1806 VSS.t1805 sky130_fd_pr__nfet_01v8 ad=0.143 pd=1.62 as=0 ps=0 w=0.55 l=4.73
X1875 VDD _63_.A.t15 _67_.B VDD sky130_fd_pr__pfet_01v8_hvt ad=0.165 pd=1.33 as=0.135 ps=1.27 w=1 l=0.15
X1876 VSS.t970 VDD VSS.t969 VSS.t968 sky130_fd_pr__nfet_01v8 ad=0.143 pd=1.62 as=0 ps=0 w=0.55 l=4.73
X1877 VSS.t1015 VDD VSS.t1014 VSS.t1013 sky130_fd_pr__nfet_01v8 ad=0.143 pd=1.62 as=0 ps=0 w=0.55 l=4.73
X1878 VDD VSS.t3761 VDD VDD sky130_fd_pr__pfet_01v8_hvt ad=0.2262 pd=2.26 as=0 ps=0 w=0.87 l=4.73
X1879 VDD VSS.t4127 VDD VDD sky130_fd_pr__pfet_01v8_hvt ad=0.2262 pd=2.26 as=0 ps=0 w=0.87 l=4.73
X1880 _53_.A.t0 _50_.Y a_25320_16143# VSS.t61 sky130_fd_pr__nfet_01v8 ad=0.143 pd=1.09 as=0.091 ps=0.93 w=0.65 l=0.15
X1881 VSS.t2840 VDD VSS.t2839 VSS.t2838 sky130_fd_pr__nfet_01v8 ad=0.143 pd=1.62 as=0 ps=0 w=0.55 l=4.73
X1882 VSS.t3184 VDD VSS.t3183 VSS.t3182 sky130_fd_pr__nfet_01v8 ad=0.143 pd=1.62 as=0 ps=0 w=0.55 l=4.73
X1883 VSS.t1824 VDD VSS.t1823 VSS.t1822 sky130_fd_pr__nfet_01v8 ad=0.143 pd=1.62 as=0 ps=0 w=0.55 l=4.73
X1884 VSS.t1636 VDD VSS.t1635 VSS.t1634 sky130_fd_pr__nfet_01v8 ad=0.143 pd=1.62 as=0 ps=0 w=0.55 l=1.97
X1885 VDD VSS.t4032 VDD VDD sky130_fd_pr__pfet_01v8_hvt ad=0.2262 pd=2.26 as=0 ps=0 w=0.87 l=1.97
X1886 VDD VSS.t3847 VDD VDD sky130_fd_pr__pfet_01v8_hvt ad=0.2262 pd=2.26 as=0 ps=0 w=0.87 l=4.73
X1887 VDD VSS.t4096 VDD VDD sky130_fd_pr__pfet_01v8_hvt ad=0.2262 pd=2.26 as=0 ps=0 w=0.87 l=4.73
X1888 a_7033_15823# _63_.B _63_.Y VDD sky130_fd_pr__pfet_01v8_hvt ad=0.105 pd=1.21 as=0.165 ps=1.33 w=1 l=0.15
X1889 VDD VSS.t4279 VDD VDD sky130_fd_pr__pfet_01v8_hvt ad=0.2262 pd=2.26 as=0 ps=0 w=0.87 l=4.73
X1890 VSS.t952 VDD VSS.t951 VSS.t843 sky130_fd_pr__nfet_01v8 ad=0.143 pd=1.62 as=0 ps=0 w=0.55 l=4.73
X1891 VSS.t2299 VDD VSS.t2298 VSS.t2297 sky130_fd_pr__nfet_01v8 ad=0.143 pd=1.62 as=0 ps=0 w=0.55 l=1.97
X1892 VSS.t1362 VDD VSS.t1361 VSS.t1360 sky130_fd_pr__nfet_01v8 ad=0.143 pd=1.62 as=0 ps=0 w=0.55 l=4.73
X1893 VSS.t512 VDD VSS.t439 VSS.t511 sky130_fd_pr__nfet_01v8 ad=0.143 pd=1.62 as=0 ps=0 w=0.55 l=4.73
X1894 VSS.t2592 VDD VSS.t2591 VSS.t2590 sky130_fd_pr__nfet_01v8 ad=0.143 pd=1.62 as=0 ps=0 w=0.55 l=4.73
X1895 VDD VSS.t4118 VDD VDD sky130_fd_pr__pfet_01v8_hvt ad=0.2262 pd=2.26 as=0 ps=0 w=0.87 l=1.97
X1896 VSS.t2028 VDD VSS.t2027 VSS.t2026 sky130_fd_pr__nfet_01v8 ad=0.143 pd=1.62 as=0 ps=0 w=0.55 l=1.97
X1897 VDD VSS.t3877 VDD VDD sky130_fd_pr__pfet_01v8_hvt ad=0.2262 pd=2.26 as=0 ps=0 w=0.87 l=1.97
X1898 a_20503_15253# a_20794_15553# a_20745_15645# VDD sky130_fd_pr__pfet_01v8_hvt ad=0.0567 pd=0.69 as=0.0882 ps=0.84 w=0.42 l=0.15
X1899 VDD VSS.t3683 VDD VDD sky130_fd_pr__pfet_01v8_hvt ad=0.2262 pd=2.26 as=0 ps=0 w=0.87 l=4.73
X1900 VSS.t1902 VDD VSS.t1901 VSS.t1900 sky130_fd_pr__nfet_01v8 ad=0.143 pd=1.62 as=0 ps=0 w=0.55 l=4.73
X1901 VDD a_11413_16341.t38 _75_.CLK VDD sky130_fd_pr__pfet_01v8_hvt ad=0.14 pd=1.28 as=0.14 ps=1.28 w=1 l=0.15
X1902 _63_.Y a_6883_16055# VDD VDD sky130_fd_pr__pfet_01v8_hvt ad=0.165 pd=1.33 as=0.36 ps=2.72 w=1 l=0.15
X1903 VSS.t1242 VDD VSS.t1241 VSS.t1240 sky130_fd_pr__nfet_01v8 ad=0.143 pd=1.62 as=0 ps=0 w=0.55 l=4.73
X1904 VDD VSS.t1493 VDD VDD sky130_fd_pr__pfet_01v8_hvt ad=0.2262 pd=2.26 as=0 ps=0 w=0.87 l=0.59
X1905 _36_.B.t0 output3.A.t8 VDD VDD sky130_fd_pr__pfet_01v8_hvt ad=0.135 pd=1.27 as=0.135 ps=1.27 w=1 l=0.15
X1906 VSS.t1645 VDD VSS.t1644 VSS.t1643 sky130_fd_pr__nfet_01v8 ad=0.143 pd=1.62 as=0 ps=0 w=0.55 l=4.73
X1907 input2.X.t2 a_1407_9839# VDD VDD sky130_fd_pr__pfet_01v8_hvt ad=0.135 pd=1.27 as=0.149 ps=1.325 w=1 l=0.15
X1908 VSS.t1170 VDD VSS.t1170 VSS.t1169 sky130_fd_pr__nfet_01v8 ad=0.143 pd=1.62 as=0 ps=0 w=0.55 l=0.59
X1909 VDD VSS.t4347 VDD VDD sky130_fd_pr__pfet_01v8_hvt ad=0.2262 pd=2.26 as=0 ps=0 w=0.87 l=4.73
X1910 VSS.t234 _40_.A1 a_20868_16519# VSS.t3247 sky130_fd_pr__nfet_01v8 ad=0.0567 pd=0.69 as=0.0567 ps=0.69 w=0.42 l=0.15
X1911 VDD VSS.t3609 VDD VDD sky130_fd_pr__pfet_01v8_hvt ad=0.2262 pd=2.26 as=0 ps=0 w=0.87 l=4.73
X1912 VSS.t2926 VDD VSS.t2925 VSS.t2924 sky130_fd_pr__nfet_01v8 ad=0.143 pd=1.62 as=0 ps=0 w=0.55 l=4.73
X1913 VSS.t723 VDD VSS.t722 VSS.t721 sky130_fd_pr__nfet_01v8 ad=0.143 pd=1.62 as=0 ps=0 w=0.55 l=4.73
X1914 VSS.t482 VDD VSS.t481 VSS.t480 sky130_fd_pr__nfet_01v8 ad=0.143 pd=1.62 as=0 ps=0 w=0.55 l=1.05
X1915 VDD VSS.t3465 VDD VDD sky130_fd_pr__pfet_01v8_hvt ad=0.2262 pd=2.26 as=0 ps=0 w=0.87 l=4.73
X1916 VDD VSS.t3492 VDD VDD sky130_fd_pr__pfet_01v8_hvt ad=0.2262 pd=2.26 as=0 ps=0 w=0.87 l=4.73
X1917 VDD VSS.t4057 VDD VDD sky130_fd_pr__pfet_01v8_hvt ad=0.2262 pd=2.26 as=0 ps=0 w=0.87 l=4.73
X1918 VSS.t2610 VDD VSS.t2609 VSS.t2608 sky130_fd_pr__nfet_01v8 ad=0.143 pd=1.62 as=0 ps=0 w=0.55 l=4.73
X1919 a_23197_15279# _48_.X VSS.t183 VSS.t182 sky130_fd_pr__nfet_01v8 ad=0.0813 pd=0.83 as=0.1092 ps=1.36 w=0.42 l=0.15
X1920 VSS.t881 VDD VSS.t880 VSS.t879 sky130_fd_pr__nfet_01v8 ad=0.143 pd=1.62 as=0 ps=0 w=0.55 l=4.73
X1921 VSS.t2917 VDD VSS.t2916 VSS.t2915 sky130_fd_pr__nfet_01v8 ad=0.143 pd=1.62 as=0 ps=0 w=0.55 l=4.73
X1922 VSS.t1941 VDD VSS.t1940 VSS.t1939 sky130_fd_pr__nfet_01v8 ad=0.143 pd=1.62 as=0 ps=0 w=0.55 l=4.73
X1923 VSS.t1589 VDD VSS.t1588 VSS.t1587 sky130_fd_pr__nfet_01v8 ad=0.143 pd=1.62 as=0 ps=0 w=0.55 l=4.73
X1924 VDD VSS.t3001 VDD VDD sky130_fd_pr__pfet_01v8_hvt ad=0.2262 pd=2.26 as=0 ps=0 w=0.87 l=0.59
X1925 VSS.t1854 VDD VSS.t1853 VSS.t1852 sky130_fd_pr__nfet_01v8 ad=0.143 pd=1.62 as=0 ps=0 w=0.55 l=1.97
X1926 VSS.t1299 VDD VSS.t1298 VSS.t1297 sky130_fd_pr__nfet_01v8 ad=0.143 pd=1.62 as=0 ps=0 w=0.55 l=4.73
X1927 VDD VSS.t4187 VDD VDD sky130_fd_pr__pfet_01v8_hvt ad=0.2262 pd=2.26 as=0 ps=0 w=0.87 l=4.73
X1928 VDD VSS.t3642 VDD VDD sky130_fd_pr__pfet_01v8_hvt ad=0.2262 pd=2.26 as=0 ps=0 w=0.87 l=4.73
X1929 VDD VSS.t3660 VDD VDD sky130_fd_pr__pfet_01v8_hvt ad=0.2262 pd=2.26 as=0 ps=0 w=0.87 l=4.73
X1930 VDD VSS.t3460 VDD VDD sky130_fd_pr__pfet_01v8_hvt ad=0.2262 pd=2.26 as=0 ps=0 w=0.87 l=0.59
X1931 VSS.t2756 VDD VSS.t2755 VSS.t2754 sky130_fd_pr__nfet_01v8 ad=0.143 pd=1.62 as=0 ps=0 w=0.55 l=4.73
X1932 VDD VSS.t3923 VDD VDD sky130_fd_pr__pfet_01v8_hvt ad=0.2262 pd=2.26 as=0 ps=0 w=0.87 l=1.97
X1933 VDD input1.X.t11 _36_.B.t0 VDD sky130_fd_pr__pfet_01v8_hvt ad=0.135 pd=1.27 as=0.135 ps=1.27 w=1 l=0.15
X1934 VDD VSS.t4048 VDD VDD sky130_fd_pr__pfet_01v8_hvt ad=0.2262 pd=2.26 as=0 ps=0 w=0.87 l=1.97
X1935 VSS.t217 a_11413_16341.t16 _75_.CLK VSS.t218 sky130_fd_pr__nfet_01v8 ad=0.05775 pd=0.695 as=0.0588 ps=0.7 w=0.42 l=0.15
X1936 VSS.t149 a_25460_15797# _53_.A.t1 VSS.t271 sky130_fd_pr__nfet_01v8 ad=0.10187 pd=0.99 as=0.143 ps=1.09 w=0.65 l=0.15
X1937 clkbuf_0_clock_i.X a_16762_15823.t17 VDD VDD sky130_fd_pr__pfet_01v8_hvt ad=0.14 pd=1.28 as=0.14 ps=1.28 w=1 l=0.15
X1938 VDD VSS.t3838 VDD VDD sky130_fd_pr__pfet_01v8_hvt ad=0.2262 pd=2.26 as=0 ps=0 w=0.87 l=1.97
X1939 VSS.t1959 VDD VSS.t1958 VSS.t1957 sky130_fd_pr__nfet_01v8 ad=0.143 pd=1.62 as=0 ps=0 w=0.55 l=4.73
X1940 VDD VSS.t3534 VDD VDD sky130_fd_pr__pfet_01v8_hvt ad=0.2262 pd=2.26 as=0 ps=0 w=0.87 l=4.73
X1941 VSS.t3205 VDD VSS.t3204 VSS.t3203 sky130_fd_pr__nfet_01v8 ad=0.143 pd=1.62 as=0 ps=0 w=0.55 l=4.73
X1942 VSS.t1863 VDD VSS.t1862 VSS.t1861 sky130_fd_pr__nfet_01v8 ad=0.143 pd=1.62 as=0 ps=0 w=0.55 l=4.73
X1943 VSS.t1227 VDD VSS.t1226 VSS.t1225 sky130_fd_pr__nfet_01v8 ad=0.143 pd=1.62 as=0 ps=0 w=0.55 l=4.73
X1944 VSS.t1069 VDD VSS.t1068 VSS.t1067 sky130_fd_pr__nfet_01v8 ad=0.143 pd=1.62 as=0 ps=0 w=0.55 l=4.73
X1945 VDD VSS.t3878 VDD VDD sky130_fd_pr__pfet_01v8_hvt ad=0.2262 pd=2.26 as=0 ps=0 w=0.87 l=4.73
X1946 VDD VSS.t4345 VDD VDD sky130_fd_pr__pfet_01v8_hvt ad=0.2262 pd=2.26 as=0 ps=0 w=0.87 l=1.97
X1947 VSS.t899 VDD VSS.t898 VSS.t897 sky130_fd_pr__nfet_01v8 ad=0.143 pd=1.62 as=0 ps=0 w=0.55 l=4.73
X1948 VSS.t1057 VDD VSS.t1056 VSS.t1055 sky130_fd_pr__nfet_01v8 ad=0.143 pd=1.62 as=0 ps=0 w=0.55 l=4.73
X1949 VSS.t2699 VDD VSS.t2698 VSS.t2697 sky130_fd_pr__nfet_01v8 ad=0.143 pd=1.62 as=0 ps=0 w=0.55 l=1.97
X1950 VDD VSS.t3920 VDD VDD sky130_fd_pr__pfet_01v8_hvt ad=0.2262 pd=2.26 as=0 ps=0 w=0.87 l=4.73
X1951 VDD VSS.t4352 VDD VDD sky130_fd_pr__pfet_01v8_hvt ad=0.2262 pd=2.26 as=0 ps=0 w=0.87 l=4.73
X1952 VDD VSS.t3452 VDD VDD sky130_fd_pr__pfet_01v8_hvt ad=0.2262 pd=2.26 as=0 ps=0 w=0.87 l=4.73
X1953 VSS.t1421 VDD VSS.t1420 VSS.t1419 sky130_fd_pr__nfet_01v8 ad=0.143 pd=1.62 as=0 ps=0 w=0.55 l=1.97
X1954 counter_value_o[7] a_37471_16919# VSS.t3278 VSS.t391 sky130_fd_pr__nfet_01v8 ad=0.08775 pd=0.92 as=0.097 ps=0.975 w=0.65 l=0.15
X1955 VDD VSS.t4211 VDD VDD sky130_fd_pr__pfet_01v8_hvt ad=0.2262 pd=2.26 as=0 ps=0 w=0.87 l=4.73
X1956 VSS.t2090 VDD VSS.t2089 VSS.t2088 sky130_fd_pr__nfet_01v8 ad=0.143 pd=1.62 as=0 ps=0 w=0.55 l=4.73
X1957 VDD VSS.t3958 VDD VDD sky130_fd_pr__pfet_01v8_hvt ad=0.2262 pd=2.26 as=0 ps=0 w=0.87 l=4.73
X1958 _53_.X a_26339_15279# VSS.t67 VSS.t66 sky130_fd_pr__nfet_01v8 ad=0.08775 pd=0.92 as=0.08775 ps=0.92 w=0.65 l=0.15
X1959 VDD VSS.t3867 VDD VDD sky130_fd_pr__pfet_01v8_hvt ad=0.2262 pd=2.26 as=0 ps=0 w=0.87 l=4.73
X1960 VDD VSS.t4399 VDD VDD sky130_fd_pr__pfet_01v8_hvt ad=0.2262 pd=2.26 as=0 ps=0 w=0.87 l=4.73
X1961 VDD a_4675_16519# output3.A.t1 VDD sky130_fd_pr__pfet_01v8_hvt ad=0.135 pd=1.27 as=0.26 ps=2.52 w=1 l=0.15
X1962 VSS.t2311 VDD VSS.t2310 VSS.t2309 sky130_fd_pr__nfet_01v8 ad=0.143 pd=1.62 as=0 ps=0 w=0.55 l=4.73
X1963 VDD a_21914_15823.t17 _77_.CLK VDD sky130_fd_pr__pfet_01v8_hvt ad=0.14 pd=1.28 as=0.14 ps=1.28 w=1 l=0.15
X1964 VSS.t702 VDD VSS.t701 VSS.t700 sky130_fd_pr__nfet_01v8 ad=0.143 pd=1.62 as=0 ps=0 w=0.55 l=4.73
X1965 VDD VSS.t4372 VDD VDD sky130_fd_pr__pfet_01v8_hvt ad=0.2262 pd=2.26 as=0 ps=0 w=0.87 l=0.59
X1966 VDD VSS.t3861 VDD VDD sky130_fd_pr__pfet_01v8_hvt ad=0.2262 pd=2.26 as=0 ps=0 w=0.87 l=4.73
X1967 VDD VSS.t4002 VDD VDD sky130_fd_pr__pfet_01v8_hvt ad=0.2262 pd=2.26 as=0 ps=0 w=0.87 l=4.73
X1968 VDD VSS.t4295 VDD VDD sky130_fd_pr__pfet_01v8_hvt ad=0.2262 pd=2.26 as=0 ps=0 w=0.87 l=4.73
X1969 a_4771_16341# a_5055_16341.t4 a_4990_16367# VSS.t85 sky130_fd_pr__special_nfet_01v8 ad=0.0684 pd=0.74 as=0.066 ps=0.745 w=0.36 l=0.15
X1970 VSS.t674 VDD VSS.t673 VSS.t672 sky130_fd_pr__nfet_01v8 ad=0.143 pd=1.62 as=0 ps=0 w=0.55 l=4.73
X1971 VSS.t1278 VDD VSS.t1278 VSS.t1273 sky130_fd_pr__nfet_01v8 ad=0.143 pd=1.62 as=0 ps=0 w=0.55 l=0.59
X1972 VSS.t1535 VDD VSS.t1534 VSS.t1533 sky130_fd_pr__nfet_01v8 ad=0.143 pd=1.62 as=0 ps=0 w=0.55 l=1.97
X1973 VSS.t2320 VDD VSS.t2319 VSS.t2318 sky130_fd_pr__nfet_01v8 ad=0.143 pd=1.62 as=0 ps=0 w=0.55 l=4.73
X1974 VDD VSS.t4150 VDD VDD sky130_fd_pr__pfet_01v8_hvt ad=0.2262 pd=2.26 as=0 ps=0 w=0.87 l=4.73
X1975 a_18225_16733# a_17691_16367# a_18130_16733# VDD sky130_fd_pr__pfet_01v8_hvt ad=0.07665 pd=0.785 as=0.06825 ps=0.745 w=0.42 l=0.15
X1976 VDD _40_.Y a_20540_16617# VDD sky130_fd_pr__pfet_01v8_hvt ad=0.14 pd=1.28 as=0.14 ps=1.28 w=1 l=0.15
X1977 VDD VSS.t4205 VDD VDD sky130_fd_pr__pfet_01v8_hvt ad=0.2262 pd=2.26 as=0 ps=0 w=0.87 l=4.73
X1978 VDD VSS.t3636 VDD VDD sky130_fd_pr__pfet_01v8_hvt ad=0.2262 pd=2.26 as=0 ps=0 w=0.87 l=4.73
X1979 VSS.t419 VDD VSS.t418 VSS.t417 sky130_fd_pr__nfet_01v8 ad=0.143 pd=1.62 as=0 ps=0 w=0.55 l=4.73
X1980 VSS.t1511 VDD VSS.t1510 VSS.t1509 sky130_fd_pr__nfet_01v8 ad=0.143 pd=1.62 as=0 ps=0 w=0.55 l=4.73
X1981 VDD _43_.A.t3 a_20359_14735# VDD sky130_fd_pr__pfet_01v8_hvt ad=0.135 pd=1.27 as=0.26 ps=2.52 w=1 l=0.15
X1982 VSS.t1062 VDD VSS.t1061 VSS.t1058 sky130_fd_pr__nfet_01v8 ad=0.143 pd=1.62 as=0 ps=0 w=0.55 l=1.97
X1983 VSS.t1042 VDD VSS.t1041 VSS.t1040 sky130_fd_pr__nfet_01v8 ad=0.143 pd=1.62 as=0 ps=0 w=0.55 l=4.73
X1984 VDD VSS.t3583 VDD VDD sky130_fd_pr__pfet_01v8_hvt ad=0.2262 pd=2.26 as=0 ps=0 w=0.87 l=1.97
X1985 VDD VSS.t3906 VDD VDD sky130_fd_pr__pfet_01v8_hvt ad=0.2262 pd=2.26 as=0 ps=0 w=0.87 l=4.73
X1986 a_9523_16143# _67_.B VDD VDD sky130_fd_pr__pfet_01v8_hvt ad=0.135 pd=1.27 as=0.3 ps=2.6 w=1 l=0.15
X1987 VDD VSS.t3586 VDD VDD sky130_fd_pr__pfet_01v8_hvt ad=0.2262 pd=2.26 as=0 ps=0 w=0.87 l=4.73
X1988 VDD VSS.t1396 VDD VDD sky130_fd_pr__pfet_01v8_hvt ad=0.2262 pd=2.26 as=0 ps=0 w=0.87 l=4.73
X1989 VDD VSS.t3939 VDD VDD sky130_fd_pr__pfet_01v8_hvt ad=0.2262 pd=2.26 as=0 ps=0 w=0.87 l=4.73
X1990 VDD VSS.t4023 VDD VDD sky130_fd_pr__pfet_01v8_hvt ad=0.2262 pd=2.26 as=0 ps=0 w=0.87 l=4.73
X1991 VDD a_20407_15431# _77_.Q VDD sky130_fd_pr__pfet_01v8_hvt ad=0.135 pd=1.27 as=0.26 ps=2.52 w=1 l=0.15
X1992 VDD VSS.t3676 VDD VDD sky130_fd_pr__pfet_01v8_hvt ad=0.2262 pd=2.26 as=0 ps=0 w=0.87 l=4.73
X1993 VDD VSS.t4400 VDD VDD sky130_fd_pr__pfet_01v8_hvt ad=0.2262 pd=2.26 as=0 ps=0 w=0.87 l=4.73
X1994 VDD a_11413_16341.t26 _75_.CLK VDD sky130_fd_pr__pfet_01v8_hvt ad=0.14 pd=1.28 as=0.14 ps=1.28 w=1 l=0.15
X1995 VSS.t2768 VDD VSS.t2767 VSS.t2766 sky130_fd_pr__nfet_01v8 ad=0.143 pd=1.62 as=0 ps=0 w=0.55 l=4.73
X1996 VDD a_28433_17143# _54_.A VDD sky130_fd_pr__pfet_01v8_hvt ad=0.14075 pd=1.325 as=0.26 ps=2.52 w=1 l=0.15
X1997 VDD VSS.t4288 VDD VDD sky130_fd_pr__pfet_01v8_hvt ad=0.2262 pd=2.26 as=0 ps=0 w=0.87 l=4.73
X1998 _43_.X a_20359_14735# VDD VDD sky130_fd_pr__pfet_01v8_hvt ad=0.135 pd=1.27 as=0.135 ps=1.27 w=1 l=0.15
X1999 VDD VSS.t3514 VDD VDD sky130_fd_pr__pfet_01v8_hvt ad=0.2262 pd=2.26 as=0 ps=0 w=0.87 l=4.73
X2000 VDD VSS.t3001 VDD VDD sky130_fd_pr__pfet_01v8_hvt ad=0.2262 pd=2.26 as=0 ps=0 w=0.87 l=0.59
X2001 VDD VSS.t380 VDD VDD sky130_fd_pr__pfet_01v8_hvt ad=0.2262 pd=2.26 as=0 ps=0 w=0.87 l=1.97
X2002 VDD VSS.t2686 VDD VDD sky130_fd_pr__pfet_01v8_hvt ad=0.2262 pd=2.26 as=0 ps=0 w=0.87 l=4.73
X2003 VSS.t2263 VDD VSS.t2262 VSS.t2261 sky130_fd_pr__nfet_01v8 ad=0.143 pd=1.62 as=0 ps=0 w=0.55 l=4.73
X2004 hold12.A _54_.Y a_26965_16617# VDD sky130_fd_pr__pfet_01v8_hvt ad=0.155 pd=1.31 as=0.135 ps=1.27 w=1 l=0.15
X2005 VSS.t1696 VDD VSS.t1695 VSS.t1694 sky130_fd_pr__nfet_01v8 ad=0.143 pd=1.62 as=0 ps=0 w=0.55 l=1.97
X2006 VDD VSS.t3976 VDD VDD sky130_fd_pr__pfet_01v8_hvt ad=0.2262 pd=2.26 as=0 ps=0 w=0.87 l=4.73
X2007 VSS.t2631 VDD VSS.t2630 VSS.t2629 sky130_fd_pr__nfet_01v8 ad=0.143 pd=1.62 as=0 ps=0 w=0.55 l=4.73
X2008 VSS.t2577 VDD VSS.t2576 VSS.t2575 sky130_fd_pr__nfet_01v8 ad=0.143 pd=1.62 as=0 ps=0 w=0.55 l=4.73
X2009 VDD a_18298_16479# a_18225_16733# VDD sky130_fd_pr__pfet_01v8_hvt ad=0.17887 pd=1.26 as=0.07665 ps=0.785 w=0.42 l=0.15
X2010 VSS.t1269 VDD VSS.t1268 VSS.t1267 sky130_fd_pr__nfet_01v8 ad=0.143 pd=1.62 as=0 ps=0 w=0.55 l=4.73
X2011 VSS.t1111 VDD VSS.t1110 VSS.t1109 sky130_fd_pr__nfet_01v8 ad=0.143 pd=1.62 as=0 ps=0 w=0.55 l=4.73
X2012 VDD VSS.t3508 VDD VDD sky130_fd_pr__pfet_01v8_hvt ad=0.2262 pd=2.26 as=0 ps=0 w=0.87 l=1.97
X2013 VDD VSS.t4080 VDD VDD sky130_fd_pr__pfet_01v8_hvt ad=0.2262 pd=2.26 as=0 ps=0 w=0.87 l=4.73
X2014 VSS.t2777 VDD VSS.t2776 VSS.t2775 sky130_fd_pr__nfet_01v8 ad=0.143 pd=1.62 as=0 ps=0 w=0.55 l=4.73
X2015 VSS.t1520 VDD VSS.t1519 VSS.t1518 sky130_fd_pr__nfet_01v8 ad=0.143 pd=1.62 as=0 ps=0 w=0.55 l=1.97
X2016 VDD VSS.t3663 VDD VDD sky130_fd_pr__pfet_01v8_hvt ad=0.2262 pd=2.26 as=0 ps=0 w=0.87 l=1.97
X2017 VDD VSS.t3487 VDD VDD sky130_fd_pr__pfet_01v8_hvt ad=0.2262 pd=2.26 as=0 ps=0 w=0.87 l=4.73
X2018 VSS.t3290 _69_.A a_10883_15823# VSS.t3323 sky130_fd_pr__nfet_01v8 ad=0.0754 pd=0.81 as=0.1352 ps=1.56 w=0.52 l=0.15
X2019 VDD VSS.t4337 VDD VDD sky130_fd_pr__pfet_01v8_hvt ad=0.2262 pd=2.26 as=0 ps=0 w=0.87 l=2.89
X2020 VDD VSS.t4331 VDD VDD sky130_fd_pr__pfet_01v8_hvt ad=0.2262 pd=2.26 as=0 ps=0 w=0.87 l=2.89
X2021 VSS.t1783 VDD VSS.t1782 VSS.t1781 sky130_fd_pr__nfet_01v8 ad=0.143 pd=1.62 as=0 ps=0 w=0.55 l=1.97
X2022 VDD VSS.t3625 VDD VDD sky130_fd_pr__pfet_01v8_hvt ad=0.2262 pd=2.26 as=0 ps=0 w=0.87 l=4.73
X2023 VSS.t908 VDD VSS.t907 VSS.t906 sky130_fd_pr__nfet_01v8 ad=0.143 pd=1.62 as=0 ps=0 w=0.55 l=4.73
X2024 VDD VSS.t4161 VDD VDD sky130_fd_pr__pfet_01v8_hvt ad=0.2262 pd=2.26 as=0 ps=0 w=0.87 l=4.73
X2025 a_28943_16733# a_28161_16367# a_28859_16733# VDD sky130_fd_pr__pfet_01v8_hvt ad=0.0882 pd=0.84 as=0.0567 ps=0.69 w=0.42 l=0.15
X2026 a_23833_15279# a_22843_15279# a_23707_15645# VSS.t199 sky130_fd_pr__special_nfet_01v8 ad=0.066 pd=0.745 as=0.0684 ps=0.74 w=0.36 l=0.15
X2027 VSS.t3154 VDD VSS.t3153 VSS.t3152 sky130_fd_pr__nfet_01v8 ad=0.143 pd=1.62 as=0 ps=0 w=0.55 l=0.59
X2028 VDD VSS.t3454 VDD VDD sky130_fd_pr__pfet_01v8_hvt ad=0.2262 pd=2.26 as=0 ps=0 w=0.87 l=0.59
X2029 VSS.t1821 VDD VSS.t1820 VSS.t1819 sky130_fd_pr__nfet_01v8 ad=0.143 pd=1.62 as=0 ps=0 w=0.55 l=4.73
X2030 VDD VSS.t4043 VDD VDD sky130_fd_pr__pfet_01v8_hvt ad=0.2262 pd=2.26 as=0 ps=0 w=0.87 l=4.73
X2031 a_21003_16617# _77_.Q VDD VDD sky130_fd_pr__pfet_01v8_hvt ad=0.0693 pd=0.75 as=0.14825 ps=1.34 w=0.42 l=0.15
X2032 VSS.t3193 VDD VSS.t3192 VSS.t3191 sky130_fd_pr__nfet_01v8 ad=0.143 pd=1.62 as=0 ps=0 w=0.55 l=4.73
X2033 VSS.t2010 VDD VSS.t2009 VSS.t2008 sky130_fd_pr__nfet_01v8 ad=0.143 pd=1.62 as=0 ps=0 w=0.55 l=4.73
X2034 VDD VSS.t4247 VDD VDD sky130_fd_pr__pfet_01v8_hvt ad=0.2262 pd=2.26 as=0 ps=0 w=0.87 l=1.97
X2035 VSS.t3049 VDD VSS.t3048 VSS.t3047 sky130_fd_pr__nfet_01v8 ad=0.143 pd=1.62 as=0 ps=0 w=0.55 l=4.73
X2036 VDD output3.A.t9 _36_.B.t0 VDD sky130_fd_pr__pfet_01v8_hvt ad=0.135 pd=1.27 as=0.135 ps=1.27 w=1 l=0.15
X2037 VDD a_16762_15823.t10 clkbuf_0_clock_i.X VDD sky130_fd_pr__pfet_01v8_hvt ad=0.14 pd=1.28 as=0.14 ps=1.28 w=1 l=0.15
X2038 VSS.t1914 VDD VSS.t1913 VSS.t1912 sky130_fd_pr__nfet_01v8 ad=0.143 pd=1.62 as=0 ps=0 w=0.55 l=1.97
X2039 VDD VSS.t3601 VDD VDD sky130_fd_pr__pfet_01v8_hvt ad=0.2262 pd=2.26 as=0 ps=0 w=0.87 l=4.73
X2040 VSS.t1974 VDD VSS.t1973 VSS.t1972 sky130_fd_pr__nfet_01v8 ad=0.143 pd=1.62 as=0 ps=0 w=0.55 l=4.73
X2041 VSS.t3369 _64_.X.t3 a_6927_16911# VSS.t3368 sky130_fd_pr__nfet_01v8 ad=0.0754 pd=0.81 as=0.1352 ps=1.56 w=0.52 l=0.15
X2042 VDD VSS.t3895 VDD VDD sky130_fd_pr__pfet_01v8_hvt ad=0.2262 pd=2.26 as=0 ps=0 w=0.87 l=4.73
X2043 VSS.t1308 VDD VSS.t1307 VSS.t1306 sky130_fd_pr__nfet_01v8 ad=0.143 pd=1.62 as=0 ps=0 w=0.55 l=4.73
X2044 VSS.t285 VDD VSS.t284 VSS.t283 sky130_fd_pr__nfet_01v8 ad=0.143 pd=1.62 as=0 ps=0 w=0.55 l=4.73
X2045 VSS.t2893 VDD VSS.t2893 VSS.t2892 sky130_fd_pr__nfet_01v8 ad=0.143 pd=1.62 as=0 ps=0 w=0.55 l=0.59
X2046 VDD VSS.t4031 VDD VDD sky130_fd_pr__pfet_01v8_hvt ad=0.2262 pd=2.26 as=0 ps=0 w=0.87 l=4.73
X2047 a_23024_16617# _46_.X VDD VDD sky130_fd_pr__pfet_01v8_hvt ad=0.265 pd=2.53 as=0.14 ps=1.28 w=1 l=0.15
X2048 VSS.t2260 VDD VSS.t2259 VSS.t2258 sky130_fd_pr__nfet_01v8 ad=0.143 pd=1.62 as=0 ps=0 w=0.55 l=4.73
X2049 VDD VSS.t4136 VDD VDD sky130_fd_pr__pfet_01v8_hvt ad=0.2262 pd=2.26 as=0 ps=0 w=0.87 l=4.73
X2050 VSS.t372 VDD VSS.t371 VSS.t370 sky130_fd_pr__nfet_01v8 ad=0.143 pd=1.62 as=0 ps=0 w=0.55 l=0.59
X2051 VSS.t1693 VDD VSS.t1692 VSS.t1691 sky130_fd_pr__nfet_01v8 ad=0.143 pd=1.62 as=0 ps=0 w=0.55 l=4.73
X2052 VDD VSS.t397 VDD VDD sky130_fd_pr__pfet_01v8_hvt ad=0.2262 pd=2.26 as=0 ps=0 w=0.87 l=0.59
X2053 VDD VSS.t3915 VDD VDD sky130_fd_pr__pfet_01v8_hvt ad=0.2262 pd=2.26 as=0 ps=0 w=0.87 l=4.73
X2054 VDD VSS.t3689 VDD VDD sky130_fd_pr__pfet_01v8_hvt ad=0.2262 pd=2.26 as=0 ps=0 w=0.87 l=4.73
X2055 _36_.B.t0 input1.X.t12 VDD VDD sky130_fd_pr__pfet_01v8_hvt ad=0.135 pd=1.27 as=0.395 ps=1.79 w=1 l=0.15
X2056 VSS.t2019 VDD VSS.t2018 VSS.t2017 sky130_fd_pr__nfet_01v8 ad=0.143 pd=1.62 as=0 ps=0 w=0.55 l=4.73
X2057 VDD VSS.t1608 VDD VDD sky130_fd_pr__pfet_01v8_hvt ad=0.2262 pd=2.26 as=0 ps=0 w=0.87 l=4.73
X2058 VSS.t1448 VDD VSS.t1447 VSS.t1446 sky130_fd_pr__nfet_01v8 ad=0.143 pd=1.62 as=0 ps=0 w=0.55 l=4.73
X2059 VDD VSS.t4173 VDD VDD sky130_fd_pr__pfet_01v8_hvt ad=0.2262 pd=2.26 as=0 ps=0 w=0.87 l=4.73
X2060 VDD VSS.t3617 VDD VDD sky130_fd_pr__pfet_01v8_hvt ad=0.2262 pd=2.26 as=0 ps=0 w=0.87 l=1.97
X2061 VDD VSS.t4202 VDD VDD sky130_fd_pr__pfet_01v8_hvt ad=0.2262 pd=2.26 as=0 ps=0 w=0.87 l=4.73
X2062 VSS.t2240 VDD VSS.t2239 VSS.t2238 sky130_fd_pr__nfet_01v8 ad=0.143 pd=1.62 as=0 ps=0 w=0.55 l=4.73
X2063 VDD VSS.t3949 VDD VDD sky130_fd_pr__pfet_01v8_hvt ad=0.2262 pd=2.26 as=0 ps=0 w=0.87 l=4.73
X2064 VDD VSS.t4091 VDD VDD sky130_fd_pr__pfet_01v8_hvt ad=0.2262 pd=2.26 as=0 ps=0 w=0.87 l=4.73
X2065 VSS.t914 VDD VSS.t913 VSS.t912 sky130_fd_pr__nfet_01v8 ad=0.143 pd=1.62 as=0 ps=0 w=0.55 l=4.73
X2066 VDD VSS.t4181 VDD VDD sky130_fd_pr__pfet_01v8_hvt ad=0.2262 pd=2.26 as=0 ps=0 w=0.87 l=4.73
X2067 VSS.t100 _60_.B a_4193_16161# VSS.t252 sky130_fd_pr__nfet_01v8 ad=0.1118 pd=1.04 as=0.0567 ps=0.69 w=0.42 l=0.15
X2068 _77_.CLK a_21914_15823.t10 VDD VDD sky130_fd_pr__pfet_01v8_hvt ad=0.14 pd=1.28 as=0.14 ps=1.28 w=1 l=0.15
X2069 VDD VSS.t3664 VDD VDD sky130_fd_pr__pfet_01v8_hvt ad=0.2262 pd=2.26 as=0 ps=0 w=0.87 l=4.73
X2070 VDD VSS.t3872 VDD VDD sky130_fd_pr__pfet_01v8_hvt ad=0.2262 pd=2.26 as=0 ps=0 w=0.87 l=4.73
X2071 VDD VSS.t2033 VDD VDD sky130_fd_pr__pfet_01v8_hvt ad=0.2262 pd=2.26 as=0 ps=0 w=0.87 l=0.59
X2072 a_18045_16367# _38_.X VDD VDD sky130_fd_pr__pfet_01v8_hvt ad=0.05775 pd=0.695 as=0.1092 ps=1.36 w=0.42 l=0.15
X2073 VDD VSS.t3650 VDD VDD sky130_fd_pr__pfet_01v8_hvt ad=0.2262 pd=2.26 as=0 ps=0 w=0.87 l=4.73
X2074 VDD VSS.t3844 VDD VDD sky130_fd_pr__pfet_01v8_hvt ad=0.2262 pd=2.26 as=0 ps=0 w=0.87 l=4.73
X2075 VSS.t2649 VDD VSS.t2648 VSS.t2647 sky130_fd_pr__nfet_01v8 ad=0.143 pd=1.62 as=0 ps=0 w=0.55 l=4.73
X2076 a_20503_15253# a_20787_15253.t4 a_20722_15279# VSS.t3251 sky130_fd_pr__special_nfet_01v8 ad=0.0684 pd=0.74 as=0.066 ps=0.745 w=0.36 l=0.15
X2077 VSS.t147 input1.X.t15 a_3807_16617# VSS.t3260 sky130_fd_pr__nfet_01v8 ad=0.08775 pd=0.92 as=0.08775 ps=0.92 w=0.65 l=0.15
X2078 VSS.t2899 VDD VSS.t2898 VSS.t2897 sky130_fd_pr__nfet_01v8 ad=0.143 pd=1.62 as=0 ps=0 w=0.55 l=2.89
X2079 VSS.t2813 VDD VSS.t2812 VSS.t2811 sky130_fd_pr__nfet_01v8 ad=0.143 pd=1.62 as=0 ps=0 w=0.55 l=1.97
X2080 VDD VSS.t4273 VDD VDD sky130_fd_pr__pfet_01v8_hvt ad=0.2262 pd=2.26 as=0 ps=0 w=0.87 l=1.05
X2081 VDD VSS.t4323 VDD VDD sky130_fd_pr__pfet_01v8_hvt ad=0.2262 pd=2.26 as=0 ps=0 w=0.87 l=4.73
X2082 VSS.t82 a_16762_15823.t32 clkbuf_0_clock_i.X VSS.t160 sky130_fd_pr__nfet_01v8 ad=0.0588 pd=0.7 as=0.0588 ps=0.7 w=0.42 l=0.15
X2083 VSS.t2804 VDD VSS.t2803 VSS.t2802 sky130_fd_pr__nfet_01v8 ad=0.143 pd=1.62 as=0 ps=0 w=0.55 l=4.73
X2084 VDD VSS.t3856 VDD VDD sky130_fd_pr__pfet_01v8_hvt ad=0.2262 pd=2.26 as=0 ps=0 w=0.87 l=4.73
X2085 a_9727_16367# _67_.A.t8 _36_.B VSS.t39 sky130_fd_pr__nfet_01v8 ad=0.08775 pd=0.92 as=0.08775 ps=0.92 w=0.65 l=0.15
X2086 VSS.t3255 a_16762_15823.t22 clkbuf_0_clock_i.X VSS.t3254 sky130_fd_pr__nfet_01v8 ad=0.1113 pd=1.37 as=0.0588 ps=0.7 w=0.42 l=0.15
X2087 VDD VSS.t4011 VDD VDD sky130_fd_pr__pfet_01v8_hvt ad=0.2262 pd=2.26 as=0 ps=0 w=0.87 l=4.73
X2088 VSS.t279 VDD VSS.t278 VSS.t277 sky130_fd_pr__nfet_01v8 ad=0.143 pd=1.62 as=0 ps=0 w=0.55 l=4.73
X2089 VSS.t647 VDD VSS.t646 VSS.t645 sky130_fd_pr__nfet_01v8 ad=0.143 pd=1.62 as=0 ps=0 w=0.55 l=4.73
X2090 VDD VSS.t3614 VDD VDD sky130_fd_pr__pfet_01v8_hvt ad=0.2262 pd=2.26 as=0 ps=0 w=0.87 l=4.73
X2091 VDD VSS.t4066 VDD VDD sky130_fd_pr__pfet_01v8_hvt ad=0.2262 pd=2.26 as=0 ps=0 w=0.87 l=4.73
X2092 a_9369_16367# _63_.A.t7 a_8951_16367# VSS.t3272 sky130_fd_pr__nfet_01v8 ad=0.08775 pd=0.92 as=0.08775 ps=0.92 w=0.65 l=0.15
X2093 VDD input1.X.t18 _63_.B VDD sky130_fd_pr__pfet_01v8_hvt ad=0.26 pd=2.52 as=0.135 ps=1.27 w=1 l=0.15
X2094 VSS.t1911 VDD VSS.t1910 VSS.t1909 sky130_fd_pr__nfet_01v8 ad=0.143 pd=1.62 as=0 ps=0 w=0.55 l=4.73
X2095 VSS.t3 a_20868_16519# _42_.A2 VSS.t18 sky130_fd_pr__nfet_01v8 ad=0.10187 pd=0.99 as=0.182 ps=1.86 w=0.65 l=0.15
X2096 VDD a_21914_15823.t19 _77_.CLK VDD sky130_fd_pr__pfet_01v8_hvt ad=0.14 pd=1.28 as=0.14 ps=1.28 w=1 l=0.15
X2097 _48_.X a_23027_14735# VSS.t178 VSS.t225 sky130_fd_pr__nfet_01v8 ad=0.08775 pd=0.92 as=0.08775 ps=0.92 w=0.65 l=0.15
X2098 VSS.t381 VDD VSS.t380 VSS.t379 sky130_fd_pr__nfet_01v8 ad=0.143 pd=1.62 as=0 ps=0 w=0.55 l=1.97
X2099 VSS.t955 VDD VSS.t955 VSS.t954 sky130_fd_pr__nfet_01v8 ad=0.143 pd=1.62 as=0 ps=0 w=0.55 l=0.59
X2100 VSS.t3399 reset_n_i a_1407_9839# VSS.t3442 sky130_fd_pr__nfet_01v8 ad=0.097 pd=0.975 as=0.1092 ps=1.36 w=0.42 l=0.15
X2101 VDD VSS.t3841 VDD VDD sky130_fd_pr__pfet_01v8_hvt ad=0.2262 pd=2.26 as=0 ps=0 w=0.87 l=4.73
X2102 _51_.X.t0 a_24777_15939# VSS.t436 VSS.t3427 sky130_fd_pr__nfet_01v8 ad=0.182 pd=1.86 as=0.10187 ps=0.99 w=0.65 l=0.15
X2103 VDD VSS.t3540 VDD VDD sky130_fd_pr__pfet_01v8_hvt ad=0.2262 pd=2.26 as=0 ps=0 w=0.87 l=4.73
X2104 VSS.t3145 VDD VSS.t3144 VSS.t3143 sky130_fd_pr__nfet_01v8 ad=0.143 pd=1.62 as=0 ps=0 w=0.55 l=0.59
X2105 VDD VSS.t4103 VDD VDD sky130_fd_pr__pfet_01v8_hvt ad=0.2262 pd=2.26 as=0 ps=0 w=0.87 l=4.73
X2106 VSS.t2455 VDD VSS.t2454 VSS.t2453 sky130_fd_pr__nfet_01v8 ad=0.143 pd=1.62 as=0 ps=0 w=0.55 l=4.73
X2107 VDD VSS.t3769 VDD VDD sky130_fd_pr__pfet_01v8_hvt ad=0.2262 pd=2.26 as=0 ps=0 w=0.87 l=4.73
X2108 VDD VSS.t3478 VDD VDD sky130_fd_pr__pfet_01v8_hvt ad=0.2262 pd=2.26 as=0 ps=0 w=0.87 l=0.59
X2109 _77_.CLK a_21914_15823.t30 VSS.t3408 VSS.t3407 sky130_fd_pr__nfet_01v8 ad=0.0588 pd=0.7 as=0.05775 ps=0.695 w=0.42 l=0.15
X2110 VDD VSS.t4200 VDD VDD sky130_fd_pr__pfet_01v8_hvt ad=0.2262 pd=2.26 as=0 ps=0 w=0.87 l=4.73
X2111 VDD VSS.t4178 VDD VDD sky130_fd_pr__pfet_01v8_hvt ad=0.2262 pd=2.26 as=0 ps=0 w=0.87 l=4.73
X2112 VDD VSS.t4111 VDD VDD sky130_fd_pr__pfet_01v8_hvt ad=0.2262 pd=2.26 as=0 ps=0 w=0.87 l=4.73
X2113 VSS.t2066 VDD VSS.t2065 VSS.t2064 sky130_fd_pr__nfet_01v8 ad=0.143 pd=1.62 as=0 ps=0 w=0.55 l=4.73
X2114 VDD VSS.t3947 VDD VDD sky130_fd_pr__pfet_01v8_hvt ad=0.2262 pd=2.26 as=0 ps=0 w=0.87 l=1.97
X2115 VDD VSS.t2248 VDD VDD sky130_fd_pr__pfet_01v8_hvt ad=0.2262 pd=2.26 as=0 ps=0 w=0.87 l=0.59
X2116 VDD VSS.t4014 VDD VDD sky130_fd_pr__pfet_01v8_hvt ad=0.2262 pd=2.26 as=0 ps=0 w=0.87 l=4.73
X2117 clkbuf_0_clock_i.X a_16762_15823.t31 VSS.t82 VSS.t81 sky130_fd_pr__nfet_01v8 ad=0.0588 pd=0.7 as=0.0588 ps=0.7 w=0.42 l=0.15
X2118 VDD VSS.t3591 VDD VDD sky130_fd_pr__pfet_01v8_hvt ad=0.2262 pd=2.26 as=0 ps=0 w=0.87 l=4.73
X2119 VDD VSS.t3826 VDD VDD sky130_fd_pr__pfet_01v8_hvt ad=0.2262 pd=2.26 as=0 ps=0 w=0.87 l=4.73
X2120 VSS.t3235 VDD VSS.t3234 VSS.t3233 sky130_fd_pr__nfet_01v8 ad=0.143 pd=1.62 as=0 ps=0 w=0.55 l=0.59
X2121 VSS.t2057 VDD VSS.t2056 VSS.t2055 sky130_fd_pr__nfet_01v8 ad=0.143 pd=1.62 as=0 ps=0 w=0.55 l=4.73
X2122 VDD VSS.t3563 VDD VDD sky130_fd_pr__pfet_01v8_hvt ad=0.2262 pd=2.26 as=0 ps=0 w=0.87 l=1.97
X2123 VDD VSS.t3501 VDD VDD sky130_fd_pr__pfet_01v8_hvt ad=0.2262 pd=2.26 as=0 ps=0 w=0.87 l=4.73
X2124 a_18298_16479# a_18130_16733# VSS.t134 VSS.t262 sky130_fd_pr__nfet_01v8 ad=0.0989 pd=0.995 as=0.12095 ps=1.085 w=0.64 l=0.15
X2125 VSS.t491 VDD VSS.t490 VSS.t489 sky130_fd_pr__nfet_01v8 ad=0.143 pd=1.62 as=0 ps=0 w=0.55 l=2.89
X2126 VSS.t507 VDD VSS.t3 VSS.t506 sky130_fd_pr__nfet_01v8 ad=0.143 pd=1.62 as=0 ps=0 w=0.55 l=2.89
X2127 VSS.t405 VDD VSS.t405 VSS.t404 sky130_fd_pr__nfet_01v8 ad=0.143 pd=1.62 as=0 ps=0 w=0.55 l=0.59
X2128 VSS.t1221 VDD VSS.t1220 VSS.t1219 sky130_fd_pr__nfet_01v8 ad=0.143 pd=1.62 as=0 ps=0 w=0.55 l=1.97
X2129 a_20868_16519# _36_.B.t19 a_21099_16617# VDD sky130_fd_pr__pfet_01v8_hvt ad=0.1092 pd=1.36 as=0.0441 ps=0.63 w=0.42 l=0.15
X2130 VDD VSS.t3883 VDD VDD sky130_fd_pr__pfet_01v8_hvt ad=0.2262 pd=2.26 as=0 ps=0 w=0.87 l=4.73
X2131 VDD VSS.t3458 VDD VDD sky130_fd_pr__pfet_01v8_hvt ad=0.2262 pd=2.26 as=0 ps=0 w=0.87 l=4.73
X2132 VDD VSS.t468 VDD VDD sky130_fd_pr__pfet_01v8_hvt ad=0.2262 pd=2.26 as=0 ps=0 w=0.87 l=0.59
X2133 VDD VSS.t3935 VDD VDD sky130_fd_pr__pfet_01v8_hvt ad=0.2262 pd=2.26 as=0 ps=0 w=0.87 l=4.73
X2134 VSS.t1821 VDD VSS.t1820 VSS.t1819 sky130_fd_pr__nfet_01v8 ad=0.143 pd=1.62 as=0 ps=0 w=0.55 l=4.73
X2135 VDD a_20359_14735# _43_.X VDD sky130_fd_pr__pfet_01v8_hvt ad=0.135 pd=1.27 as=0.135 ps=1.27 w=1 l=0.15
X2136 VSS.t2296 VDD VSS.t2295 VSS.t2294 sky130_fd_pr__nfet_01v8 ad=0.143 pd=1.62 as=0 ps=0 w=0.55 l=4.73
X2137 hold12.X a_28359_15823# VDD VDD sky130_fd_pr__pfet_01v8_hvt ad=0.26 pd=2.52 as=0.14075 ps=1.325 w=1 l=0.15
X2138 VDD VSS.t3699 VDD VDD sky130_fd_pr__pfet_01v8_hvt ad=0.2262 pd=2.26 as=0 ps=0 w=0.87 l=4.73
X2139 VDD _57_.Y a_26799_16367# VDD sky130_fd_pr__pfet_01v8_hvt ad=0.135 pd=1.27 as=0.26 ps=2.52 w=1 l=0.15
X2140 VDD VSS.t397 VDD VDD sky130_fd_pr__pfet_01v8_hvt ad=0.2262 pd=2.26 as=0 ps=0 w=0.87 l=0.59
X2141 VDD VSS.t4108 VDD VDD sky130_fd_pr__pfet_01v8_hvt ad=0.2262 pd=2.26 as=0 ps=0 w=0.87 l=4.73
X2142 _67_.B input1.X.t13 VDD VDD sky130_fd_pr__pfet_01v8_hvt ad=0.26 pd=2.52 as=0.165 ps=1.33 w=1 l=0.15
X2143 VSS.t3172 VDD VSS.t3171 VSS.t3170 sky130_fd_pr__nfet_01v8 ad=0.143 pd=1.62 as=0 ps=0 w=0.55 l=0.59
X2144 VSS.t12 a_28602_16479# a_28560_16367# VSS.t11 sky130_fd_pr__nfet_01v8 ad=0.12095 pd=1.085 as=0.0696 ps=0.765 w=0.42 l=0.15
X2145 VDD VSS.t3756 VDD VDD sky130_fd_pr__pfet_01v8_hvt ad=0.2262 pd=2.26 as=0 ps=0 w=0.87 l=4.73
X2146 VSS.t204 a_7716_16885# counter_value_o[1] VSS.t246 sky130_fd_pr__nfet_01v8 ad=0.097 pd=0.975 as=0.08775 ps=0.92 w=0.65 l=0.15
X2147 VDD VSS.t4362 VDD VDD sky130_fd_pr__pfet_01v8_hvt ad=0.2262 pd=2.26 as=0 ps=0 w=0.87 l=4.73
X2148 VSS.t2523 VDD VSS.t2522 VSS.t2521 sky130_fd_pr__nfet_01v8 ad=0.143 pd=1.62 as=0 ps=0 w=0.55 l=4.73
X2149 VDD VSS.t3902 VDD VDD sky130_fd_pr__pfet_01v8_hvt ad=0.2262 pd=2.26 as=0 ps=0 w=0.87 l=1.97
X2150 VSS.t2893 VDD VSS.t2893 VSS.t2892 sky130_fd_pr__nfet_01v8 ad=0.143 pd=1.62 as=0 ps=0 w=0.55 l=0.59
X2151 VDD VSS.t3929 VDD VDD sky130_fd_pr__pfet_01v8_hvt ad=0.2262 pd=2.26 as=0 ps=0 w=0.87 l=4.73
X2152 VDD _75_.CLK a_17691_16367# VDD sky130_fd_pr__pfet_01v8_hvt ad=0.0864 pd=0.91 as=0.1664 ps=1.8 w=0.64 l=0.15
X2153 VDD VSS.t4260 VDD VDD sky130_fd_pr__pfet_01v8_hvt ad=0.2262 pd=2.26 as=0 ps=0 w=0.87 l=4.73
X2154 VDD VSS.t4238 VDD VDD sky130_fd_pr__pfet_01v8_hvt ad=0.2262 pd=2.26 as=0 ps=0 w=0.87 l=4.73
X2155 VDD VSS.t3481 VDD VDD sky130_fd_pr__pfet_01v8_hvt ad=0.2262 pd=2.26 as=0 ps=0 w=0.87 l=0.59
X2156 a_4675_16519# a_4771_16341# VSS.t251 VSS.t250 sky130_fd_pr__nfet_01v8 ad=0.169 pd=1.82 as=0.08775 ps=0.92 w=0.65 l=0.15
X2157 VDD VSS.t4338 VDD VDD sky130_fd_pr__pfet_01v8_hvt ad=0.2262 pd=2.26 as=0 ps=0 w=0.87 l=2.89
X2158 VSS.t3433 a_1407_3311# input1.X.t1 VSS.t3432 sky130_fd_pr__nfet_01v8 ad=0.17225 pd=1.83 as=0.08775 ps=0.92 w=0.65 l=0.15
X2159 VSS.t3294 _50_.B1.t5 _56_.Y VSS.t3293 sky130_fd_pr__nfet_01v8 ad=0.169 pd=1.82 as=0.169 ps=1.82 w=0.65 l=0.15
X2160 VSS.t2786 VDD VSS.t2786 VSS.t2781 sky130_fd_pr__nfet_01v8 ad=0.143 pd=1.62 as=0 ps=0 w=0.55 l=0.59
X2161 VSS.t3226 VDD VSS.t3225 VSS.t3224 sky130_fd_pr__nfet_01v8 ad=0.143 pd=1.62 as=0 ps=0 w=0.55 l=0.59
X2162 VSS.t1642 VDD VSS.t1641 VSS.t1640 sky130_fd_pr__nfet_01v8 ad=0.143 pd=1.62 as=0 ps=0 w=0.55 l=4.73
X2163 VDD VSS.t3997 VDD VDD sky130_fd_pr__pfet_01v8_hvt ad=0.2262 pd=2.26 as=0 ps=0 w=0.87 l=4.73
X2164 a_23282_15645# a_22843_15279# a_23197_15279# VSS.t198 sky130_fd_pr__special_nfet_01v8 ad=0.0621 pd=0.705 as=0.0813 ps=0.83 w=0.36 l=0.15
X2165 VDD VSS.t4386 VDD VDD sky130_fd_pr__pfet_01v8_hvt ad=0.2262 pd=2.26 as=0 ps=0 w=0.87 l=4.73
X2166 VDD VSS.t3817 VDD VDD sky130_fd_pr__pfet_01v8_hvt ad=0.2262 pd=2.26 as=0 ps=0 w=0.87 l=1.97
X2167 VSS.t1176 VDD VSS.t1175 VSS.t1174 sky130_fd_pr__nfet_01v8 ad=0.143 pd=1.62 as=0 ps=0 w=0.55 l=4.73
X2168 _60_.B output3.A.t12 a_4057_16367# VSS.t202 sky130_fd_pr__nfet_01v8 ad=0.25025 pd=1.42 as=0.08775 ps=0.92 w=0.65 l=0.15
X2169 VSS.t1036 VDD VSS.t1035 VSS.t1034 sky130_fd_pr__nfet_01v8 ad=0.143 pd=1.62 as=0 ps=0 w=0.55 l=1.97
X2170 VDD a_32503_16919# counter_value_o[6] VDD sky130_fd_pr__pfet_01v8_hvt ad=0.265 pd=2.53 as=0.135 ps=1.27 w=1 l=0.15
X2171 a_28859_16733# a_27995_16367# a_28602_16479# VDD sky130_fd_pr__pfet_01v8_hvt ad=0.0567 pd=0.69 as=0.1095 ps=1.075 w=0.42 l=0.15
X2172 VSS.t2607 VDD VSS.t2606 VSS.t2605 sky130_fd_pr__nfet_01v8 ad=0.143 pd=1.62 as=0 ps=0 w=0.55 l=4.73
X2173 _55_.Y a_27366_16055# VDD VDD sky130_fd_pr__pfet_01v8_hvt ad=0.135 pd=1.27 as=0.265 ps=2.53 w=1 l=0.15
X2174 VSS.t1078 VDD VSS.t1077 VSS.t1076 sky130_fd_pr__nfet_01v8 ad=0.143 pd=1.62 as=0 ps=0 w=0.55 l=4.73
X2175 VSS.t1063 VDD VSS.t1063 VSS.t1058 sky130_fd_pr__nfet_01v8 ad=0.143 pd=1.62 as=0 ps=0 w=0.55 l=0.59
X2176 VSS.t1144 VDD VSS.t1143 VSS.t1142 sky130_fd_pr__nfet_01v8 ad=0.143 pd=1.62 as=0 ps=0 w=0.55 l=4.73
X2177 VSS.t1394 VDD VSS.t1393 VSS.t1392 sky130_fd_pr__nfet_01v8 ad=0.143 pd=1.62 as=0 ps=0 w=0.55 l=4.73
X2178 counter_value_o[4] a_22843_16919# VSS.t5 VSS.t130 sky130_fd_pr__nfet_01v8 ad=0.08775 pd=0.92 as=0.097 ps=0.975 w=0.65 l=0.15
X2179 VSS.t691 VDD VSS.t599 VSS.t690 sky130_fd_pr__nfet_01v8 ad=0.143 pd=1.62 as=0 ps=0 w=0.55 l=1.05
X2180 VSS.t537 VDD VSS.t536 VSS.t535 sky130_fd_pr__nfet_01v8 ad=0.143 pd=1.62 as=0 ps=0 w=0.55 l=4.73
X2181 VDD VSS.t3567 VDD VDD sky130_fd_pr__pfet_01v8_hvt ad=0.2262 pd=2.26 as=0 ps=0 w=0.87 l=4.73
X2182 a_17652_16885# _36_.A.t10 VDD VDD sky130_fd_pr__pfet_01v8_hvt ad=0.1664 pd=1.8 as=0.149 ps=1.325 w=0.64 l=0.15
X2183 VSS.t2753 VDD VSS.t2752 VSS.t2751 sky130_fd_pr__nfet_01v8 ad=0.143 pd=1.62 as=0 ps=0 w=0.55 l=4.73
X2184 VSS.t1475 VDD VSS.t1474 VSS.t1473 sky130_fd_pr__nfet_01v8 ad=0.143 pd=1.62 as=0 ps=0 w=0.55 l=4.73
X2185 VDD VSS.t4164 VDD VDD sky130_fd_pr__pfet_01v8_hvt ad=0.2262 pd=2.26 as=0 ps=0 w=0.87 l=4.73
X2186 a_7783_16733# a_7001_16367# a_7699_16733# VDD sky130_fd_pr__pfet_01v8_hvt ad=0.0882 pd=0.84 as=0.0567 ps=0.69 w=0.42 l=0.15
X2187 VSS.t3375 a_27535_16919# counter_value_o[5] VSS.t3374 sky130_fd_pr__nfet_01v8 ad=0.17225 pd=1.83 as=0.08775 ps=0.92 w=0.65 l=0.15
X2188 VSS.t941 VDD VSS.t940 VSS.t939 sky130_fd_pr__nfet_01v8 ad=0.143 pd=1.62 as=0 ps=0 w=0.55 l=4.73
X2189 VSS.t3061 VDD VSS.t3060 VSS.t3059 sky130_fd_pr__nfet_01v8 ad=0.143 pd=1.62 as=0 ps=0 w=0.55 l=1.97
X2190 VDD VSS.t4356 VDD VDD sky130_fd_pr__pfet_01v8_hvt ad=0.2262 pd=2.26 as=0 ps=0 w=0.87 l=0.59
X2191 VSS.t3277 a_28787_16885# a_28529_16885# VSS.t3331 sky130_fd_pr__nfet_01v8 ad=0.0567 pd=0.69 as=0.1092 ps=1.36 w=0.42 l=0.5
X2192 VSS.t994 VDD VSS.t993 VSS.t992 sky130_fd_pr__nfet_01v8 ad=0.143 pd=1.62 as=0 ps=0 w=0.55 l=4.73
X2193 VSS.t2932 VDD VSS.t2931 VSS.t2930 sky130_fd_pr__nfet_01v8 ad=0.143 pd=1.62 as=0 ps=0 w=0.55 l=4.73
X2194 VDD VSS.t3645 VDD VDD sky130_fd_pr__pfet_01v8_hvt ad=0.2262 pd=2.26 as=0 ps=0 w=0.87 l=4.73
X2195 VSS.t1956 VDD VSS.t1955 VSS.t1954 sky130_fd_pr__nfet_01v8 ad=0.143 pd=1.62 as=0 ps=0 w=0.55 l=4.73
X2196 VSS.t1765 VDD VSS.t1764 VSS.t1763 sky130_fd_pr__nfet_01v8 ad=0.143 pd=1.62 as=0 ps=0 w=0.55 l=4.73
X2197 VDD VSS.t3597 VDD VDD sky130_fd_pr__pfet_01v8_hvt ad=0.2262 pd=2.26 as=0 ps=0 w=0.87 l=1.97
X2198 VDD VSS.t556 VDD VDD sky130_fd_pr__pfet_01v8_hvt ad=0.2262 pd=2.26 as=0 ps=0 w=0.87 l=4.73
X2199 input2.X.t0 a_1407_9839# VSS.t3399 VSS.t3398 sky130_fd_pr__nfet_01v8 ad=0.08775 pd=0.92 as=0.097 ps=0.975 w=0.65 l=0.15
X2200 VSS.t3280 _50_.A2 _57_.Y VSS.t3279 sky130_fd_pr__nfet_01v8 ad=0.08775 pd=0.92 as=0.169 ps=1.82 w=0.65 l=0.15
X2201 clkbuf_0_clock_i.X a_16762_15823.t25 VSS.t74 VSS.t3259 sky130_fd_pr__nfet_01v8 ad=0.0588 pd=0.7 as=0.0588 ps=0.7 w=0.42 l=0.15
X2202 VSS.t1860 VDD VSS.t1859 VSS.t1858 sky130_fd_pr__nfet_01v8 ad=0.143 pd=1.62 as=0 ps=0 w=0.55 l=4.73
X2203 a_6737_17231# output3.A.t18 VSS.t65 VSS.t64 sky130_fd_pr__nfet_01v8 ad=0.08775 pd=0.92 as=0.169 ps=1.82 w=0.65 l=0.15
X2204 VDD VSS.t3482 VDD VDD sky130_fd_pr__pfet_01v8_hvt ad=0.2262 pd=2.26 as=0 ps=0 w=0.87 l=4.73
X2205 VDD VSS.t3747 VDD VDD sky130_fd_pr__pfet_01v8_hvt ad=0.2262 pd=2.26 as=0 ps=0 w=0.87 l=1.97
X2206 VDD VSS.t3879 VDD VDD sky130_fd_pr__pfet_01v8_hvt ad=0.2262 pd=2.26 as=0 ps=0 w=0.87 l=4.73
X2207 _77_.CLK a_21914_15823.t22 VDD VDD sky130_fd_pr__pfet_01v8_hvt ad=0.14 pd=1.28 as=0.14 ps=1.28 w=1 l=0.15
X2208 VDD VSS.t3630 VDD VDD sky130_fd_pr__pfet_01v8_hvt ad=0.2262 pd=2.26 as=0 ps=0 w=0.87 l=4.73
X2209 VSS.t2684 VDD VSS.t2683 VSS.t2682 sky130_fd_pr__nfet_01v8 ad=0.143 pd=1.62 as=0 ps=0 w=0.55 l=4.73
X2210 _77_.CLK a_21914_15823.t12 VDD VDD sky130_fd_pr__pfet_01v8_hvt ad=0.14 pd=1.28 as=0.14 ps=1.28 w=1 l=0.15
X2211 VSS.t976 VDD VSS.t975 VSS.t974 sky130_fd_pr__nfet_01v8 ad=0.143 pd=1.62 as=0 ps=0 w=0.55 l=1.97
X2212 VDD VSS.t4392 VDD VDD sky130_fd_pr__pfet_01v8_hvt ad=0.2262 pd=2.26 as=0 ps=0 w=0.87 l=4.73
X2213 VSS.t2873 VDD VSS.t2872 VSS.t2871 sky130_fd_pr__nfet_01v8 ad=0.143 pd=1.62 as=0 ps=0 w=0.55 l=1.97
X2214 VDD VSS.t4147 VDD VDD sky130_fd_pr__pfet_01v8_hvt ad=0.2262 pd=2.26 as=0 ps=0 w=0.87 l=4.73
X2215 VSS.t1021 VDD VSS.t1020 VSS.t1019 sky130_fd_pr__nfet_01v8 ad=0.143 pd=1.62 as=0 ps=0 w=0.55 l=1.97
X2216 VDD VSS.t4125 VDD VDD sky130_fd_pr__pfet_01v8_hvt ad=0.2262 pd=2.26 as=0 ps=0 w=0.87 l=4.73
X2217 VSS.t3070 VDD VSS.t3069 VSS.t3068 sky130_fd_pr__nfet_01v8 ad=0.143 pd=1.62 as=0 ps=0 w=0.55 l=4.73
X2218 VDD VSS.t3833 VDD VDD sky130_fd_pr__pfet_01v8_hvt ad=0.2262 pd=2.26 as=0 ps=0 w=0.87 l=4.73
X2219 VSS.t1388 VDD VSS.t1387 VSS.t1386 sky130_fd_pr__nfet_01v8 ad=0.143 pd=1.62 as=0 ps=0 w=0.55 l=4.73
X2220 VDD VSS.t468 VDD VDD sky130_fd_pr__pfet_01v8_hvt ad=0.2262 pd=2.26 as=0 ps=0 w=0.87 l=0.59
X2221 VSS.t459 VDD VSS.t458 VSS.t457 sky130_fd_pr__nfet_01v8 ad=0.143 pd=1.62 as=0 ps=0 w=0.55 l=4.73
X2222 VDD VSS.t4094 VDD VDD sky130_fd_pr__pfet_01v8_hvt ad=0.2262 pd=2.26 as=0 ps=0 w=0.87 l=4.73
X2223 a_3807_16617# output3.A.t13 VSS.t157 VSS.t156 sky130_fd_pr__nfet_01v8 ad=0.08775 pd=0.92 as=0.169 ps=1.82 w=0.65 l=0.15
X2224 VDD VSS.t4327 VDD VDD sky130_fd_pr__pfet_01v8_hvt ad=0.2262 pd=2.26 as=0 ps=0 w=0.87 l=4.73
X2225 VSS.t3316 a_27498_15391# a_27456_15279# VSS.t3342 sky130_fd_pr__nfet_01v8 ad=0.12095 pd=1.085 as=0.0696 ps=0.765 w=0.42 l=0.15
X2226 VDD VSS.t4277 VDD VDD sky130_fd_pr__pfet_01v8_hvt ad=0.2262 pd=2.26 as=0 ps=0 w=0.87 l=1.97
X2227 VSS.t1995 VDD VSS.t1994 VSS.t1993 sky130_fd_pr__nfet_01v8 ad=0.143 pd=1.62 as=0 ps=0 w=0.55 l=4.73
X2228 VSS.t162 a_16762_15823.t34 clkbuf_0_clock_i.X VSS.t163 sky130_fd_pr__nfet_01v8 ad=0.0588 pd=0.7 as=0.0588 ps=0.7 w=0.42 l=0.15
X2229 VSS.t201 _36_.B.t4 a_25148_15279# VSS.t200 sky130_fd_pr__nfet_01v8 ad=0.0588 pd=0.7 as=0.1113 ps=1.37 w=0.42 l=0.15
X2230 VDD VSS.t4184 VDD VDD sky130_fd_pr__pfet_01v8_hvt ad=0.2262 pd=2.26 as=0 ps=0 w=0.87 l=4.73
X2231 VSS.t1481 VDD VSS.t1480 VSS.t1479 sky130_fd_pr__nfet_01v8 ad=0.143 pd=1.62 as=0 ps=0 w=0.55 l=1.97
X2232 VSS.t3257 a_16762_15823.t24 clkbuf_0_clock_i.X VSS.t3258 sky130_fd_pr__nfet_01v8 ad=0.0588 pd=0.7 as=0.0588 ps=0.7 w=0.42 l=0.15
X2233 VDD VSS.t4191 VDD VDD sky130_fd_pr__pfet_01v8_hvt ad=0.2262 pd=2.26 as=0 ps=0 w=0.87 l=4.73
X2234 VDD VSS.t4169 VDD VDD sky130_fd_pr__pfet_01v8_hvt ad=0.2262 pd=2.26 as=0 ps=0 w=0.87 l=4.73
X2235 VSS.t602 VDD VSS.t601 VSS.t600 sky130_fd_pr__nfet_01v8 ad=0.143 pd=1.62 as=0 ps=0 w=0.55 l=1.97
X2236 VDD VSS.t4285 VDD VDD sky130_fd_pr__pfet_01v8_hvt ad=0.2262 pd=2.26 as=0 ps=0 w=0.87 l=4.73
X2237 _36_.B _67_.A.t9 a_9727_16367# VSS.t3413 sky130_fd_pr__nfet_01v8 ad=0.08775 pd=0.92 as=0.10725 ps=0.98 w=0.65 l=0.15
X2238 VDD VSS.t3462 VDD VDD sky130_fd_pr__pfet_01v8_hvt ad=0.2262 pd=2.26 as=0 ps=0 w=0.87 l=4.73
X2239 VDD VSS.t3821 VDD VDD sky130_fd_pr__pfet_01v8_hvt ad=0.2262 pd=2.26 as=0 ps=0 w=0.87 l=4.73
X2240 VDD VSS.t3876 VDD VDD sky130_fd_pr__pfet_01v8_hvt ad=0.2262 pd=2.26 as=0 ps=0 w=0.87 l=4.73
X2241 VSS.t3303 clkbuf_0_clock_i.X a_11413_16341.t1 VSS.t3302 sky130_fd_pr__nfet_01v8 ad=0.0588 pd=0.7 as=0.0588 ps=0.7 w=0.42 l=0.15
X2242 VDD VSS.t3558 VDD VDD sky130_fd_pr__pfet_01v8_hvt ad=0.2262 pd=2.26 as=0 ps=0 w=0.87 l=1.97
X2243 VDD VSS.t3672 VDD VDD sky130_fd_pr__pfet_01v8_hvt ad=0.2262 pd=2.26 as=0 ps=0 w=0.87 l=1.97
X2244 VDD VSS.t3862 VDD VDD sky130_fd_pr__pfet_01v8_hvt ad=0.2262 pd=2.26 as=0 ps=0 w=0.87 l=4.73
X2245 VDD VSS.t4335 VDD VDD sky130_fd_pr__pfet_01v8_hvt ad=0.2262 pd=2.26 as=0 ps=0 w=0.87 l=4.73
X2246 VSS.t178 _48_.A.t4 a_23027_14735# VSS.t177 sky130_fd_pr__nfet_01v8 ad=0.08775 pd=0.92 as=0.169 ps=1.82 w=0.65 l=0.15
X2247 VSS.t1182 VDD VSS.t1181 VSS.t1180 sky130_fd_pr__nfet_01v8 ad=0.143 pd=1.62 as=0 ps=0 w=0.55 l=4.73
X2248 VSS.t397 VDD VSS.t397 VSS.t396 sky130_fd_pr__nfet_01v8 ad=0.143 pd=1.62 as=0 ps=0 w=0.55 l=0.59
X2249 VDD VSS.t4317 VDD VDD sky130_fd_pr__pfet_01v8_hvt ad=0.2262 pd=2.26 as=0 ps=0 w=0.87 l=4.73
X2250 VSS.t1323 VDD VSS.t1322 VSS.t1321 sky130_fd_pr__nfet_01v8 ad=0.143 pd=1.62 as=0 ps=0 w=0.55 l=4.73
X2251 VSS.t2317 VDD VSS.t2316 VSS.t2315 sky130_fd_pr__nfet_01v8 ad=0.143 pd=1.62 as=0 ps=0 w=0.55 l=4.73
X2252 VSS.t1678 VDD VSS.t1677 VSS.t1676 sky130_fd_pr__nfet_01v8 ad=0.143 pd=1.62 as=0 ps=0 w=0.55 l=4.73
X2253 VSS.t1248 VDD VSS.t1247 VSS.t1246 sky130_fd_pr__nfet_01v8 ad=0.143 pd=1.62 as=0 ps=0 w=0.55 l=4.73
X2254 a_9727_16367# _67_.A.t6 _36_.B VSS.t3263 sky130_fd_pr__nfet_01v8 ad=0.169 pd=1.82 as=0.08775 ps=0.92 w=0.65 l=0.15
X2255 a_27755_15645# a_26891_15279# a_27498_15391# VDD sky130_fd_pr__pfet_01v8_hvt ad=0.0567 pd=0.69 as=0.1095 ps=1.075 w=0.42 l=0.15
X2256 _75_.CLK a_11413_16341.t31 VDD VDD sky130_fd_pr__pfet_01v8_hvt ad=0.14 pd=1.28 as=0.1375 ps=1.275 w=1 l=0.15
X2257 VDD VSS.t3598 VDD VDD sky130_fd_pr__pfet_01v8_hvt ad=0.2262 pd=2.26 as=0 ps=0 w=0.87 l=4.73
X2258 VSS.t2959 VDD VSS.t2958 VSS.t2957 sky130_fd_pr__nfet_01v8 ad=0.143 pd=1.62 as=0 ps=0 w=0.55 l=1.97
X2259 VSS.t2186 VDD VSS.t2185 VSS.t2184 sky130_fd_pr__nfet_01v8 ad=0.143 pd=1.62 as=0 ps=0 w=0.55 l=4.73
X2260 VDD VSS.t3982 VDD VDD sky130_fd_pr__pfet_01v8_hvt ad=0.2262 pd=2.26 as=0 ps=0 w=0.87 l=4.73
X2261 VSS.t2472 VDD VSS.t2471 VSS.t2470 sky130_fd_pr__nfet_01v8 ad=0.143 pd=1.62 as=0 ps=0 w=0.55 l=4.73
X2262 VDD VSS.t4077 VDD VDD sky130_fd_pr__pfet_01v8_hvt ad=0.2262 pd=2.26 as=0 ps=0 w=0.87 l=4.73
X2263 VSS.t189 _75_.CLK a_17691_16367# VSS.t188 sky130_fd_pr__nfet_01v8 ad=0.0567 pd=0.69 as=0.1092 ps=1.36 w=0.42 l=0.15
X2264 VSS.t488 VDD VSS.t487 VSS.t486 sky130_fd_pr__nfet_01v8 ad=0.143 pd=1.62 as=0 ps=0 w=0.55 l=2.89
X2265 a_11693_15829# a_11527_15829# VDD VDD sky130_fd_pr__pfet_01v8_hvt ad=0.1664 pd=1.8 as=0.0864 ps=0.91 w=0.64 l=0.15
X2266 VSS.t729 VDD VSS.t728 VSS.t727 sky130_fd_pr__nfet_01v8 ad=0.143 pd=1.62 as=0 ps=0 w=0.55 l=4.73
X2267 VDD VSS.t4055 VDD VDD sky130_fd_pr__pfet_01v8_hvt ad=0.2262 pd=2.26 as=0 ps=0 w=0.87 l=4.73
X2268 VDD VSS.t3763 VDD VDD sky130_fd_pr__pfet_01v8_hvt ad=0.2262 pd=2.26 as=0 ps=0 w=0.87 l=4.73
X2269 VDD VSS.t3587 VDD VDD sky130_fd_pr__pfet_01v8_hvt ad=0.2262 pd=2.26 as=0 ps=0 w=0.87 l=4.73
X2270 _67_.A.t1 a_12559_15797# VDD VDD sky130_fd_pr__pfet_01v8_hvt ad=0.26 pd=2.52 as=0.135 ps=1.27 w=1 l=0.15
X2271 VDD VSS.t4305 VDD VDD sky130_fd_pr__pfet_01v8_hvt ad=0.2262 pd=2.26 as=0 ps=0 w=0.87 l=4.73
X2272 VSS.t887 VDD VSS.t886 VSS.t885 sky130_fd_pr__nfet_01v8 ad=0.143 pd=1.62 as=0 ps=0 w=0.55 l=4.73
X2273 VSS.t2033 VDD VSS.t2033 VSS.t2032 sky130_fd_pr__nfet_01v8 ad=0.143 pd=1.62 as=0 ps=0 w=0.55 l=0.59
X2274 VDD VSS.t3922 VDD VDD sky130_fd_pr__pfet_01v8_hvt ad=0.2262 pd=2.26 as=0 ps=0 w=0.87 l=4.73
X2275 VDD VSS.t3940 VDD VDD sky130_fd_pr__pfet_01v8_hvt ad=0.2262 pd=2.26 as=0 ps=0 w=0.87 l=4.73
X2276 VDD VSS.t4330 VDD VDD sky130_fd_pr__pfet_01v8_hvt ad=0.2262 pd=2.26 as=0 ps=0 w=0.87 l=4.73
X2277 VDD _43_.X a_21341_15279# VDD sky130_fd_pr__pfet_01v8_hvt ad=0.1092 pd=1.36 as=0.05775 ps=0.695 w=0.42 l=0.15
X2278 VDD VSS.t4114 VDD VDD sky130_fd_pr__pfet_01v8_hvt ad=0.2262 pd=2.26 as=0 ps=0 w=0.87 l=4.73
X2279 VSS.t324 VDD VSS.t323 VSS.t322 sky130_fd_pr__nfet_01v8 ad=0.143 pd=1.62 as=0 ps=0 w=0.55 l=4.73
X2280 VDD VSS.t3849 VDD VDD sky130_fd_pr__pfet_01v8_hvt ad=0.2262 pd=2.26 as=0 ps=0 w=0.87 l=4.73
X2281 VDD a_28253_15823# a_28359_15823# VDD sky130_fd_pr__pfet_01v8_hvt ad=0.14075 pd=1.325 as=0.1092 ps=1.36 w=0.42 l=0.5
X2282 VDD VSS.t3548 VDD VDD sky130_fd_pr__pfet_01v8_hvt ad=0.2262 pd=2.26 as=0 ps=0 w=0.87 l=4.73
X2283 VSS.t3013 VDD VSS.t3012 VSS.t3011 sky130_fd_pr__nfet_01v8 ad=0.143 pd=1.62 as=0 ps=0 w=0.55 l=4.73
X2284 VSS.t1621 VDD VSS.t1620 VSS.t1619 sky130_fd_pr__nfet_01v8 ad=0.143 pd=1.62 as=0 ps=0 w=0.55 l=1.97
X2285 VDD VSS.t4099 VDD VDD sky130_fd_pr__pfet_01v8_hvt ad=0.2262 pd=2.26 as=0 ps=0 w=0.87 l=4.73
X2286 VDD VSS.t4282 VDD VDD sky130_fd_pr__pfet_01v8_hvt ad=0.2262 pd=2.26 as=0 ps=0 w=0.87 l=1.97
X2287 VDD VSS.t3551 VDD VDD sky130_fd_pr__pfet_01v8_hvt ad=0.2262 pd=2.26 as=0 ps=0 w=0.87 l=4.73
X2288 VDD VSS.t3751 VDD VDD sky130_fd_pr__pfet_01v8_hvt ad=0.2262 pd=2.26 as=0 ps=0 w=0.87 l=4.73
X2289 VDD VSS.t3810 VDD VDD sky130_fd_pr__pfet_01v8_hvt ad=0.2262 pd=2.26 as=0 ps=0 w=0.87 l=4.73
X2290 _43_.A.t1 a_20267_16733# VSS.t44 VSS.t3421 sky130_fd_pr__nfet_01v8 ad=0.143 pd=1.09 as=0.10187 ps=0.99 w=0.65 l=0.15
X2291 VDD VSS.t748 VDD VDD sky130_fd_pr__pfet_01v8_hvt ad=0.2262 pd=2.26 as=0 ps=0 w=0.87 l=4.73
X2292 VSS.t3308 clkbuf_0_clock_i.X a_21914_15823.t1 VSS.t3307 sky130_fd_pr__nfet_01v8 ad=0.0588 pd=0.7 as=0.0588 ps=0.7 w=0.42 l=0.15
X2293 VSS.t2355 VDD VSS.t2354 VSS.t2351 sky130_fd_pr__nfet_01v8 ad=0.143 pd=1.62 as=0 ps=0 w=0.55 l=1.97
X2294 VSS.t1938 VDD VSS.t1937 VSS.t1936 sky130_fd_pr__nfet_01v8 ad=0.143 pd=1.62 as=0 ps=0 w=0.55 l=1.05
X2295 _55_.A_N a_29027_16635# VSS.t113 VSS.t3424 sky130_fd_pr__nfet_01v8 ad=0.169 pd=1.82 as=0.08775 ps=0.92 w=0.65 l=0.15
X2296 VDD VSS.t4229 VDD VDD sky130_fd_pr__pfet_01v8_hvt ad=0.2262 pd=2.26 as=0 ps=0 w=0.87 l=4.73
X2297 VDD VSS.t3581 VDD VDD sky130_fd_pr__pfet_01v8_hvt ad=0.2262 pd=2.26 as=0 ps=0 w=0.87 l=4.73
X2298 VSS.t2469 VDD VSS.t2468 VSS.t2467 sky130_fd_pr__nfet_01v8 ad=0.143 pd=1.62 as=0 ps=0 w=0.55 l=4.73
X2299 VDD VSS.t3965 VDD VDD sky130_fd_pr__pfet_01v8_hvt ad=0.2262 pd=2.26 as=0 ps=0 w=0.87 l=4.73
X2300 VSS.t2861 VDD VSS.t2860 VSS.t2859 sky130_fd_pr__nfet_01v8 ad=0.143 pd=1.62 as=0 ps=0 w=0.55 l=4.73
X2301 _60_.B a_3807_16617# a_4057_16617# VDD sky130_fd_pr__pfet_01v8_hvt ad=0.3 pd=2.6 as=0.26 ps=2.52 w=1 l=0.15
X2302 a_12475_15823# a_11693_15829# a_12391_15823# VDD sky130_fd_pr__pfet_01v8_hvt ad=0.0882 pd=0.84 as=0.0567 ps=0.69 w=0.42 l=0.15
X2303 VSS.t1896 VDD VSS.t1895 VSS.t1894 sky130_fd_pr__nfet_01v8 ad=0.143 pd=1.62 as=0 ps=0 w=0.55 l=4.73
X2304 a_5438_16733# a_5191_16367# VDD VDD sky130_fd_pr__pfet_01v8_hvt ad=0.07665 pd=0.785 as=0.17887 ps=1.26 w=0.42 l=0.15
X2305 VSS.t1188 VDD VSS.t1187 VSS.t1186 sky130_fd_pr__nfet_01v8 ad=0.143 pd=1.62 as=0 ps=0 w=0.55 l=4.73
X2306 VSS.t2401 VDD VSS.t2400 VSS.t2399 sky130_fd_pr__nfet_01v8 ad=0.143 pd=1.62 as=0 ps=0 w=0.55 l=4.73
X2307 VDD VSS.t4379 VDD VDD sky130_fd_pr__pfet_01v8_hvt ad=0.2262 pd=2.26 as=0 ps=0 w=0.87 l=4.73
X2308 VDD VSS.t3787 VDD VDD sky130_fd_pr__pfet_01v8_hvt ad=0.2262 pd=2.26 as=0 ps=0 w=0.87 l=4.73
X2309 VSS.t581 VDD VSS.t580 VSS.t579 sky130_fd_pr__nfet_01v8 ad=0.143 pd=1.62 as=0 ps=0 w=0.55 l=1.97
X2310 VSS.t1075 VDD VSS.t1074 VSS.t1073 sky130_fd_pr__nfet_01v8 ad=0.143 pd=1.62 as=0 ps=0 w=0.55 l=1.05
X2311 VDD _63_.Y a_6407_16395# VDD sky130_fd_pr__pfet_01v8_hvt ad=0.16655 pd=1.39 as=0.0567 ps=0.69 w=0.42 l=0.15
X2312 VSS.t2622 VDD VSS.t2621 VSS.t2620 sky130_fd_pr__nfet_01v8 ad=0.143 pd=1.62 as=0 ps=0 w=0.55 l=4.73
X2313 VDD VSS.t4350 VDD VDD sky130_fd_pr__pfet_01v8_hvt ad=0.2262 pd=2.26 as=0 ps=0 w=0.87 l=4.73
X2314 VDD VSS.t3626 VDD VDD sky130_fd_pr__pfet_01v8_hvt ad=0.2262 pd=2.26 as=0 ps=0 w=0.87 l=4.73
X2315 counter_value_o[1] a_7716_16885# VSS.t245 VSS.t244 sky130_fd_pr__nfet_01v8 ad=0.08775 pd=0.92 as=0.17225 ps=1.83 w=0.65 l=0.15
X2316 VDD VSS.t4209 VDD VDD sky130_fd_pr__pfet_01v8_hvt ad=0.2262 pd=2.26 as=0 ps=0 w=0.87 l=4.73
X2317 VSS.t2547 VDD VSS.t2546 VSS.t2545 sky130_fd_pr__nfet_01v8 ad=0.143 pd=1.62 as=0 ps=0 w=0.55 l=4.73
X2318 VSS.t2248 VDD VSS.t2248 VSS.t2247 sky130_fd_pr__nfet_01v8 ad=0.143 pd=1.62 as=0 ps=0 w=0.55 l=0.59
X2319 VSS.t2911 VDD VSS.t2910 VSS.t2909 sky130_fd_pr__nfet_01v8 ad=0.143 pd=1.62 as=0 ps=0 w=0.55 l=4.73
X2320 VDD VSS.t2033 VDD VDD sky130_fd_pr__pfet_01v8_hvt ad=0.2262 pd=2.26 as=0 ps=0 w=0.87 l=0.59
X2321 VDD VSS.t3455 VDD VDD sky130_fd_pr__pfet_01v8_hvt ad=0.2262 pd=2.26 as=0 ps=0 w=0.87 l=4.73
X2322 VSS.t1224 VDD VSS.t1223 VSS.t1222 sky130_fd_pr__nfet_01v8 ad=0.143 pd=1.62 as=0 ps=0 w=0.55 l=4.73
X2323 VSS.t251 a_4675_16519# output3.A.t0 VSS.t3416 sky130_fd_pr__nfet_01v8 ad=0.08775 pd=0.92 as=0.169 ps=1.82 w=0.65 l=0.15
X2324 VSS.t1580 VDD VSS.t1579 VSS.t1578 sky130_fd_pr__nfet_01v8 ad=0.143 pd=1.62 as=0 ps=0 w=0.55 l=1.97
X2325 VDD _63_.A.t11 _36_.B.t0 VDD sky130_fd_pr__pfet_01v8_hvt ad=0.395 pd=1.79 as=0.135 ps=1.27 w=1 l=0.15
X2326 VDD VSS.t4155 VDD VDD sky130_fd_pr__pfet_01v8_hvt ad=0.2262 pd=2.26 as=0 ps=0 w=0.87 l=4.73
X2327 VSS.t2667 VDD VSS.t2666 VSS.t2665 sky130_fd_pr__nfet_01v8 ad=0.143 pd=1.62 as=0 ps=0 w=0.55 l=4.73
X2328 a_6925_16143# a_6883_16055# _63_.Y VSS.t3249 sky130_fd_pr__nfet_01v8 ad=0.08775 pd=0.92 as=0.195 ps=1.9 w=0.65 l=0.15
X2329 VSS.t1839 VDD VSS.t1838 VSS.t1837 sky130_fd_pr__nfet_01v8 ad=0.143 pd=1.62 as=0 ps=0 w=0.55 l=1.97
X2330 a_28433_17143# a_28529_16885# VSS.t3242 VSS.t3317 sky130_fd_pr__nfet_01v8 ad=0.1092 pd=1.36 as=0.097 ps=0.975 w=0.42 l=0.5
X2331 VSS.t306 VDD VSS.t305 VSS.t304 sky130_fd_pr__nfet_01v8 ad=0.143 pd=1.62 as=0 ps=0 w=0.55 l=4.73
X2332 VSS.t3319 a_7442_16479# a_7400_16367# VSS.t3318 sky130_fd_pr__nfet_01v8 ad=0.12095 pd=1.085 as=0.0696 ps=0.765 w=0.42 l=0.15
X2333 VDD VSS.t3740 VDD VDD sky130_fd_pr__pfet_01v8_hvt ad=0.2262 pd=2.26 as=0 ps=0 w=0.87 l=4.73
X2334 VSS.t2278 VDD VSS.t2277 VSS.t2276 sky130_fd_pr__nfet_01v8 ad=0.143 pd=1.62 as=0 ps=0 w=0.55 l=4.73
X2335 a_4057_16367# input1.X.t14 VSS.t147 VSS.t146 sky130_fd_pr__nfet_01v8 ad=0.08775 pd=0.92 as=0.08775 ps=0.92 w=0.65 l=0.15
X2336 VDD VSS.t4256 VDD VDD sky130_fd_pr__pfet_01v8_hvt ad=0.2262 pd=2.26 as=0 ps=0 w=0.87 l=4.73
X2337 VSS.t2947 VDD VSS.t2946 VSS.t2945 sky130_fd_pr__nfet_01v8 ad=0.143 pd=1.62 as=0 ps=0 w=0.55 l=4.73
X2338 VDD VSS.t3868 VDD VDD sky130_fd_pr__pfet_01v8_hvt ad=0.2262 pd=2.26 as=0 ps=0 w=0.87 l=1.05
X2339 VSS.t2499 VDD VSS.t2498 VSS.t2497 sky130_fd_pr__nfet_01v8 ad=0.143 pd=1.62 as=0 ps=0 w=0.55 l=1.97
X2340 VSS.t1571 VDD VSS.t1570 VSS.t1569 sky130_fd_pr__nfet_01v8 ad=0.143 pd=1.62 as=0 ps=0 w=0.55 l=4.73
X2341 VSS.t468 VDD VSS.t468 VSS.t463 sky130_fd_pr__nfet_01v8 ad=0.143 pd=1.62 as=0 ps=0 w=0.55 l=0.59
X2342 VDD VSS.t4227 VDD VDD sky130_fd_pr__pfet_01v8_hvt ad=0.2262 pd=2.26 as=0 ps=0 w=0.87 l=1.97
X2343 VDD VSS.t4000 VDD VDD sky130_fd_pr__pfet_01v8_hvt ad=0.2262 pd=2.26 as=0 ps=0 w=0.87 l=4.73
X2344 VSS.t525 VDD VSS.t524 VSS.t523 sky130_fd_pr__nfet_01v8 ad=0.143 pd=1.62 as=0 ps=0 w=0.55 l=4.73
X2345 VDD VSS.t4293 VDD VDD sky130_fd_pr__pfet_01v8_hvt ad=0.2262 pd=2.26 as=0 ps=0 w=0.87 l=4.73
X2346 VSS.t1690 VDD VSS.t1689 VSS.t1688 sky130_fd_pr__nfet_01v8 ad=0.143 pd=1.62 as=0 ps=0 w=0.55 l=4.73
X2347 VSS.t680 VDD VSS.t679 VSS.t678 sky130_fd_pr__nfet_01v8 ad=0.143 pd=1.62 as=0 ps=0 w=0.55 l=1.97
X2348 VDD VSS.t3970 VDD VDD sky130_fd_pr__pfet_01v8_hvt ad=0.2262 pd=2.26 as=0 ps=0 w=0.87 l=4.73
X2349 VSS.t2353 VDD VSS.t2352 VSS.t2351 sky130_fd_pr__nfet_01v8 ad=0.143 pd=1.62 as=0 ps=0 w=0.55 l=4.73
X2350 VDD VSS.t3717 VDD VDD sky130_fd_pr__pfet_01v8_hvt ad=0.2262 pd=2.26 as=0 ps=0 w=0.87 l=4.73
X2351 VDD VSS.t3916 VDD VDD sky130_fd_pr__pfet_01v8_hvt ad=0.2262 pd=2.26 as=0 ps=0 w=0.87 l=4.73
X2352 VSS.t656 VDD VSS.t655 VSS.t654 sky130_fd_pr__nfet_01v8 ad=0.143 pd=1.62 as=0 ps=0 w=0.55 l=4.73
X2353 VSS.t776 VDD VSS.t775 VSS.t774 sky130_fd_pr__nfet_01v8 ad=0.143 pd=1.62 as=0 ps=0 w=0.55 l=1.97
X2354 VDD VSS.t3690 VDD VDD sky130_fd_pr__pfet_01v8_hvt ad=0.2262 pd=2.26 as=0 ps=0 w=0.87 l=4.73
X2355 VDD VSS.t4363 VDD VDD sky130_fd_pr__pfet_01v8_hvt ad=0.2262 pd=2.26 as=0 ps=0 w=0.87 l=4.73
X2356 a_7699_16733# a_6835_16367# a_7442_16479# VDD sky130_fd_pr__pfet_01v8_hvt ad=0.0567 pd=0.69 as=0.1095 ps=1.075 w=0.42 l=0.15
X2357 VSS.t2016 VDD VSS.t2015 VSS.t2014 sky130_fd_pr__nfet_01v8 ad=0.143 pd=1.62 as=0 ps=0 w=0.55 l=4.73
X2358 VDD VSS.t4148 VDD VDD sky130_fd_pr__pfet_01v8_hvt ad=0.2262 pd=2.26 as=0 ps=0 w=0.87 l=1.05
X2359 a_20624_16367# _40_.Y _43_.A.t0 VSS.t3243 sky130_fd_pr__nfet_01v8 ad=0.091 pd=0.93 as=0.143 ps=1.09 w=0.65 l=0.15
X2360 VSS.t1368 VDD VSS.t1367 VSS.t1366 sky130_fd_pr__nfet_01v8 ad=0.143 pd=1.62 as=0 ps=0 w=0.55 l=4.73
X2361 VDD _60_.B a_4107_16161# VDD sky130_fd_pr__pfet_01v8_hvt ad=0.16655 pd=1.39 as=0.0567 ps=0.69 w=0.42 l=0.15
X2362 VSS.t1135 VDD VSS.t1134 VSS.t1133 sky130_fd_pr__nfet_01v8 ad=0.143 pd=1.62 as=0 ps=0 w=0.55 l=1.97
X2363 VSS.t2888 VDD VSS.t2887 VSS.t2886 sky130_fd_pr__nfet_01v8 ad=0.143 pd=1.62 as=0 ps=0 w=0.55 l=1.97
X2364 a_7369_16733# a_6835_16367# a_7274_16733# VDD sky130_fd_pr__pfet_01v8_hvt ad=0.07665 pd=0.785 as=0.06825 ps=0.745 w=0.42 l=0.15
X2365 VSS.t1048 VDD VSS.t1047 VSS.t1046 sky130_fd_pr__nfet_01v8 ad=0.143 pd=1.62 as=0 ps=0 w=0.55 l=4.73
X2366 VSS.t3085 VDD VSS.t3084 VSS.t3083 sky130_fd_pr__nfet_01v8 ad=0.143 pd=1.62 as=0 ps=0 w=0.55 l=4.73
X2367 VSS.t413 VDD VSS.t412 VSS.t411 sky130_fd_pr__nfet_01v8 ad=0.143 pd=1.62 as=0 ps=0 w=0.55 l=4.73
X2368 VDD VSS.t2248 VDD VDD sky130_fd_pr__pfet_01v8_hvt ad=0.2262 pd=2.26 as=0 ps=0 w=0.87 l=0.59
X2369 VDD VSS.t3665 VDD VDD sky130_fd_pr__pfet_01v8_hvt ad=0.2262 pd=2.26 as=0 ps=0 w=0.87 l=4.73
X2370 VSS.t2508 VDD VSS.t2507 VSS.t2506 sky130_fd_pr__nfet_01v8 ad=0.143 pd=1.62 as=0 ps=0 w=0.55 l=4.73
X2371 VDD VSS.t4085 VDD VDD sky130_fd_pr__pfet_01v8_hvt ad=0.2262 pd=2.26 as=0 ps=0 w=0.87 l=4.73
X2372 _53_.X a_26339_15279# VSS.t69 VSS.t70 sky130_fd_pr__nfet_01v8 ad=0.08775 pd=0.92 as=0.08775 ps=0.92 w=0.65 l=0.15
X2373 VSS.t1699 VDD VSS.t1698 VSS.t1697 sky130_fd_pr__nfet_01v8 ad=0.143 pd=1.62 as=0 ps=0 w=0.55 l=4.73
X2374 _75_.CLK a_11413_16341.t9 VSS.t118 VSS.t117 sky130_fd_pr__nfet_01v8 ad=0.0588 pd=0.7 as=0.0588 ps=0.7 w=0.42 l=0.15
X2375 VDD VSS.t4153 VDD VDD sky130_fd_pr__pfet_01v8_hvt ad=0.2262 pd=2.26 as=0 ps=0 w=0.87 l=1.97
X2376 VSS.t2896 VDD VSS.t2895 VSS.t2894 sky130_fd_pr__nfet_01v8 ad=0.143 pd=1.62 as=0 ps=0 w=0.55 l=4.73
X2377 VDD VSS.t4160 VDD VDD sky130_fd_pr__pfet_01v8_hvt ad=0.2262 pd=2.26 as=0 ps=0 w=0.87 l=4.73
X2378 a_21914_15823.t5 clkbuf_0_clock_i.X VDD VDD sky130_fd_pr__pfet_01v8_hvt ad=0.14 pd=1.28 as=0.14 ps=1.28 w=1 l=0.15
X2379 VSS.t2980 VDD VSS.t2979 VSS.t2978 sky130_fd_pr__nfet_01v8 ad=0.143 pd=1.62 as=0 ps=0 w=0.55 l=4.73
X2380 VDD _36_.A.t4 a_17987_15279# VDD sky130_fd_pr__pfet_01v8_hvt ad=0.365 pd=1.73 as=0.135 ps=1.27 w=1 l=0.15
X2381 VSS.t2735 VDD VSS.t2734 VSS.t2733 sky130_fd_pr__nfet_01v8 ad=0.143 pd=1.62 as=0 ps=0 w=0.55 l=4.73
X2382 VSS.t2801 VDD VSS.t2800 VSS.t2799 sky130_fd_pr__nfet_01v8 ad=0.143 pd=1.62 as=0 ps=0 w=0.55 l=4.73
X2383 VSS.t46 input2.X.t10 a_22751_16733# VSS.t45 sky130_fd_pr__nfet_01v8 ad=0.10187 pd=0.99 as=0.1113 ps=1.37 w=0.42 l=0.15
X2384 VDD VSS.t3615 VDD VDD sky130_fd_pr__pfet_01v8_hvt ad=0.2262 pd=2.26 as=0 ps=0 w=0.87 l=4.73
X2385 VDD VSS.t3822 VDD VDD sky130_fd_pr__pfet_01v8_hvt ad=0.2262 pd=2.26 as=0 ps=0 w=0.87 l=1.97
X2386 VSS.t510 VDD VSS.t509 VSS.t508 sky130_fd_pr__nfet_01v8 ad=0.143 pd=1.62 as=0 ps=0 w=0.55 l=4.73
X2387 VDD reset_n_i a_1407_9839# VDD sky130_fd_pr__pfet_01v8_hvt ad=0.149 pd=1.325 as=0.1664 ps=1.8 w=0.64 l=0.15
X2388 VSS.t1908 VDD VSS.t1907 VSS.t1906 sky130_fd_pr__nfet_01v8 ad=0.143 pd=1.62 as=0 ps=0 w=0.55 l=4.73
X2389 VSS.t743 VDD VSS.t742 VSS.t741 sky130_fd_pr__nfet_01v8 ad=0.143 pd=1.62 as=0 ps=0 w=0.55 l=4.73
X2390 VSS.t2033 VDD VSS.t2033 VSS.t2032 sky130_fd_pr__nfet_01v8 ad=0.143 pd=1.62 as=0 ps=0 w=0.55 l=0.59
X2391 VSS.t1275 VDD VSS.t1274 VSS.t1273 sky130_fd_pr__nfet_01v8 ad=0.143 pd=1.62 as=0 ps=0 w=0.55 l=4.73
X2392 VSS.t3278 _55_.A_N a_37471_16919# VSS.t391 sky130_fd_pr__nfet_01v8 ad=0.097 pd=0.975 as=0.1092 ps=1.36 w=0.42 l=0.15
X2393 VSS.t665 VDD VSS.t664 VSS.t663 sky130_fd_pr__nfet_01v8 ad=0.143 pd=1.62 as=0 ps=0 w=0.55 l=1.97
X2394 VSS.t165 a_16762_15823.t36 clkbuf_0_clock_i.X VSS.t166 sky130_fd_pr__nfet_01v8 ad=0.0588 pd=0.7 as=0.0588 ps=0.7 w=0.42 l=0.15
X2395 VDD VSS.t3842 VDD VDD sky130_fd_pr__pfet_01v8_hvt ad=0.2262 pd=2.26 as=0 ps=0 w=0.87 l=4.73
X2396 VDD VSS.t4078 VDD VDD sky130_fd_pr__pfet_01v8_hvt ad=0.2262 pd=2.26 as=0 ps=0 w=0.87 l=1.05
X2397 VSS.t3142 VDD VSS.t3141 VSS.t3140 sky130_fd_pr__nfet_01v8 ad=0.143 pd=1.62 as=0 ps=0 w=0.55 l=4.73
X2398 VSS.t961 VDD VSS.t960 VSS.t959 sky130_fd_pr__nfet_01v8 ad=0.143 pd=1.62 as=0 ps=0 w=0.55 l=4.73
X2399 VDD VSS.t4128 VDD VDD sky130_fd_pr__pfet_01v8_hvt ad=0.2262 pd=2.26 as=0 ps=0 w=0.87 l=1.97
X2400 VSS.t220 a_11413_16341.t18 _75_.CLK VSS.t221 sky130_fd_pr__nfet_01v8 ad=0.0588 pd=0.7 as=0.0588 ps=0.7 w=0.42 l=0.15
X2401 VDD VSS.t3638 VDD VDD sky130_fd_pr__pfet_01v8_hvt ad=0.2262 pd=2.26 as=0 ps=0 w=0.87 l=1.97
X2402 a_12134_15797# a_11966_15823# VSS.t270 VSS.t3441 sky130_fd_pr__nfet_01v8 ad=0.0989 pd=0.995 as=0.12095 ps=1.085 w=0.64 l=0.15
X2403 VSS.t2819 VDD VSS.t2818 VSS.t2817 sky130_fd_pr__nfet_01v8 ad=0.143 pd=1.62 as=0 ps=0 w=0.55 l=4.73
X2404 VDD VSS.t1926 VDD VDD sky130_fd_pr__pfet_01v8_hvt ad=0.2262 pd=2.26 as=0 ps=0 w=0.87 l=0.59
X2405 VSS.t1120 VDD VSS.t1119 VSS.t1118 sky130_fd_pr__nfet_01v8 ad=0.143 pd=1.62 as=0 ps=0 w=0.55 l=1.97
X2406 VDD VSS.t3592 VDD VDD sky130_fd_pr__pfet_01v8_hvt ad=0.2262 pd=2.26 as=0 ps=0 w=0.87 l=4.73
X2407 VSS.t3232 VDD VSS.t3231 VSS.t3230 sky130_fd_pr__nfet_01v8 ad=0.143 pd=1.62 as=0 ps=0 w=0.55 l=4.73
X2408 VSS.t3408 a_21914_15823.t31 _77_.CLK VSS.t3409 sky130_fd_pr__nfet_01v8 ad=0.05775 pd=0.695 as=0.0588 ps=0.7 w=0.42 l=0.15
X2409 VSS.t351 VDD VSS.t350 VSS.t349 sky130_fd_pr__nfet_01v8 ad=0.143 pd=1.62 as=0 ps=0 w=0.55 l=4.73
X2410 VDD VSS.t3564 VDD VDD sky130_fd_pr__pfet_01v8_hvt ad=0.2262 pd=2.26 as=0 ps=0 w=0.87 l=4.73
X2411 VSS.t1917 VDD VSS.t1916 VSS.t1915 sky130_fd_pr__nfet_01v8 ad=0.143 pd=1.62 as=0 ps=0 w=0.55 l=4.73
X2412 a_18256_16367# a_17857_16367# a_18130_16733# VSS.t258 sky130_fd_pr__special_nfet_01v8 ad=0.0696 pd=0.765 as=0.0621 ps=0.705 w=0.36 l=0.15
X2413 VDD VSS.t4083 VDD VDD sky130_fd_pr__pfet_01v8_hvt ad=0.2262 pd=2.26 as=0 ps=0 w=0.87 l=1.97
X2414 VDD VSS.t4090 VDD VDD sky130_fd_pr__pfet_01v8_hvt ad=0.2262 pd=2.26 as=0 ps=0 w=0.87 l=4.73
X2415 VDD a_26799_16367# a_27133_16617# VDD sky130_fd_pr__pfet_01v8_hvt ad=0.26 pd=2.52 as=0.135 ps=1.27 w=1 l=0.15
X2416 VSS.t1427 VDD VSS.t1426 VSS.t1425 sky130_fd_pr__nfet_01v8 ad=0.143 pd=1.62 as=0 ps=0 w=0.55 l=4.73
X2417 VDD VSS.t3752 VDD VDD sky130_fd_pr__pfet_01v8_hvt ad=0.2262 pd=2.26 as=0 ps=0 w=0.87 l=1.97
X2418 VDD VSS.t3576 VDD VDD sky130_fd_pr__pfet_01v8_hvt ad=0.2262 pd=2.26 as=0 ps=0 w=0.87 l=4.73
X2419 VDD VSS.t3472 VDD VDD sky130_fd_pr__pfet_01v8_hvt ad=0.2262 pd=2.26 as=0 ps=0 w=0.87 l=0.59
X2420 VDD VSS.t3884 VDD VDD sky130_fd_pr__pfet_01v8_hvt ad=0.2262 pd=2.26 as=0 ps=0 w=0.87 l=4.73
X2421 _67_.A.t0 a_12559_15797# VSS.t57 VSS.t60 sky130_fd_pr__nfet_01v8 ad=0.169 pd=1.82 as=0.08775 ps=0.92 w=0.65 l=0.15
X2422 VDD VSS.t3956 VDD VDD sky130_fd_pr__pfet_01v8_hvt ad=0.2262 pd=2.26 as=0 ps=0 w=0.87 l=4.73
X2423 VDD _75_.CLK a_11527_15829# VDD sky130_fd_pr__pfet_01v8_hvt ad=0.0864 pd=0.91 as=0.1664 ps=1.8 w=0.64 l=0.15
X2424 VSS.t1314 VDD VSS.t1313 VSS.t1312 sky130_fd_pr__nfet_01v8 ad=0.143 pd=1.62 as=0 ps=0 w=0.55 l=4.73
X2425 VDD VSS.t3459 VDD VDD sky130_fd_pr__pfet_01v8_hvt ad=0.2262 pd=2.26 as=0 ps=0 w=0.87 l=4.73
X2426 VSS.t214 _46_.X a_23108_16367# VSS.t3423 sky130_fd_pr__nfet_01v8 ad=0.17225 pd=1.83 as=0.091 ps=0.93 w=0.65 l=0.15
X2427 VDD VSS.t4222 VDD VDD sky130_fd_pr__pfet_01v8_hvt ad=0.2262 pd=2.26 as=0 ps=0 w=0.87 l=4.73
X2428 VSS.t2198 VDD VSS.t2197 VSS.t2196 sky130_fd_pr__nfet_01v8 ad=0.143 pd=1.62 as=0 ps=0 w=0.55 l=1.97
X2429 VDD a_12391_15823# a_12559_15797# VDD sky130_fd_pr__pfet_01v8_hvt ad=0.135 pd=1.27 as=0.27 ps=2.54 w=1 l=0.15
X2430 VSS.t2072 VDD VSS.t2071 VSS.t2070 sky130_fd_pr__nfet_01v8 ad=0.143 pd=1.62 as=0 ps=0 w=0.55 l=4.73
X2431 VSS.t1738 VDD VSS.t1737 VSS.t1736 sky130_fd_pr__nfet_01v8 ad=0.143 pd=1.62 as=0 ps=0 w=0.55 l=1.97
X2432 VDD _67_.Y a_10547_16395# VDD sky130_fd_pr__pfet_01v8_hvt ad=0.16655 pd=1.39 as=0.0567 ps=0.69 w=0.42 l=0.15
X2433 VDD VSS.t3561 VDD VDD sky130_fd_pr__pfet_01v8_hvt ad=0.2262 pd=2.26 as=0 ps=0 w=0.87 l=4.73
X2434 VSS.t3025 VDD VSS.t3024 VSS.t3023 sky130_fd_pr__nfet_01v8 ad=0.143 pd=1.62 as=0 ps=0 w=0.55 l=4.73
X2435 VDD VSS.t4058 VDD VDD sky130_fd_pr__pfet_01v8_hvt ad=0.2262 pd=2.26 as=0 ps=0 w=0.87 l=1.97
X2436 VSS.t132 a_22843_16919# counter_value_o[4] VSS.t131 sky130_fd_pr__nfet_01v8 ad=0.17225 pd=1.83 as=0.08775 ps=0.92 w=0.65 l=0.15
X2437 VSS.t3326 a_18611_15831# _38_.X VSS.t3325 sky130_fd_pr__nfet_01v8 ad=0.17225 pd=1.83 as=0.08775 ps=0.92 w=0.65 l=0.15
X2438 a_27366_16055# _55_.A_N VDD VDD sky130_fd_pr__pfet_01v8_hvt ad=0.1092 pd=1.36 as=0.14575 ps=1.335 w=0.42 l=0.15
X2439 VDD VSS.t3489 VDD VDD sky130_fd_pr__pfet_01v8_hvt ad=0.2262 pd=2.26 as=0 ps=0 w=0.87 l=4.73
X2440 VSS.t1729 VDD VSS.t1728 VSS.t1727 sky130_fd_pr__nfet_01v8 ad=0.143 pd=1.62 as=0 ps=0 w=0.55 l=4.73
X2441 VDD VSS.t4343 VDD VDD sky130_fd_pr__pfet_01v8_hvt ad=0.2262 pd=2.26 as=0 ps=0 w=0.87 l=4.73
X2442 VDD VSS.t4133 VDD VDD sky130_fd_pr__pfet_01v8_hvt ad=0.2262 pd=2.26 as=0 ps=0 w=0.87 l=1.97
X2443 VSS.t407 VDD VSS.t407 VSS.t406 sky130_fd_pr__nfet_01v8 ad=0.143 pd=1.62 as=0 ps=0 w=0.55 l=1.05
X2444 a_28602_16479# a_28434_16733# VDD VDD sky130_fd_pr__pfet_01v8_hvt ad=0.1095 pd=1.075 as=0.17887 ps=1.26 w=0.75 l=0.15
X2445 VSS.t1950 VDD VSS.t1949 VSS.t1948 sky130_fd_pr__nfet_01v8 ad=0.143 pd=1.62 as=0 ps=0 w=0.55 l=4.73
X2446 VSS.t113 a_28859_16733# a_29027_16635# VSS.t112 sky130_fd_pr__nfet_01v8 ad=0.08775 pd=0.92 as=0.169 ps=1.82 w=0.65 l=0.15
X2447 a_6883_16055# _63_.A.t2 VDD VDD sky130_fd_pr__pfet_01v8_hvt ad=0.135 pd=1.27 as=0.365 ps=1.73 w=1 l=0.15
X2448 VSS.t1926 VDD VSS.t1926 VSS.t1921 sky130_fd_pr__nfet_01v8 ad=0.143 pd=1.62 as=0 ps=0 w=0.55 l=0.59
X2449 VDD VSS.t3930 VDD VDD sky130_fd_pr__pfet_01v8_hvt ad=0.2262 pd=2.26 as=0 ps=0 w=0.87 l=4.73
X2450 _36_.B.t0 output3.A.t10 VDD VDD sky130_fd_pr__pfet_01v8_hvt ad=0.135 pd=1.27 as=0.26 ps=2.52 w=1 l=0.15
X2451 a_23197_15279# _48_.X VDD VDD sky130_fd_pr__pfet_01v8_hvt ad=0.05775 pd=0.695 as=0.1092 ps=1.36 w=0.42 l=0.15
X2452 a_5411_16367# a_5191_16367# VSS.t10 VSS.t3334 sky130_fd_pr__nfet_01v8 ad=0.0696 pd=0.765 as=0.12095 ps=1.085 w=0.42 l=0.15
X2453 VSS.t2207 VDD VSS.t2206 VSS.t2205 sky130_fd_pr__nfet_01v8 ad=0.143 pd=1.62 as=0 ps=0 w=0.55 l=4.73
X2454 VSS.t3043 VDD VSS.t3042 VSS.t3041 sky130_fd_pr__nfet_01v8 ad=0.143 pd=1.62 as=0 ps=0 w=0.55 l=4.73
X2455 _63_.A.t0 a_7867_16635# VSS.t102 VSS.t255 sky130_fd_pr__nfet_01v8 ad=0.169 pd=1.82 as=0.08775 ps=0.92 w=0.65 l=0.15
X2456 VDD VSS.t3818 VDD VDD sky130_fd_pr__pfet_01v8_hvt ad=0.2262 pd=2.26 as=0 ps=0 w=0.87 l=4.73
X2457 VDD output3.A.t7 _36_.B.t0 VDD sky130_fd_pr__pfet_01v8_hvt ad=0.135 pd=1.27 as=0.135 ps=1.27 w=1 l=0.15
X2458 VDD a_1407_9839# input2.X.t3 VDD sky130_fd_pr__pfet_01v8_hvt ad=0.265 pd=2.53 as=0.135 ps=1.27 w=1 l=0.15
X2459 VDD VSS.t3603 VDD VDD sky130_fd_pr__pfet_01v8_hvt ad=0.2262 pd=2.26 as=0 ps=0 w=0.87 l=4.73
X2460 VSS.t2944 VDD VSS.t2943 VSS.t2942 sky130_fd_pr__nfet_01v8 ad=0.143 pd=1.62 as=0 ps=0 w=0.55 l=1.97
X2461 VSS.t1597 VDD VSS.t1596 VSS.t1488 sky130_fd_pr__nfet_01v8 ad=0.143 pd=1.62 as=0 ps=0 w=0.55 l=4.73
X2462 VSS.t1412 VDD VSS.t1411 VSS.t1410 sky130_fd_pr__nfet_01v8 ad=0.143 pd=1.62 as=0 ps=0 w=0.55 l=4.73
X2463 VSS.t2413 VDD VSS.t2412 VSS.t2411 sky130_fd_pr__nfet_01v8 ad=0.143 pd=1.62 as=0 ps=0 w=0.55 l=1.97
X2464 VSS.t1968 VDD VSS.t1967 VSS.t1966 sky130_fd_pr__nfet_01v8 ad=0.143 pd=1.62 as=0 ps=0 w=0.55 l=1.97
X2465 VDD VSS.t3991 VDD VDD sky130_fd_pr__pfet_01v8_hvt ad=0.2262 pd=2.26 as=0 ps=0 w=0.87 l=4.73
X2466 VDD VSS.t4009 VDD VDD sky130_fd_pr__pfet_01v8_hvt ad=0.2262 pd=2.26 as=0 ps=0 w=0.87 l=4.73
X2467 VDD VSS.t3783 VDD VDD sky130_fd_pr__pfet_01v8_hvt ad=0.2262 pd=2.26 as=0 ps=0 w=0.87 l=1.97
X2468 VDD VSS.t3555 VDD VDD sky130_fd_pr__pfet_01v8_hvt ad=0.2262 pd=2.26 as=0 ps=0 w=0.87 l=2.89
X2469 VSS.t803 VDD VSS.t802 VSS.t801 sky130_fd_pr__nfet_01v8 ad=0.143 pd=1.62 as=0 ps=0 w=0.55 l=4.73
X2470 VSS.t2030 VDD VSS.t2029 VSS.t1921 sky130_fd_pr__nfet_01v8 ad=0.143 pd=1.62 as=0 ps=0 w=0.55 l=4.73
X2471 VSS.t2559 VDD VSS.t2558 VSS.t2557 sky130_fd_pr__nfet_01v8 ad=0.143 pd=1.62 as=0 ps=0 w=0.55 l=1.97
X2472 VSS.t1162 VDD VSS.t1161 VSS.t1160 sky130_fd_pr__nfet_01v8 ad=0.143 pd=1.62 as=0 ps=0 w=0.55 l=4.73
X2473 VSS.t872 VDD VSS.t871 VSS.t870 sky130_fd_pr__nfet_01v8 ad=0.143 pd=1.62 as=0 ps=0 w=0.55 l=4.73
X2474 VDD VSS.t4063 VDD VDD sky130_fd_pr__pfet_01v8_hvt ad=0.2262 pd=2.26 as=0 ps=0 w=0.87 l=1.97
X2475 _36_.B.t0 input1.X.t10 VDD VDD sky130_fd_pr__pfet_01v8_hvt ad=0.135 pd=1.27 as=0.135 ps=1.27 w=1 l=0.15
X2476 VSS.t2099 VDD VSS.t2098 VSS.t2097 sky130_fd_pr__nfet_01v8 ad=0.143 pd=1.62 as=0 ps=0 w=0.55 l=1.97
X2477 VDD VSS.t3864 VDD VDD sky130_fd_pr__pfet_01v8_hvt ad=0.2262 pd=2.26 as=0 ps=0 w=0.87 l=4.73
X2478 VDD VSS.t3815 VDD VDD sky130_fd_pr__pfet_01v8_hvt ad=0.2262 pd=2.26 as=0 ps=0 w=0.87 l=4.73
X2479 VDD VSS.t3622 VDD VDD sky130_fd_pr__pfet_01v8_hvt ad=0.2262 pd=2.26 as=0 ps=0 w=0.87 l=1.97
X2480 VDD VSS.t1926 VDD VDD sky130_fd_pr__pfet_01v8_hvt ad=0.2262 pd=2.26 as=0 ps=0 w=0.87 l=0.59
X2481 _55_.A_N a_29027_16635# VDD VDD sky130_fd_pr__pfet_01v8_hvt ad=0.26 pd=2.52 as=0.135 ps=1.27 w=1 l=0.15
X2482 VDD VSS.t955 VDD VDD sky130_fd_pr__pfet_01v8_hvt ad=0.2262 pd=2.26 as=0 ps=0 w=0.87 l=0.59
X2483 VSS.t2422 VDD VSS.t2421 VSS.t2420 sky130_fd_pr__nfet_01v8 ad=0.143 pd=1.62 as=0 ps=0 w=0.55 l=4.73
X2484 VDD VSS.t3780 VDD VDD sky130_fd_pr__pfet_01v8_hvt ad=0.2262 pd=2.26 as=0 ps=0 w=0.87 l=4.73
X2485 VDD VSS.t3475 VDD VDD sky130_fd_pr__pfet_01v8_hvt ad=0.2262 pd=2.26 as=0 ps=0 w=0.87 l=0.59
X2486 a_23450_15391# a_23282_15645# VSS.t3267 VSS.t3314 sky130_fd_pr__nfet_01v8 ad=0.0989 pd=0.995 as=0.12095 ps=1.085 w=0.64 l=0.15
X2487 VSS.t2643 VDD VSS.t2642 VSS.t2641 sky130_fd_pr__nfet_01v8 ad=0.143 pd=1.62 as=0 ps=0 w=0.55 l=1.97
X2488 VSS.t3440 a_18723_16635# a_18681_16367# VSS.t3439 sky130_fd_pr__nfet_01v8 ad=0.1092 pd=1.36 as=0.066 ps=0.745 w=0.42 l=0.15
X2489 VSS.t1526 VDD VSS.t1525 VSS.t1524 sky130_fd_pr__nfet_01v8 ad=0.143 pd=1.62 as=0 ps=0 w=0.55 l=4.73
X2490 VSS.t441 VDD VSS.t441 VSS.t440 sky130_fd_pr__nfet_01v8 ad=0.143 pd=1.62 as=0 ps=0 w=0.55 l=0.59
X2491 VDD VSS.t3748 VDD VDD sky130_fd_pr__pfet_01v8_hvt ad=0.2262 pd=2.26 as=0 ps=0 w=0.87 l=4.73
X2492 a_11881_15823# _69_.X.t3 VSS.t3403 VSS.t3402 sky130_fd_pr__nfet_01v8 ad=0.0813 pd=0.83 as=0.1092 ps=1.36 w=0.42 l=0.15
X2493 VSS.t2150 VDD VSS.t2149 VSS.t2148 sky130_fd_pr__nfet_01v8 ad=0.143 pd=1.62 as=0 ps=0 w=0.55 l=4.73
X2494 VSS.t2681 VDD VSS.t2680 VSS.t2679 sky130_fd_pr__nfet_01v8 ad=0.143 pd=1.62 as=0 ps=0 w=0.55 l=4.73
X2495 VDD VSS.t3445 VDD VDD sky130_fd_pr__pfet_01v8_hvt ad=0.2262 pd=2.26 as=0 ps=0 w=0.87 l=0.59
X2496 VDD VSS.t3858 VDD VDD sky130_fd_pr__pfet_01v8_hvt ad=0.2262 pd=2.26 as=0 ps=0 w=0.87 l=1.97
X2497 _61_.X.t1 a_4535_15823# VDD VDD sky130_fd_pr__pfet_01v8_hvt ad=0.2054 pd=2.1 as=0.11455 ps=1.08 w=0.79 l=0.15
X2498 VDD VSS.t3713 VDD VDD sky130_fd_pr__pfet_01v8_hvt ad=0.2262 pd=2.26 as=0 ps=0 w=0.87 l=1.97
X2499 VDD _50_.B1.t7 a_32503_16919# VDD sky130_fd_pr__pfet_01v8_hvt ad=0.149 pd=1.325 as=0.1664 ps=1.8 w=0.64 l=0.15
X2500 VSS.t2870 VDD VSS.t2869 VSS.t2868 sky130_fd_pr__nfet_01v8 ad=0.143 pd=1.62 as=0 ps=0 w=0.55 l=4.73
X2501 VDD VSS.t3989 VDD VDD sky130_fd_pr__pfet_01v8_hvt ad=0.2262 pd=2.26 as=0 ps=0 w=0.87 l=4.73
X2502 VDD VSS.t4374 VDD VDD sky130_fd_pr__pfet_01v8_hvt ad=0.2262 pd=2.26 as=0 ps=0 w=0.87 l=4.73
X2503 VDD VSS.t3834 VDD VDD sky130_fd_pr__pfet_01v8_hvt ad=0.2262 pd=2.26 as=0 ps=0 w=0.87 l=4.73
X2504 _75_.CLK a_11413_16341.t11 VSS.t140 VSS.t139 sky130_fd_pr__nfet_01v8 ad=0.0588 pd=0.7 as=0.0588 ps=0.7 w=0.42 l=0.15
X2505 a_18225_15279# _36_.B.t6 VSS.t84 VSS.t83 sky130_fd_pr__nfet_01v8 ad=0.08775 pd=0.92 as=0.169 ps=1.82 w=0.65 l=0.15
X2506 VDD VSS.t4245 VDD VDD sky130_fd_pr__pfet_01v8_hvt ad=0.2262 pd=2.26 as=0 ps=0 w=0.87 l=4.73
X2507 VSS.t2329 VDD VSS.t2328 VSS.t2327 sky130_fd_pr__nfet_01v8 ad=0.143 pd=1.62 as=0 ps=0 w=0.55 l=1.97
X2508 VDD VSS.t3837 VDD VDD sky130_fd_pr__pfet_01v8_hvt ad=0.2262 pd=2.26 as=0 ps=0 w=0.87 l=4.73
X2509 VSS.t69 a_26339_15279# _53_.X VSS.t68 sky130_fd_pr__nfet_01v8 ad=0.08775 pd=0.92 as=0.08775 ps=0.92 w=0.65 l=0.15
X2510 VSS.t1708 VDD VSS.t1708 VSS.t1703 sky130_fd_pr__nfet_01v8 ad=0.143 pd=1.62 as=0 ps=0 w=0.55 l=0.59
X2511 VDD input2.X.t12 a_22751_16733# VDD sky130_fd_pr__pfet_01v8_hvt ad=0.1113 pd=1.37 as=0.1113 ps=1.37 w=0.42 l=0.15
X2512 a_27498_15391# a_27330_15645# VDD VDD sky130_fd_pr__pfet_01v8_hvt ad=0.1095 pd=1.075 as=0.17887 ps=1.26 w=0.75 l=0.15
X2513 VDD VSS.t4119 VDD VDD sky130_fd_pr__pfet_01v8_hvt ad=0.2262 pd=2.26 as=0 ps=0 w=0.87 l=4.73
X2514 VSS.t232 a_27755_15645# a_27923_15547# VSS.t231 sky130_fd_pr__nfet_01v8 ad=0.08775 pd=0.92 as=0.169 ps=1.82 w=0.65 l=0.15
X2515 _48_.X a_23027_14735# VSS.t227 VSS.t228 sky130_fd_pr__nfet_01v8 ad=0.08775 pd=0.92 as=0.08775 ps=0.92 w=0.65 l=0.15
X2516 VDD VSS.t4214 VDD VDD sky130_fd_pr__pfet_01v8_hvt ad=0.2262 pd=2.26 as=0 ps=0 w=0.87 l=4.73
X2517 VSS.t2834 VDD VSS.t2833 VSS.t2832 sky130_fd_pr__nfet_01v8 ad=0.143 pd=1.62 as=0 ps=0 w=0.55 l=4.73
X2518 counter_value_o[2] a_12684_16885# VSS.t26 VSS.t25 sky130_fd_pr__nfet_01v8 ad=0.08775 pd=0.92 as=0.17225 ps=1.83 w=0.65 l=0.15
X2519 VDD a_23352_16519# _46_.X VDD sky130_fd_pr__pfet_01v8_hvt ad=0.14825 pd=1.34 as=0.28 ps=2.56 w=1 l=0.15
X2520 VSS.t1147 VDD VSS.t1146 VSS.t1145 sky130_fd_pr__nfet_01v8 ad=0.143 pd=1.62 as=0 ps=0 w=0.55 l=4.73
X2521 VDD VSS.t332 VDD VDD sky130_fd_pr__pfet_01v8_hvt ad=0.2262 pd=2.26 as=0 ps=0 w=0.87 l=1.97
X2522 a_23024_16617# a_22751_16733# _48_.A.t1 VDD sky130_fd_pr__pfet_01v8_hvt ad=0.14 pd=1.28 as=0.265 ps=2.53 w=1 l=0.15
X2523 VDD a_16762_15823.t14 clkbuf_0_clock_i.X VDD sky130_fd_pr__pfet_01v8_hvt ad=0.1375 pd=1.275 as=0.14 ps=1.28 w=1 l=0.15
X2524 VDD VSS.t3745 VDD VDD sky130_fd_pr__pfet_01v8_hvt ad=0.2262 pd=2.26 as=0 ps=0 w=0.87 l=4.73
X2525 a_7716_16885# _63_.A.t17 VSS.t204 VSS.t203 sky130_fd_pr__nfet_01v8 ad=0.1092 pd=1.36 as=0.097 ps=0.975 w=0.42 l=0.15
X2526 _77_.CLK a_21914_15823.t24 VSS.t211 VSS.t210 sky130_fd_pr__nfet_01v8 ad=0.0588 pd=0.7 as=0.0588 ps=0.7 w=0.42 l=0.15
X2527 a_17987_15279# _36_.B.t9 VDD VDD sky130_fd_pr__pfet_01v8_hvt ad=0.135 pd=1.27 as=0.3 ps=2.6 w=1 l=0.15
X2528 VSS.t2556 VDD VSS.t2555 VSS.t2554 sky130_fd_pr__nfet_01v8 ad=0.143 pd=1.62 as=0 ps=0 w=0.55 l=4.73
X2529 VDD VSS.t1170 VDD VDD sky130_fd_pr__pfet_01v8_hvt ad=0.2262 pd=2.26 as=0 ps=0 w=0.87 l=0.59
X2530 VDD VSS.t4360 VDD VDD sky130_fd_pr__pfet_01v8_hvt ad=0.2262 pd=2.26 as=0 ps=0 w=0.87 l=4.73
X2531 VDD _77_.CLK a_22843_15279# VDD sky130_fd_pr__pfet_01v8_hvt ad=0.0864 pd=0.91 as=0.1664 ps=1.8 w=0.64 l=0.15
X2532 VDD VSS.t3710 VDD VDD sky130_fd_pr__pfet_01v8_hvt ad=0.2262 pd=2.26 as=0 ps=0 w=0.87 l=4.73
X2533 VSS.t1544 VDD VSS.t1543 VSS.t1542 sky130_fd_pr__nfet_01v8 ad=0.143 pd=1.62 as=0 ps=0 w=0.55 l=4.73
X2534 VSS.t2879 VDD VSS.t2878 VSS.t2877 sky130_fd_pr__nfet_01v8 ad=0.143 pd=1.62 as=0 ps=0 w=0.55 l=4.73
X2535 VSS.t2051 VDD VSS.t2050 VSS.t2049 sky130_fd_pr__nfet_01v8 ad=0.143 pd=1.62 as=0 ps=0 w=0.55 l=4.73
X2536 VDD _70_.Q _45_.Y VDD sky130_fd_pr__pfet_01v8_hvt ad=0.1824 pd=1.85 as=0.0896 ps=0.92 w=0.64 l=0.15
X2537 VSS.t425 VDD VSS.t424 VSS.t423 sky130_fd_pr__nfet_01v8 ad=0.143 pd=1.62 as=0 ps=0 w=0.55 l=2.89
X2538 VSS.t1675 VDD VSS.t1674 VSS.t1673 sky130_fd_pr__nfet_01v8 ad=0.143 pd=1.62 as=0 ps=0 w=0.55 l=4.73
X2539 VSS.t151 a_11413_16341.t20 _75_.CLK VSS.t152 sky130_fd_pr__nfet_01v8 ad=0.0588 pd=0.7 as=0.0588 ps=0.7 w=0.42 l=0.15
X2540 VSS.t955 VDD VSS.t955 VSS.t954 sky130_fd_pr__nfet_01v8 ad=0.143 pd=1.62 as=0 ps=0 w=0.55 l=0.59
X2541 VSS.t1454 VDD VSS.t1453 VSS.t1452 sky130_fd_pr__nfet_01v8 ad=0.143 pd=1.62 as=0 ps=0 w=0.55 l=4.73
X2542 VSS.t403 VDD VSS.t402 VSS.t401 sky130_fd_pr__nfet_01v8 ad=0.143 pd=1.62 as=0 ps=0 w=0.55 l=4.73
X2543 VDD VSS.t3466 VDD VDD sky130_fd_pr__pfet_01v8_hvt ad=0.2262 pd=2.26 as=0 ps=0 w=0.87 l=0.59
X2544 VDD VSS.t3599 VDD VDD sky130_fd_pr__pfet_01v8_hvt ad=0.2262 pd=2.26 as=0 ps=0 w=0.87 l=4.73
X2545 VSS.t2956 VDD VSS.t2955 VSS.t2954 sky130_fd_pr__nfet_01v8 ad=0.143 pd=1.62 as=0 ps=0 w=0.55 l=4.73
X2546 VSS.t2365 VDD VSS.t2364 VSS.t2363 sky130_fd_pr__nfet_01v8 ad=0.143 pd=1.62 as=0 ps=0 w=0.55 l=4.73
X2547 VDD VSS.t3799 VDD VDD sky130_fd_pr__pfet_01v8_hvt ad=0.2262 pd=2.26 as=0 ps=0 w=0.87 l=4.73
X2548 VSS.t2711 VDD VSS.t2710 VSS.t2709 sky130_fd_pr__nfet_01v8 ad=0.143 pd=1.62 as=0 ps=0 w=0.55 l=4.73
X2549 VSS.t1341 VDD VSS.t1340 VSS.t1339 sky130_fd_pr__nfet_01v8 ad=0.143 pd=1.62 as=0 ps=0 w=0.55 l=4.73
X2550 VSS.t1287 VDD VSS.t1286 VSS.t1285 sky130_fd_pr__nfet_01v8 ad=0.143 pd=1.62 as=0 ps=0 w=0.55 l=4.73
X2551 VDD VSS.t2893 VDD VDD sky130_fd_pr__pfet_01v8_hvt ad=0.2262 pd=2.26 as=0 ps=0 w=0.87 l=0.59
X2552 VSS.t2702 VDD VSS.t2701 VSS.t2700 sky130_fd_pr__nfet_01v8 ad=0.143 pd=1.62 as=0 ps=0 w=0.55 l=4.73
X2553 VSS.t2087 VDD VSS.t2086 VSS.t2085 sky130_fd_pr__nfet_01v8 ad=0.143 pd=1.62 as=0 ps=0 w=0.55 l=4.73
X2554 VDD a_2748_16885# counter_value_o[0] VDD sky130_fd_pr__pfet_01v8_hvt ad=0.149 pd=1.325 as=0.135 ps=1.27 w=1 l=0.15
X2555 VSS.t554 VDD VSS.t553 VSS.t552 sky130_fd_pr__nfet_01v8 ad=0.143 pd=1.62 as=0 ps=0 w=0.55 l=4.73
X2556 VDD VSS.t3764 VDD VDD sky130_fd_pr__pfet_01v8_hvt ad=0.2262 pd=2.26 as=0 ps=0 w=0.87 l=4.73
X2557 VDD VSS.t4393 VDD VDD sky130_fd_pr__pfet_01v8_hvt ad=0.2262 pd=2.26 as=0 ps=0 w=0.87 l=4.73
X2558 VSS.t1084 VDD VSS.t1083 VSS.t1082 sky130_fd_pr__nfet_01v8 ad=0.143 pd=1.62 as=0 ps=0 w=0.55 l=4.73
X2559 VDD VSS.t3448 VDD VDD sky130_fd_pr__pfet_01v8_hvt ad=0.2262 pd=2.26 as=0 ps=0 w=0.87 l=0.59
X2560 VDD VSS.t3994 VDD VDD sky130_fd_pr__pfet_01v8_hvt ad=0.2262 pd=2.26 as=0 ps=0 w=0.87 l=4.73
X2561 VSS.t620 VDD VSS.t619 VSS.t618 sky130_fd_pr__nfet_01v8 ad=0.143 pd=1.62 as=0 ps=0 w=0.55 l=4.73
X2562 VSS.t1926 VDD VSS.t1926 VSS.t1921 sky130_fd_pr__nfet_01v8 ad=0.143 pd=1.62 as=0 ps=0 w=0.55 l=0.59
X2563 VDD _67_.A.t3 a_9523_16143# VDD sky130_fd_pr__pfet_01v8_hvt ad=0.365 pd=1.73 as=0.135 ps=1.27 w=1 l=0.15
X2564 VDD VSS.t4049 VDD VDD sky130_fd_pr__pfet_01v8_hvt ad=0.2262 pd=2.26 as=0 ps=0 w=0.87 l=4.73
X2565 VDD VSS.t4250 VDD VDD sky130_fd_pr__pfet_01v8_hvt ad=0.2262 pd=2.26 as=0 ps=0 w=0.87 l=4.73
X2566 a_20407_15431# a_20503_15253# VDD VDD sky130_fd_pr__pfet_01v8_hvt ad=0.27 pd=2.54 as=0.135 ps=1.27 w=1 l=0.15
X2567 VDD a_20994_15253# a_20923_15279# VDD sky130_fd_pr__pfet_01v8_hvt ad=0.17887 pd=1.26 as=0.1095 ps=1.075 w=0.75 l=0.15
X2568 VSS.t3010 VDD VSS.t3009 VSS.t3008 sky130_fd_pr__nfet_01v8 ad=0.143 pd=1.62 as=0 ps=0 w=0.55 l=4.73
X2569 VSS.t3064 VDD VSS.t3063 VSS.t3062 sky130_fd_pr__nfet_01v8 ad=0.143 pd=1.62 as=0 ps=0 w=0.55 l=4.73
X2570 VDD a_20359_14735# _43_.X VDD sky130_fd_pr__pfet_01v8_hvt ad=0.26 pd=2.52 as=0.135 ps=1.27 w=1 l=0.15
X2571 VDD VSS.t4162 VDD VDD sky130_fd_pr__pfet_01v8_hvt ad=0.2262 pd=2.26 as=0 ps=0 w=0.87 l=1.97
X2572 VDD VSS.t2044 VDD VDD sky130_fd_pr__pfet_01v8_hvt ad=0.2262 pd=2.26 as=0 ps=0 w=0.87 l=4.73
X2573 VDD VSS.t4124 VDD VDD sky130_fd_pr__pfet_01v8_hvt ad=0.2262 pd=2.26 as=0 ps=0 w=0.87 l=4.73
X2574 VSS.t1714 VDD VSS.t1605 VSS.t1713 sky130_fd_pr__nfet_01v8 ad=0.143 pd=1.62 as=0 ps=0 w=0.55 l=4.73
X2575 a_28787_16885# _55_.A_N VDD VDD sky130_fd_pr__pfet_01v8_hvt ad=0.1092 pd=1.36 as=0.0567 ps=0.69 w=0.42 l=0.15
X2576 VDD input1.X.t9 _36_.B.t0 VDD sky130_fd_pr__pfet_01v8_hvt ad=0.165 pd=1.33 as=0.135 ps=1.27 w=1 l=0.15
X2577 VDD VSS.t1063 VDD VDD sky130_fd_pr__pfet_01v8_hvt ad=0.2262 pd=2.26 as=0 ps=0 w=0.87 l=0.59
X2578 VDD VSS.t3596 VDD VDD sky130_fd_pr__pfet_01v8_hvt ad=0.2262 pd=2.26 as=0 ps=0 w=0.87 l=4.73
X2579 VSS.t2965 VDD VSS.t2964 VSS.t2963 sky130_fd_pr__nfet_01v8 ad=0.143 pd=1.62 as=0 ps=0 w=0.55 l=4.73
X2580 VDD VSS.t3925 VDD VDD sky130_fd_pr__pfet_01v8_hvt ad=0.2262 pd=2.26 as=0 ps=0 w=0.87 l=4.73
X2581 VSS.t1798 VDD VSS.t1797 VSS.t1796 sky130_fd_pr__nfet_01v8 ad=0.143 pd=1.62 as=0 ps=0 w=0.55 l=1.97
X2582 VDD VSS.t3644 VDD VDD sky130_fd_pr__pfet_01v8_hvt ad=0.2262 pd=2.26 as=0 ps=0 w=0.87 l=4.73
X2583 VSS.t1989 VDD VSS.t1988 VSS.t1987 sky130_fd_pr__nfet_01v8 ad=0.143 pd=1.62 as=0 ps=0 w=0.55 l=4.73
X2584 VDD VSS.t3582 VDD VDD sky130_fd_pr__pfet_01v8_hvt ad=0.2262 pd=2.26 as=0 ps=0 w=0.87 l=4.73
X2585 VSS.t2466 VDD VSS.t2465 VSS.t2464 sky130_fd_pr__nfet_01v8 ad=0.143 pd=1.62 as=0 ps=0 w=0.55 l=4.73
X2586 VSS.t2222 VDD VSS.t2221 VSS.t2220 sky130_fd_pr__nfet_01v8 ad=0.143 pd=1.62 as=0 ps=0 w=0.55 l=4.73
X2587 VSS.t1000 VDD VSS.t999 VSS.t998 sky130_fd_pr__nfet_01v8 ad=0.143 pd=1.62 as=0 ps=0 w=0.55 l=4.73
X2588 VSS.t1893 VDD VSS.t1892 VSS.t1891 sky130_fd_pr__nfet_01v8 ad=0.143 pd=1.62 as=0 ps=0 w=0.55 l=4.73
X2589 VDD VSS.t955 VDD VDD sky130_fd_pr__pfet_01v8_hvt ad=0.2262 pd=2.26 as=0 ps=0 w=0.87 l=0.59
X2590 hold12.A _55_.Y a_27133_16617# VDD sky130_fd_pr__pfet_01v8_hvt ad=0.455 pd=2.91 as=0.1375 ps=1.275 w=1 l=0.15
X2591 VDD VSS.t4263 VDD VDD sky130_fd_pr__pfet_01v8_hvt ad=0.2262 pd=2.26 as=0 ps=0 w=0.87 l=1.97
X2592 VDD VSS.t3910 VDD VDD sky130_fd_pr__pfet_01v8_hvt ad=0.2262 pd=2.26 as=0 ps=0 w=0.87 l=4.73
X2593 VDD VSS.t3729 VDD VDD sky130_fd_pr__pfet_01v8_hvt ad=0.2262 pd=2.26 as=0 ps=0 w=0.87 l=4.73
X2594 _38_.X a_18611_15831# VSS.t30 VSS.t3324 sky130_fd_pr__nfet_01v8 ad=0.08775 pd=0.92 as=0.097 ps=0.975 w=0.65 l=0.15
X2595 VDD VSS.t3546 VDD VDD sky130_fd_pr__pfet_01v8_hvt ad=0.2262 pd=2.26 as=0 ps=0 w=0.87 l=4.73
X2596 VDD VSS.t4176 VDD VDD sky130_fd_pr__pfet_01v8_hvt ad=0.2262 pd=2.26 as=0 ps=0 w=0.87 l=4.73
X2597 VSS.t2120 VDD VSS.t2119 VSS.t2118 sky130_fd_pr__nfet_01v8 ad=0.143 pd=1.62 as=0 ps=0 w=0.55 l=4.73
X2598 VSS.t749 VDD VSS.t748 VSS.t747 sky130_fd_pr__nfet_01v8 ad=0.143 pd=1.62 as=0 ps=0 w=0.55 l=4.73
X2599 VSS.t1347 VDD VSS.t1346 VSS.t1345 sky130_fd_pr__nfet_01v8 ad=0.143 pd=1.62 as=0 ps=0 w=0.55 l=4.73
X2600 _75_.CLK a_11413_16341.t33 VDD VDD sky130_fd_pr__pfet_01v8_hvt ad=0.14 pd=1.28 as=0.14 ps=1.28 w=1 l=0.15
X2601 a_11413_16341.t4 clkbuf_0_clock_i.X VDD VDD sky130_fd_pr__pfet_01v8_hvt ad=0.14 pd=1.28 as=0.14 ps=1.28 w=1 l=0.15
X2602 VSS.t548 VDD VSS.t547 VSS.t546 sky130_fd_pr__nfet_01v8 ad=0.143 pd=1.62 as=0 ps=0 w=0.55 l=4.73
X2603 VDD VSS.t4145 VDD VDD sky130_fd_pr__pfet_01v8_hvt ad=0.2262 pd=2.26 as=0 ps=0 w=0.87 l=4.73
X2604 VDD VSS.t4266 VDD VDD sky130_fd_pr__pfet_01v8_hvt ad=0.2262 pd=2.26 as=0 ps=0 w=0.87 l=4.73
X2605 VSS.t2908 VDD VSS.t2907 VSS.t2906 sky130_fd_pr__nfet_01v8 ad=0.143 pd=1.62 as=0 ps=0 w=0.55 l=4.73
X2606 VDD VSS.t3890 VDD VDD sky130_fd_pr__pfet_01v8_hvt ad=0.2262 pd=2.26 as=0 ps=0 w=0.87 l=4.73
X2607 VSS.t830 VDD VSS.t829 VSS.t828 sky130_fd_pr__nfet_01v8 ad=0.143 pd=1.62 as=0 ps=0 w=0.55 l=4.73
X2608 VSS.t626 VDD VSS.t625 VSS.t624 sky130_fd_pr__nfet_01v8 ad=0.143 pd=1.62 as=0 ps=0 w=0.55 l=1.97
X2609 VSS.t465 VDD VSS.t464 VSS.t463 sky130_fd_pr__nfet_01v8 ad=0.143 pd=1.62 as=0 ps=0 w=0.55 l=4.73
X2610 VDD VSS.t3569 VDD VDD sky130_fd_pr__pfet_01v8_hvt ad=0.2262 pd=2.26 as=0 ps=0 w=0.87 l=4.73
X2611 VDD VSS.t2259 VDD VDD sky130_fd_pr__pfet_01v8_hvt ad=0.2262 pd=2.26 as=0 ps=0 w=0.87 l=4.73
X2612 VDD VSS.t4092 VDD VDD sky130_fd_pr__pfet_01v8_hvt ad=0.2262 pd=2.26 as=0 ps=0 w=0.87 l=1.97
X2613 a_7442_16479# a_7274_16733# VDD VDD sky130_fd_pr__pfet_01v8_hvt ad=0.1095 pd=1.075 as=0.17887 ps=1.26 w=0.75 l=0.15
X2614 VDD VSS.t4054 VDD VDD sky130_fd_pr__pfet_01v8_hvt ad=0.2262 pd=2.26 as=0 ps=0 w=0.87 l=4.73
X2615 VSS.t102 a_7699_16733# a_7867_16635# VSS.t101 sky130_fd_pr__nfet_01v8 ad=0.08775 pd=0.92 as=0.169 ps=1.82 w=0.65 l=0.15
X2616 VDD VSS.t4182 VDD VDD sky130_fd_pr__pfet_01v8_hvt ad=0.2262 pd=2.26 as=0 ps=0 w=0.87 l=1.97
X2617 VSS.t366 VDD VSS.t365 VSS.t364 sky130_fd_pr__nfet_01v8 ad=0.143 pd=1.62 as=0 ps=0 w=0.55 l=4.73
X2618 VDD VSS.t4326 VDD VDD sky130_fd_pr__pfet_01v8_hvt ad=0.2262 pd=2.26 as=0 ps=0 w=0.87 l=4.73
X2619 VSS.t2275 VDD VSS.t2274 VSS.t2273 sky130_fd_pr__nfet_01v8 ad=0.143 pd=1.62 as=0 ps=0 w=0.55 l=4.73
X2620 VDD VSS.t1278 VDD VDD sky130_fd_pr__pfet_01v8_hvt ad=0.2262 pd=2.26 as=0 ps=0 w=0.87 l=0.59
X2621 VDD VSS.t4396 VDD VDD sky130_fd_pr__pfet_01v8_hvt ad=0.2262 pd=2.26 as=0 ps=0 w=0.87 l=0.59
X2622 VDD VSS.t4167 VDD VDD sky130_fd_pr__pfet_01v8_hvt ad=0.2262 pd=2.26 as=0 ps=0 w=0.87 l=1.97
X2623 VDD VSS.t3851 VDD VDD sky130_fd_pr__pfet_01v8_hvt ad=0.2262 pd=2.26 as=0 ps=0 w=0.87 l=4.73
X2624 VSS.t2437 VDD VSS.t2436 VSS.t2435 sky130_fd_pr__nfet_01v8 ad=0.143 pd=1.62 as=0 ps=0 w=0.55 l=4.73
X2625 VDD VSS.t3775 VDD VDD sky130_fd_pr__pfet_01v8_hvt ad=0.2262 pd=2.26 as=0 ps=0 w=0.87 l=4.73
X2626 VDD VSS.t4328 VDD VDD sky130_fd_pr__pfet_01v8_hvt ad=0.2262 pd=2.26 as=0 ps=0 w=0.87 l=4.73
X2627 VSS.t1063 VDD VSS.t1063 VSS.t1058 sky130_fd_pr__nfet_01v8 ad=0.143 pd=1.62 as=0 ps=0 w=0.55 l=0.59
X2628 VSS.t985 VDD VSS.t984 VSS.t983 sky130_fd_pr__nfet_01v8 ad=0.143 pd=1.62 as=0 ps=0 w=0.55 l=4.73
X2629 VDD VSS.t1170 VDD VDD sky130_fd_pr__pfet_01v8_hvt ad=0.2262 pd=2.26 as=0 ps=0 w=0.87 l=0.59
X2630 VDD VSS.t499 VDD VDD sky130_fd_pr__pfet_01v8_hvt ad=0.2262 pd=2.26 as=0 ps=0 w=0.87 l=0.59
X2631 VSS.t2350 VDD VSS.t2349 VSS.t2348 sky130_fd_pr__nfet_01v8 ad=0.143 pd=1.62 as=0 ps=0 w=0.55 l=4.73
X2632 VSS.t1553 VDD VSS.t1552 VSS.t1551 sky130_fd_pr__nfet_01v8 ad=0.143 pd=1.62 as=0 ps=0 w=0.55 l=4.73
X2633 VDD VSS.t3951 VDD VDD sky130_fd_pr__pfet_01v8_hvt ad=0.2262 pd=2.26 as=0 ps=0 w=0.87 l=4.73
X2634 VSS.t333 VDD VSS.t332 VSS.t331 sky130_fd_pr__nfet_01v8 ad=0.143 pd=1.62 as=0 ps=0 w=0.55 l=1.97
X2635 VDD VSS.t3507 VDD VDD sky130_fd_pr__pfet_01v8_hvt ad=0.2262 pd=2.26 as=0 ps=0 w=0.87 l=4.73
X2636 VSS.t3286 _56_.Y _57_.Y VSS.t3285 sky130_fd_pr__nfet_01v8 ad=0.169 pd=1.82 as=0.08775 ps=0.92 w=0.65 l=0.15
X2637 VDD VSS.t4106 VDD VDD sky130_fd_pr__pfet_01v8_hvt ad=0.2262 pd=2.26 as=0 ps=0 w=0.87 l=4.73
X2638 VDD a_23450_15391# a_23377_15645# VDD sky130_fd_pr__pfet_01v8_hvt ad=0.17887 pd=1.26 as=0.07665 ps=0.785 w=0.42 l=0.15
X2639 VSS.t923 VDD VSS.t922 VSS.t921 sky130_fd_pr__nfet_01v8 ad=0.143 pd=1.62 as=0 ps=0 w=0.55 l=4.73
X2640 _50_.A2 _70_.Q a_22273_16367# VSS.t3436 sky130_fd_pr__nfet_01v8 ad=0.169 pd=1.82 as=0.10725 ps=0.98 w=0.65 l=0.15
X2641 VDD VSS.t4037 VDD VDD sky130_fd_pr__pfet_01v8_hvt ad=0.2262 pd=2.26 as=0 ps=0 w=0.87 l=1.97
X2642 VSS.t197 _77_.CLK a_22843_15279# VSS.t264 sky130_fd_pr__nfet_01v8 ad=0.0567 pd=0.69 as=0.1092 ps=1.36 w=0.42 l=0.15
X2643 VDD VSS.t3980 VDD VDD sky130_fd_pr__pfet_01v8_hvt ad=0.2262 pd=2.26 as=0 ps=0 w=0.87 l=4.73
X2644 VSS.t743 VDD VSS.t742 VSS.t741 sky130_fd_pr__nfet_01v8 ad=0.143 pd=1.62 as=0 ps=0 w=0.55 l=4.73
X2645 VSS.t3082 VDD VSS.t3081 VSS.t3080 sky130_fd_pr__nfet_01v8 ad=0.143 pd=1.62 as=0 ps=0 w=0.55 l=4.73
X2646 VDD VSS.t4075 VDD VDD sky130_fd_pr__pfet_01v8_hvt ad=0.2262 pd=2.26 as=0 ps=0 w=0.87 l=4.73
X2647 counter_value_o[5] a_27535_16919# VDD VDD sky130_fd_pr__pfet_01v8_hvt ad=0.135 pd=1.27 as=0.149 ps=1.325 w=1 l=0.15
X2648 VSS.t1332 VDD VSS.t1331 VSS.t1330 sky130_fd_pr__nfet_01v8 ad=0.143 pd=1.62 as=0 ps=0 w=0.55 l=4.73
X2649 VDD a_28859_16733# a_29027_16635# VDD sky130_fd_pr__pfet_01v8_hvt ad=0.135 pd=1.27 as=0.27 ps=2.54 w=1 l=0.15
X2650 VDD VSS.t4236 VDD VDD sky130_fd_pr__pfet_01v8_hvt ad=0.2262 pd=2.26 as=0 ps=0 w=0.87 l=4.73
X2651 VDD VSS.t2893 VDD VDD sky130_fd_pr__pfet_01v8_hvt ad=0.2262 pd=2.26 as=0 ps=0 w=0.87 l=0.59
X2652 VSS.t1786 VDD VSS.t1785 VSS.t1784 sky130_fd_pr__nfet_01v8 ad=0.143 pd=1.62 as=0 ps=0 w=0.55 l=4.73
X2653 VSS.t2505 VDD VSS.t2504 VSS.t2503 sky130_fd_pr__nfet_01v8 ad=0.143 pd=1.62 as=0 ps=0 w=0.55 l=4.73
X2654 VSS.t836 VDD VSS.t835 VSS.t834 sky130_fd_pr__nfet_01v8 ad=0.143 pd=1.62 as=0 ps=0 w=0.55 l=1.97
X2655 a_5013_16733# a_4675_16519# VDD VDD sky130_fd_pr__pfet_01v8_hvt ad=0.0882 pd=0.84 as=0.1113 ps=1.37 w=0.42 l=0.15
X2656 clkbuf_0_clock_i.X a_16762_15823.t7 VDD VDD sky130_fd_pr__pfet_01v8_hvt ad=0.14 pd=1.28 as=0.14 ps=1.28 w=1 l=0.15
X2657 VDD VSS.t3537 VDD VDD sky130_fd_pr__pfet_01v8_hvt ad=0.2262 pd=2.26 as=0 ps=0 w=0.87 l=1.97
X2658 VSS.t2905 VDD VSS.t2904 VSS.t2903 sky130_fd_pr__nfet_01v8 ad=0.143 pd=1.62 as=0 ps=0 w=0.55 l=4.73
X2659 VDD VSS.t4112 VDD VDD sky130_fd_pr__pfet_01v8_hvt ad=0.2262 pd=2.26 as=0 ps=0 w=0.87 l=1.97
X2660 VDD VSS.t4097 VDD VDD sky130_fd_pr__pfet_01v8_hvt ad=0.2262 pd=2.26 as=0 ps=0 w=0.87 l=1.97
X2661 _63_.A.t1 a_7867_16635# VDD VDD sky130_fd_pr__pfet_01v8_hvt ad=0.26 pd=2.52 as=0.135 ps=1.27 w=1 l=0.15
X2662 VSS.t950 VDD VSS.t949 VSS.t948 sky130_fd_pr__nfet_01v8 ad=0.143 pd=1.62 as=0 ps=0 w=0.55 l=1.97
X2663 VSS.t303 VDD VSS.t302 VSS.t301 sky130_fd_pr__nfet_01v8 ad=0.143 pd=1.62 as=0 ps=0 w=0.55 l=4.73
X2664 VSS.t2162 VDD VSS.t2161 VSS.t2160 sky130_fd_pr__nfet_01v8 ad=0.143 pd=1.62 as=0 ps=0 w=0.55 l=4.73
X2665 VDD VSS.t3705 VDD VDD sky130_fd_pr__pfet_01v8_hvt ad=0.2262 pd=2.26 as=0 ps=0 w=0.87 l=4.73
X2666 VDD VSS.t3823 VDD VDD sky130_fd_pr__pfet_01v8_hvt ad=0.2262 pd=2.26 as=0 ps=0 w=0.87 l=4.73
X2667 VDD VSS.t3588 VDD VDD sky130_fd_pr__pfet_01v8_hvt ad=0.2262 pd=2.26 as=0 ps=0 w=0.87 l=1.05
X2668 _75_.CLK a_11413_16341.t23 VSS.t125 VSS.t124 sky130_fd_pr__nfet_01v8 ad=0.0588 pd=0.7 as=0.1113 ps=1.37 w=0.42 l=0.15
X2669 _75_.CLK a_11413_16341.t13 VSS.t143 VSS.t142 sky130_fd_pr__nfet_01v8 ad=0.0588 pd=0.7 as=0.0588 ps=0.7 w=0.42 l=0.15
X2670 VDD VSS.t3963 VDD VDD sky130_fd_pr__pfet_01v8_hvt ad=0.2262 pd=2.26 as=0 ps=0 w=0.87 l=4.73
X2671 VDD VSS.t1063 VDD VDD sky130_fd_pr__pfet_01v8_hvt ad=0.2262 pd=2.26 as=0 ps=0 w=0.87 l=0.59
X2672 VDD VSS.t3971 VDD VDD sky130_fd_pr__pfet_01v8_hvt ad=0.2262 pd=2.26 as=0 ps=0 w=0.87 l=4.73
X2673 VSS.t1559 VDD VSS.t1558 VSS.t1557 sky130_fd_pr__nfet_01v8 ad=0.143 pd=1.62 as=0 ps=0 w=0.55 l=4.73
X2674 VDD VSS.t493 VDD VDD sky130_fd_pr__pfet_01v8_hvt ad=0.2262 pd=2.26 as=0 ps=0 w=0.87 l=0.59
X2675 _77_.CLK a_21914_15823.t36 VSS.t173 VSS.t172 sky130_fd_pr__nfet_01v8 ad=0.0588 pd=0.7 as=0.0588 ps=0.7 w=0.42 l=0.15
X2676 VSS.t227 a_23027_14735# _48_.X VSS.t226 sky130_fd_pr__nfet_01v8 ad=0.08775 pd=0.92 as=0.08775 ps=0.92 w=0.65 l=0.15
X2677 VDD VSS.t4197 VDD VDD sky130_fd_pr__pfet_01v8_hvt ad=0.2262 pd=2.26 as=0 ps=0 w=0.87 l=4.73
X2678 VDD VSS.t4377 VDD VDD sky130_fd_pr__pfet_01v8_hvt ad=0.2262 pd=2.26 as=0 ps=0 w=0.87 l=0.59
X2679 VSS.t2625 VDD VSS.t2624 VSS.t2623 sky130_fd_pr__nfet_01v8 ad=0.143 pd=1.62 as=0 ps=0 w=0.55 l=4.73
X2680 VSS.t2180 VDD VSS.t2179 VSS.t2178 sky130_fd_pr__nfet_01v8 ad=0.143 pd=1.62 as=0 ps=0 w=0.55 l=4.73
X2681 VSS.t2816 VDD VSS.t2815 VSS.t2814 sky130_fd_pr__nfet_01v8 ad=0.143 pd=1.62 as=0 ps=0 w=0.55 l=4.73
X2682 VDD VSS.t405 VDD VDD sky130_fd_pr__pfet_01v8_hvt ad=0.2262 pd=2.26 as=0 ps=0 w=0.87 l=0.59
X2683 VSS.t2084 VDD VSS.t2083 VSS.t2082 sky130_fd_pr__nfet_01v8 ad=0.143 pd=1.62 as=0 ps=0 w=0.55 l=1.97
X2684 clkbuf_0_clock_i.X a_16762_15823.t27 VSS.t76 VSS.t75 sky130_fd_pr__nfet_01v8 ad=0.0588 pd=0.7 as=0.0588 ps=0.7 w=0.42 l=0.15
X2685 VSS.t720 VDD VSS.t719 VSS.t718 sky130_fd_pr__nfet_01v8 ad=0.143 pd=1.62 as=0 ps=0 w=0.55 l=1.97
X2686 VDD VSS.t4395 VDD VDD sky130_fd_pr__pfet_01v8_hvt ad=0.2262 pd=2.26 as=0 ps=0 w=0.87 l=1.05
X2687 VDD VSS.t4188 VDD VDD sky130_fd_pr__pfet_01v8_hvt ad=0.2262 pd=2.26 as=0 ps=0 w=0.87 l=1.97
X2688 VSS.t2377 VDD VSS.t2376 VSS.t2375 sky130_fd_pr__nfet_01v8 ad=0.143 pd=1.62 as=0 ps=0 w=0.55 l=4.73
X2689 VDD VSS.t3795 VDD VDD sky130_fd_pr__pfet_01v8_hvt ad=0.2262 pd=2.26 as=0 ps=0 w=0.87 l=4.73
X2690 VSS.t1813 VDD VSS.t1812 VSS.t1811 sky130_fd_pr__nfet_01v8 ad=0.143 pd=1.62 as=0 ps=0 w=0.55 l=1.97
X2691 VDD VSS.t3753 VDD VDD sky130_fd_pr__pfet_01v8_hvt ad=0.2262 pd=2.26 as=0 ps=0 w=0.87 l=4.73
X2692 VSS.t711 VDD VSS.t710 VSS.t709 sky130_fd_pr__nfet_01v8 ad=0.143 pd=1.62 as=0 ps=0 w=0.55 l=4.73
X2693 VDD VSS.t3553 VDD VDD sky130_fd_pr__pfet_01v8_hvt ad=0.2262 pd=2.26 as=0 ps=0 w=0.87 l=4.73
X2694 VSS.t1093 VDD VSS.t1092 VSS.t1091 sky130_fd_pr__nfet_01v8 ad=0.143 pd=1.62 as=0 ps=0 w=0.55 l=4.73
X2695 VSS.t1027 VDD VSS.t1026 VSS.t1025 sky130_fd_pr__nfet_01v8 ad=0.143 pd=1.62 as=0 ps=0 w=0.55 l=4.73
X2696 counter_value_o[0] a_2748_16885# VDD VDD sky130_fd_pr__pfet_01v8_hvt ad=0.135 pd=1.27 as=0.265 ps=2.53 w=1 l=0.15
X2697 VDD VSS.t1278 VDD VDD sky130_fd_pr__pfet_01v8_hvt ad=0.2262 pd=2.26 as=0 ps=0 w=0.87 l=0.59
X2698 VDD VSS.t3998 VDD VDD sky130_fd_pr__pfet_01v8_hvt ad=0.2262 pd=2.26 as=0 ps=0 w=0.87 l=1.97
X2699 VSS.t2855 VDD VSS.t2854 VSS.t2853 sky130_fd_pr__nfet_01v8 ad=0.143 pd=1.62 as=0 ps=0 w=0.55 l=4.73
X2700 VDD VSS.t3968 VDD VDD sky130_fd_pr__pfet_01v8_hvt ad=0.2262 pd=2.26 as=0 ps=0 w=0.87 l=4.73
X2701 VDD VSS.t3679 VDD VDD sky130_fd_pr__pfet_01v8_hvt ad=0.2262 pd=2.26 as=0 ps=0 w=0.87 l=4.73
X2702 VSS.t528 VDD VSS.t527 VSS.t526 sky130_fd_pr__nfet_01v8 ad=0.143 pd=1.62 as=0 ps=0 w=0.55 l=4.73
X2703 VDD VSS.t4006 VDD VDD sky130_fd_pr__pfet_01v8_hvt ad=0.2262 pd=2.26 as=0 ps=0 w=0.87 l=4.73
X2704 VSS.t294 VDD VSS.t293 VSS.t292 sky130_fd_pr__nfet_01v8 ad=0.143 pd=1.62 as=0 ps=0 w=0.55 l=0.59
X2705 _61_.X.t0 a_4535_15823# VSS.t36 VSS.t35 sky130_fd_pr__nfet_01v8 ad=0.1352 pd=1.56 as=0.0754 ps=0.81 w=0.52 l=0.15
X2706 VDD VSS.t3562 VDD VDD sky130_fd_pr__pfet_01v8_hvt ad=0.2262 pd=2.26 as=0 ps=0 w=0.87 l=4.73
X2707 VDD VSS.t3541 VDD VDD sky130_fd_pr__pfet_01v8_hvt ad=0.2262 pd=2.26 as=0 ps=0 w=0.87 l=4.73
X2708 VDD a_27755_15645# a_27923_15547# VDD sky130_fd_pr__pfet_01v8_hvt ad=0.135 pd=1.27 as=0.27 ps=2.54 w=1 l=0.15
X2709 VSS.t2395 VDD VSS.t2394 VSS.t2393 sky130_fd_pr__nfet_01v8 ad=0.143 pd=1.62 as=0 ps=0 w=0.55 l=4.73
X2710 VDD VSS.t3789 VDD VDD sky130_fd_pr__pfet_01v8_hvt ad=0.2262 pd=2.26 as=0 ps=0 w=0.87 l=4.73
X2711 VDD VSS.t4397 VDD VDD sky130_fd_pr__pfet_01v8_hvt ad=0.2262 pd=2.26 as=0 ps=0 w=0.87 l=0.59
X2712 _53_.A.t2 a_25460_15797# a_25235_15823# VDD sky130_fd_pr__pfet_01v8_hvt ad=0.265 pd=2.53 as=0.14 ps=1.28 w=1 l=0.15
X2713 VSS.t1726 VDD VSS.t1725 VSS.t1724 sky130_fd_pr__nfet_01v8 ad=0.143 pd=1.62 as=0 ps=0 w=0.55 l=4.73
X2714 VSS.t1657 VDD VSS.t1656 VSS.t1655 sky130_fd_pr__nfet_01v8 ad=0.143 pd=1.62 as=0 ps=0 w=0.55 l=4.73
X2715 VSS.t1374 VDD VSS.t1373 VSS.t1372 sky130_fd_pr__nfet_01v8 ad=0.143 pd=1.62 as=0 ps=0 w=0.55 l=4.73
X2716 VDD VSS.t4381 VDD VDD sky130_fd_pr__pfet_01v8_hvt ad=0.2262 pd=2.26 as=0 ps=0 w=0.87 l=0.59
X2717 VDD VSS.t2786 VDD VDD sky130_fd_pr__pfet_01v8_hvt ad=0.2262 pd=2.26 as=0 ps=0 w=0.87 l=0.59
X2718 VSS.t522 VDD VSS.t521 VSS.t520 sky130_fd_pr__nfet_01v8 ad=0.143 pd=1.62 as=0 ps=0 w=0.55 l=4.73
X2719 a_26965_16617# _57_.Y VDD VDD sky130_fd_pr__pfet_01v8_hvt ad=0.135 pd=1.27 as=0.135 ps=1.27 w=1 l=0.15
X2720 VDD VSS.t4257 VDD VDD sky130_fd_pr__pfet_01v8_hvt ad=0.2262 pd=2.26 as=0 ps=0 w=0.87 l=4.73
X2721 VSS.t499 VDD VSS.t499 VSS.t498 sky130_fd_pr__nfet_01v8 ad=0.143 pd=1.62 as=0 ps=0 w=0.55 l=0.59
X2722 VDD _53_.A.t4 a_26339_15279# VDD sky130_fd_pr__pfet_01v8_hvt ad=0.135 pd=1.27 as=0.26 ps=2.52 w=1 l=0.15
X2723 VSS.t2541 VDD VSS.t2540 VSS.t2539 sky130_fd_pr__nfet_01v8 ad=0.143 pd=1.62 as=0 ps=0 w=0.55 l=4.73
X2724 VSS.t20 _36_.B.t13 a_20627_16189# VSS.t19 sky130_fd_pr__nfet_01v8 ad=0.0588 pd=0.7 as=0.0588 ps=0.7 w=0.42 l=0.15
X2725 a_17857_16367# a_17691_16367# VDD VDD sky130_fd_pr__pfet_01v8_hvt ad=0.1664 pd=1.8 as=0.0864 ps=0.91 w=0.64 l=0.15
X2726 VSS.t3040 VDD VSS.t3039 VSS.t3038 sky130_fd_pr__nfet_01v8 ad=0.143 pd=1.62 as=0 ps=0 w=0.55 l=4.73
X2727 VDD VSS.t3725 VDD VDD sky130_fd_pr__pfet_01v8_hvt ad=0.2262 pd=2.26 as=0 ps=0 w=0.87 l=4.73
X2728 a_21099_16617# _40_.A1 a_21003_16617# VDD sky130_fd_pr__pfet_01v8_hvt ad=0.0441 pd=0.63 as=0.0693 ps=0.75 w=0.42 l=0.15
X2729 VDD VSS.t4158 VDD VDD sky130_fd_pr__pfet_01v8_hvt ad=0.2262 pd=2.26 as=0 ps=0 w=0.87 l=4.73
X2730 VSS.t1744 VDD VSS.t1743 VSS.t1742 sky130_fd_pr__nfet_01v8 ad=0.143 pd=1.62 as=0 ps=0 w=0.55 l=4.73
X2731 _75_.CLK a_11413_16341.t35 VDD VDD sky130_fd_pr__pfet_01v8_hvt ad=0.14 pd=1.28 as=0.14 ps=1.28 w=1 l=0.15
X2732 VDD VSS.t4142 VDD VDD sky130_fd_pr__pfet_01v8_hvt ad=0.2262 pd=2.26 as=0 ps=0 w=0.87 l=4.73
X2733 VDD VSS.t4270 VDD VDD sky130_fd_pr__pfet_01v8_hvt ad=0.2262 pd=2.26 as=0 ps=0 w=0.87 l=4.73
X2734 VDD VSS.t3604 VDD VDD sky130_fd_pr__pfet_01v8_hvt ad=0.2262 pd=2.26 as=0 ps=0 w=0.87 l=4.73
X2735 VSS.t2941 VDD VSS.t2940 VSS.t2939 sky130_fd_pr__nfet_01v8 ad=0.143 pd=1.62 as=0 ps=0 w=0.55 l=4.73
X2736 a_28253_15823# a_28017_15823# VSS.t3336 VSS.t3337 sky130_fd_pr__nfet_01v8 ad=0.1092 pd=1.36 as=0.0567 ps=0.69 w=0.42 l=0.5
X2737 VSS.t1469 VDD VSS.t1468 VSS.t1467 sky130_fd_pr__nfet_01v8 ad=0.143 pd=1.62 as=0 ps=0 w=0.55 l=4.73
X2738 VSS.t854 VDD VSS.t853 VSS.t852 sky130_fd_pr__nfet_01v8 ad=0.143 pd=1.62 as=0 ps=0 w=0.55 l=4.73
X2739 VSS.t1012 VDD VSS.t1011 VSS.t1010 sky130_fd_pr__nfet_01v8 ad=0.143 pd=1.62 as=0 ps=0 w=0.55 l=4.73
X2740 VDD VSS.t3556 VDD VDD sky130_fd_pr__pfet_01v8_hvt ad=0.2262 pd=2.26 as=0 ps=0 w=0.87 l=4.73
X2741 VSS.t2484 VDD VSS.t2483 VSS.t2482 sky130_fd_pr__nfet_01v8 ad=0.143 pd=1.62 as=0 ps=0 w=0.55 l=1.97
X2742 VDD VSS.t4003 VDD VDD sky130_fd_pr__pfet_01v8_hvt ad=0.2262 pd=2.26 as=0 ps=0 w=0.87 l=1.97
X2743 VDD _77_.Q _44_.Y VDD sky130_fd_pr__pfet_01v8_hvt ad=0.26 pd=2.52 as=0.135 ps=1.27 w=1 l=0.15
X2744 VDD VSS.t3530 VDD VDD sky130_fd_pr__pfet_01v8_hvt ad=0.2262 pd=2.26 as=0 ps=0 w=0.87 l=4.73
X2745 VSS.t3181 VDD VSS.t3180 VSS.t3179 sky130_fd_pr__nfet_01v8 ad=0.143 pd=1.62 as=0 ps=0 w=0.55 l=0.59
X2746 VSS.t3133 VDD VSS.t3132 VSS.t3131 sky130_fd_pr__nfet_01v8 ad=0.143 pd=1.62 as=0 ps=0 w=0.55 l=4.73
X2747 VDD VSS.t3719 VDD VDD sky130_fd_pr__pfet_01v8_hvt ad=0.2262 pd=2.26 as=0 ps=0 w=0.87 l=4.73
X2748 VDD VSS.t3918 VDD VDD sky130_fd_pr__pfet_01v8_hvt ad=0.2262 pd=2.26 as=0 ps=0 w=0.87 l=1.97
X2749 VDD VSS.t4280 VDD VDD sky130_fd_pr__pfet_01v8_hvt ad=0.2262 pd=2.26 as=0 ps=0 w=0.87 l=4.73
X2750 VSS.t2798 VDD VSS.t2797 VSS.t2796 sky130_fd_pr__nfet_01v8 ad=0.143 pd=1.62 as=0 ps=0 w=0.55 l=1.05
X2751 VSS.t1875 VDD VSS.t1874 VSS.t1873 sky130_fd_pr__nfet_01v8 ad=0.143 pd=1.62 as=0 ps=0 w=0.55 l=4.73
X2752 VDD VSS.t4028 VDD VDD sky130_fd_pr__pfet_01v8_hvt ad=0.2262 pd=2.26 as=0 ps=0 w=0.87 l=4.73
X2753 VSS.t2096 VDD VSS.t2095 VSS.t2094 sky130_fd_pr__nfet_01v8 ad=0.143 pd=1.62 as=0 ps=0 w=0.55 l=4.73
X2754 VDD VSS.t3816 VDD VDD sky130_fd_pr__pfet_01v8_hvt ad=0.2262 pd=2.26 as=0 ps=0 w=0.87 l=4.73
X2755 VDD VSS.t3898 VDD VDD sky130_fd_pr__pfet_01v8_hvt ad=0.2262 pd=2.26 as=0 ps=0 w=0.87 l=4.73
R0 VSS.t3116 VSS.t3113 15720.4
R1 VSS.t3122 VSS.t3119 15720.4
R2 VSS.t3128 VSS.t3131 15720.4
R3 VSS.t3137 VSS.t3140 15720.4
R4 VSS.t3146 VSS.t3149 15720.4
R5 VSS.t3155 VSS.t3158 15720.4
R6 VSS.t3164 VSS.t3167 15720.4
R7 VSS.t3173 VSS.t3176 15720.4
R8 VSS.t3182 VSS.t3185 15720.4
R9 VSS.t3191 VSS.t3194 15720.4
R10 VSS.t3200 VSS.t3203 15720.4
R11 VSS.t3209 VSS.t3212 15720.4
R12 VSS.t3221 VSS.t3218 15720.4
R13 VSS.t3227 VSS.t3230 15720.4
R14 VSS.t3113 VSS.t3110 9825.24
R15 VSS.n15270 VSS.t3116 9825.24
R16 VSS.t3125 VSS.t3122 9825.24
R17 VSS.t3131 VSS.t3134 9825.24
R18 VSS.t3140 VSS.t3143 9825.24
R19 VSS.t3149 VSS.t3152 9825.24
R20 VSS.t3158 VSS.t3161 9825.24
R21 VSS.t3167 VSS.t3170 9825.24
R22 VSS.t3176 VSS.t3179 9825.24
R23 VSS.t3185 VSS.t3188 9825.24
R24 VSS.t3194 VSS.t3197 9825.24
R25 VSS.t3203 VSS.t3206 9825.24
R26 VSS.t3212 VSS.t3215 9825.24
R27 VSS.t3224 VSS.t3221 9825.24
R28 VSS.t3230 VSS.t3233 9825.24
R29 VSS.t2682 VSS.t2679 9305.75
R30 VSS.t2467 VSS.t2464 9305.75
R31 VSS.t2252 VSS.t2249 9305.75
R32 VSS.t2037 VSS.t2034 9305.75
R33 VSS.t1822 VSS.t1819 9305.75
R34 VSS.t1389 VSS.t1386 9305.75
R35 VSS.t1174 VSS.t1171 9305.75
R36 VSS.t959 VSS.t956 9305.75
R37 VSS.t744 VSS.t741 9305.75
R38 VSS.t549 VSS.t546 9305.75
R39 VSS.t401 VSS.t398 9305.75
R40 VSS.t414 VSS.t411 9305.75
R41 VSS.n15270 VSS.t3119 8515.21
R42 VSS.n2884 VSS.t3128 8515.21
R43 VSS.n2883 VSS.t3137 8515.21
R44 VSS.n2882 VSS.t3146 8515.21
R45 VSS.n2881 VSS.t3155 8515.21
R46 VSS.n2880 VSS.t3164 8515.21
R47 VSS.n2879 VSS.t3173 8515.21
R48 VSS.n2878 VSS.t3182 8515.21
R49 VSS.n2877 VSS.t3191 8515.21
R50 VSS.n2876 VSS.t3200 8515.21
R51 VSS.n2875 VSS.t3209 8515.21
R52 VSS.t3218 VSS.n3427 8515.21
R53 VSS.n3428 VSS.t3227 8515.21
R54 VSS.t2900 VSS.t3011 7754.79
R55 VSS.t2685 VSS.t2793 7754.79
R56 VSS.t2470 VSS.t2578 7754.79
R57 VSS.t2255 VSS.t2363 7754.79
R58 VSS.t2040 VSS.t2148 7754.79
R59 VSS.t1825 VSS.t1933 7754.79
R60 VSS.t1607 VSS.t1718 7754.79
R61 VSS.t1392 VSS.t1500 7754.79
R62 VSS.t1177 VSS.t1285 7754.79
R63 VSS.t962 VSS.t1070 7754.79
R64 VSS.t747 VSS.t855 7754.79
R65 VSS.t552 VSS.t645 7754.79
R66 VSS.t445 VSS.t520 6979.31
R67 VSS.t3110 VSS.n15269 6559.43
R68 VSS.t3006 VSS.t2894 6203.83
R69 VSS.t3017 VSS.t2909 6203.83
R70 VSS.t2915 VSS.t3026 6203.83
R71 VSS.t3032 VSS.t2924 6203.83
R72 VSS.t2930 VSS.t3041 6203.83
R73 VSS.t3047 VSS.t2939 6203.83
R74 VSS.t2945 VSS.t3056 6203.83
R75 VSS.t3062 VSS.t2954 6203.83
R76 VSS.t2960 VSS.t3071 6203.83
R77 VSS.t3077 VSS.t2969 6203.83
R78 VSS.t2975 VSS.t3086 6203.83
R79 VSS.t3092 VSS.t2984 6203.83
R80 VSS.t3101 VSS.t2990 6203.83
R81 VSS.t2694 VSS.t2799 6203.83
R82 VSS.t2808 VSS.t2700 6203.83
R83 VSS.t2709 VSS.t2814 6203.83
R84 VSS.t2823 VSS.t2715 6203.83
R85 VSS.t2724 VSS.t2829 6203.83
R86 VSS.t2838 VSS.t2730 6203.83
R87 VSS.t2739 VSS.t2844 6203.83
R88 VSS.t2853 VSS.t2745 6203.83
R89 VSS.t2754 VSS.t2859 6203.83
R90 VSS.t2868 VSS.t2760 6203.83
R91 VSS.t2769 VSS.t2874 6203.83
R92 VSS.t2883 VSS.t2775 6203.83
R93 VSS.t2584 VSS.t2479 6203.83
R94 VSS.t2485 VSS.t2593 6203.83
R95 VSS.t2599 VSS.t2494 6203.83
R96 VSS.t2500 VSS.t2608 6203.83
R97 VSS.t2614 VSS.t2509 6203.83
R98 VSS.t2515 VSS.t2623 6203.83
R99 VSS.t2629 VSS.t2524 6203.83
R100 VSS.t2530 VSS.t2638 6203.83
R101 VSS.t2644 VSS.t2539 6203.83
R102 VSS.t2545 VSS.t2653 6203.83
R103 VSS.t2659 VSS.t2554 6203.83
R104 VSS.t2668 VSS.t2560 6203.83
R105 VSS.t2369 VSS.t2264 6203.83
R106 VSS.t2270 VSS.t2378 6203.83
R107 VSS.t2384 VSS.t2279 6203.83
R108 VSS.t2285 VSS.t2393 6203.83
R109 VSS.t2399 VSS.t2294 6203.83
R110 VSS.t2300 VSS.t2408 6203.83
R111 VSS.t2414 VSS.t2309 6203.83
R112 VSS.t2315 VSS.t2423 6203.83
R113 VSS.t2429 VSS.t2324 6203.83
R114 VSS.t2330 VSS.t2438 6203.83
R115 VSS.t2444 VSS.t2339 6203.83
R116 VSS.t2453 VSS.t2345 6203.83
R117 VSS.t2049 VSS.t2154 6203.83
R118 VSS.t2163 VSS.t2055 6203.83
R119 VSS.t2064 VSS.t2169 6203.83
R120 VSS.t2178 VSS.t2070 6203.83
R121 VSS.t2079 VSS.t2184 6203.83
R122 VSS.t2193 VSS.t2085 6203.83
R123 VSS.t2094 VSS.t2199 6203.83
R124 VSS.t2208 VSS.t2100 6203.83
R125 VSS.t2109 VSS.t2214 6203.83
R126 VSS.t2223 VSS.t2115 6203.83
R127 VSS.t2124 VSS.t2229 6203.83
R128 VSS.t2238 VSS.t2130 6203.83
R129 VSS.t1834 VSS.t1939 6203.83
R130 VSS.t1948 VSS.t1840 6203.83
R131 VSS.t1849 VSS.t1954 6203.83
R132 VSS.t1963 VSS.t1855 6203.83
R133 VSS.t1864 VSS.t1969 6203.83
R134 VSS.t1978 VSS.t1870 6203.83
R135 VSS.t1879 VSS.t1984 6203.83
R136 VSS.t1993 VSS.t1885 6203.83
R137 VSS.t1894 VSS.t1999 6203.83
R138 VSS.t2008 VSS.t1900 6203.83
R139 VSS.t1909 VSS.t2014 6203.83
R140 VSS.t2023 VSS.t1915 6203.83
R141 VSS.t1713 VSS.t1601 6203.83
R142 VSS.t1724 VSS.t1616 6203.83
R143 VSS.t1622 VSS.t1733 6203.83
R144 VSS.t1739 VSS.t1631 6203.83
R145 VSS.t1637 VSS.t1748 6203.83
R146 VSS.t1754 VSS.t1646 6203.83
R147 VSS.t1652 VSS.t1763 6203.83
R148 VSS.t1769 VSS.t1661 6203.83
R149 VSS.t1667 VSS.t1778 6203.83
R150 VSS.t1784 VSS.t1676 6203.83
R151 VSS.t1682 VSS.t1793 6203.83
R152 VSS.t1799 VSS.t1691 6203.83
R153 VSS.t1808 VSS.t1697 6203.83
R154 VSS.t1506 VSS.t1401 6203.83
R155 VSS.t1407 VSS.t1515 6203.83
R156 VSS.t1521 VSS.t1416 6203.83
R157 VSS.t1422 VSS.t1530 6203.83
R158 VSS.t1536 VSS.t1431 6203.83
R159 VSS.t1437 VSS.t1545 6203.83
R160 VSS.t1551 VSS.t1446 6203.83
R161 VSS.t1452 VSS.t1560 6203.83
R162 VSS.t1566 VSS.t1461 6203.83
R163 VSS.t1467 VSS.t1575 6203.83
R164 VSS.t1581 VSS.t1476 6203.83
R165 VSS.t1590 VSS.t1482 6203.83
R166 VSS.t1186 VSS.t1291 6203.83
R167 VSS.t1300 VSS.t1192 6203.83
R168 VSS.t1201 VSS.t1306 6203.83
R169 VSS.t1315 VSS.t1207 6203.83
R170 VSS.t1216 VSS.t1321 6203.83
R171 VSS.t1330 VSS.t1222 6203.83
R172 VSS.t1231 VSS.t1336 6203.83
R173 VSS.t1345 VSS.t1237 6203.83
R174 VSS.t1246 VSS.t1351 6203.83
R175 VSS.t1360 VSS.t1252 6203.83
R176 VSS.t1261 VSS.t1366 6203.83
R177 VSS.t1375 VSS.t1267 6203.83
R178 VSS.t971 VSS.t1076 6203.83
R179 VSS.t1085 VSS.t977 6203.83
R180 VSS.t986 VSS.t1091 6203.83
R181 VSS.t1100 VSS.t992 6203.83
R182 VSS.t1001 VSS.t1106 6203.83
R183 VSS.t1115 VSS.t1007 6203.83
R184 VSS.t1016 VSS.t1121 6203.83
R185 VSS.t1130 VSS.t1022 6203.83
R186 VSS.t1031 VSS.t1136 6203.83
R187 VSS.t1145 VSS.t1037 6203.83
R188 VSS.t1046 VSS.t1151 6203.83
R189 VSS.t1160 VSS.t1052 6203.83
R190 VSS.t861 VSS.t756 6203.83
R191 VSS.t762 VSS.t870 6203.83
R192 VSS.t876 VSS.t771 6203.83
R193 VSS.t777 VSS.t885 6203.83
R194 VSS.t891 VSS.t786 6203.83
R195 VSS.t792 VSS.t900 6203.83
R196 VSS.t906 VSS.t801 6203.83
R197 VSS.t807 VSS.t915 6203.83
R198 VSS.t921 VSS.t816 6203.83
R199 VSS.t822 VSS.t930 6203.83
R200 VSS.t936 VSS.t831 6203.83
R201 VSS.t945 VSS.t837 6203.83
R202 VSS.t651 VSS.t561 6203.83
R203 VSS.t567 VSS.t660 6203.83
R204 VSS.t666 VSS.t576 6203.83
R205 VSS.t582 VSS.t675 6203.83
R206 VSS.t612 VSS.t715 6203.83
R207 VSS.t721 VSS.t621 6203.83
R208 VSS.t730 VSS.t627 6203.83
R209 VSS.t451 VSS.t526 6203.83
R210 VSS.t535 VSS.t457 6203.83
R211 VSS.t2679 VSS.t2677 5816.09
R212 VSS.n5798 VSS.t2682 5816.09
R213 VSS.t2464 VSS.t2462 5816.09
R214 VSS.n4764 VSS.t2467 5816.09
R215 VSS.t2249 VSS.t2247 5816.09
R216 VSS.n6845 VSS.t2252 5816.09
R217 VSS.t2034 VSS.t2032 5816.09
R218 VSS.n8280 VSS.t2037 5816.09
R219 VSS.t1819 VSS.t1817 5816.09
R220 VSS.n9318 VSS.t1822 5816.09
R221 VSS.t1386 VSS.t1384 5816.09
R222 VSS.n10365 VSS.t1389 5816.09
R223 VSS.t1171 VSS.t1169 5816.09
R224 VSS.n11800 VSS.t1174 5816.09
R225 VSS.t956 VSS.t954 5816.09
R226 VSS.n12838 VSS.t959 5816.09
R227 VSS.t741 VSS.t739 5816.09
R228 VSS.n1570 VSS.t744 5816.09
R229 VSS.t546 VSS.t544 5816.09
R230 VSS.n13852 VSS.t549 5816.09
R231 VSS.t398 VSS.t396 5816.09
R232 VSS.n15222 VSS.t401 5816.09
R233 VSS.t498 VSS.t414 5816.09
R234 VSS.t609 VSS.n13645 5040.61
R235 VSS.n15039 VSS.t411 5040.61
R236 VSS.t442 VSS.n14564 5040.61
R237 VSS.n14565 VSS.t523 5040.61
R238 VSS.t2903 VSS.t3014 4652.87
R239 VSS.t2688 VSS.t2796 4652.87
R240 VSS.t2473 VSS.t2581 4652.87
R241 VSS.t2258 VSS.t2366 4652.87
R242 VSS.t2043 VSS.t2151 4652.87
R243 VSS.t1828 VSS.t1936 4652.87
R244 VSS.t1610 VSS.t1721 4652.87
R245 VSS.t1395 VSS.t1503 4652.87
R246 VSS.t1180 VSS.t1288 4652.87
R247 VSS.t965 VSS.t1073 4652.87
R248 VSS.t750 VSS.t858 4652.87
R249 VSS.t555 VSS.t648 4652.87
R250 VSS.n15257 VSS.t274 4506.95
R251 VSS.n15269 VSS.n15268 4490.81
R252 VSS.n15268 VSS.n15267 4490.81
R253 VSS.n15267 VSS.n15266 4490.81
R254 VSS.n15266 VSS.n15265 4490.81
R255 VSS.n15265 VSS.n15264 4490.81
R256 VSS.n15264 VSS.n15263 4490.81
R257 VSS.n15263 VSS.n15262 4490.81
R258 VSS.n15262 VSS.n15261 4490.81
R259 VSS.n15261 VSS.n15260 4490.81
R260 VSS.n15260 VSS.n15259 4490.81
R261 VSS.n15259 VSS.n15258 4490.81
R262 VSS.n15258 VSS.n15257 4490.81
R263 VSS.n3741 VSS.t2897 4265.13
R264 VSS.n2211 VSS.t1604 4265.13
R265 VSS.t408 VSS.n15039 4265.13
R266 VSS.t206 VSS.t423 4239.85
R267 VSS.t437 VSS.t3293 4239.85
R268 VSS.t606 VSS.t90 3911.11
R269 VSS.t3305 VSS.t408 3902.68
R270 VSS.t3020 VSS.t2912 3877.39
R271 VSS.t2918 VSS.t3029 3877.39
R272 VSS.t3035 VSS.t2927 3877.39
R273 VSS.t2933 VSS.t3044 3877.39
R274 VSS.t3050 VSS.t2942 3877.39
R275 VSS.t2948 VSS.t3059 3877.39
R276 VSS.t3065 VSS.t2957 3877.39
R277 VSS.t2963 VSS.t3074 3877.39
R278 VSS.t3080 VSS.t2972 3877.39
R279 VSS.t2978 VSS.t3089 3877.39
R280 VSS.t3095 VSS.t2987 3877.39
R281 VSS.t3104 VSS.t2993 3877.39
R282 VSS.t2697 VSS.t2802 3877.39
R283 VSS.t2811 VSS.t2703 3877.39
R284 VSS.t2712 VSS.t2817 3877.39
R285 VSS.t2826 VSS.t2718 3877.39
R286 VSS.t2727 VSS.t2832 3877.39
R287 VSS.t2841 VSS.t2733 3877.39
R288 VSS.t2742 VSS.t2847 3877.39
R289 VSS.t2856 VSS.t2748 3877.39
R290 VSS.t2757 VSS.t2862 3877.39
R291 VSS.t2871 VSS.t2763 3877.39
R292 VSS.t2772 VSS.t2877 3877.39
R293 VSS.t2886 VSS.t2778 3877.39
R294 VSS.t2587 VSS.t2482 3877.39
R295 VSS.t2488 VSS.t2596 3877.39
R296 VSS.t2602 VSS.t2497 3877.39
R297 VSS.t2503 VSS.t2611 3877.39
R298 VSS.t2617 VSS.t2512 3877.39
R299 VSS.t2518 VSS.t2626 3877.39
R300 VSS.t2632 VSS.t2527 3877.39
R301 VSS.t2533 VSS.t2641 3877.39
R302 VSS.t2647 VSS.t2542 3877.39
R303 VSS.t2548 VSS.t2656 3877.39
R304 VSS.t2662 VSS.t2557 3877.39
R305 VSS.t2671 VSS.t2563 3877.39
R306 VSS.t2372 VSS.t2267 3877.39
R307 VSS.t2273 VSS.t2381 3877.39
R308 VSS.t2387 VSS.t2282 3877.39
R309 VSS.t2288 VSS.t2396 3877.39
R310 VSS.t2402 VSS.t2297 3877.39
R311 VSS.t2303 VSS.t2411 3877.39
R312 VSS.t2417 VSS.t2312 3877.39
R313 VSS.t2318 VSS.t2426 3877.39
R314 VSS.t2432 VSS.t2327 3877.39
R315 VSS.t2333 VSS.t2441 3877.39
R316 VSS.t2447 VSS.t2342 3877.39
R317 VSS.t2456 VSS.t2348 3877.39
R318 VSS.t2052 VSS.t2157 3877.39
R319 VSS.t2166 VSS.t2058 3877.39
R320 VSS.t2067 VSS.t2172 3877.39
R321 VSS.t2181 VSS.t2073 3877.39
R322 VSS.t2082 VSS.t2187 3877.39
R323 VSS.t2196 VSS.t2088 3877.39
R324 VSS.t2097 VSS.t2202 3877.39
R325 VSS.t2211 VSS.t2103 3877.39
R326 VSS.t2112 VSS.t2217 3877.39
R327 VSS.t2226 VSS.t2118 3877.39
R328 VSS.t2127 VSS.t2232 3877.39
R329 VSS.t2241 VSS.t2133 3877.39
R330 VSS.t1837 VSS.t1942 3877.39
R331 VSS.t1951 VSS.t1843 3877.39
R332 VSS.t1852 VSS.t1957 3877.39
R333 VSS.t1966 VSS.t1858 3877.39
R334 VSS.t1867 VSS.t1972 3877.39
R335 VSS.t1981 VSS.t1873 3877.39
R336 VSS.t1882 VSS.t1987 3877.39
R337 VSS.t1996 VSS.t1888 3877.39
R338 VSS.t1897 VSS.t2002 3877.39
R339 VSS.t2011 VSS.t1903 3877.39
R340 VSS.t1912 VSS.t2017 3877.39
R341 VSS.t2026 VSS.t1918 3877.39
R342 VSS.t1727 VSS.t1619 3877.39
R343 VSS.t1625 VSS.t1736 3877.39
R344 VSS.t1742 VSS.t1634 3877.39
R345 VSS.t1640 VSS.t1751 3877.39
R346 VSS.t1757 VSS.t1649 3877.39
R347 VSS.t1655 VSS.t1766 3877.39
R348 VSS.t1772 VSS.t1664 3877.39
R349 VSS.t1670 VSS.t1781 3877.39
R350 VSS.t1787 VSS.t1679 3877.39
R351 VSS.t1685 VSS.t1796 3877.39
R352 VSS.t1802 VSS.t1694 3877.39
R353 VSS.t1811 VSS.t1700 3877.39
R354 VSS.t1509 VSS.t1404 3877.39
R355 VSS.t1410 VSS.t1518 3877.39
R356 VSS.t1524 VSS.t1419 3877.39
R357 VSS.t1425 VSS.t1533 3877.39
R358 VSS.t1539 VSS.t1434 3877.39
R359 VSS.t1440 VSS.t1548 3877.39
R360 VSS.t1554 VSS.t1449 3877.39
R361 VSS.t1455 VSS.t1563 3877.39
R362 VSS.t1569 VSS.t1464 3877.39
R363 VSS.t1470 VSS.t1578 3877.39
R364 VSS.t1584 VSS.t1479 3877.39
R365 VSS.t1593 VSS.t1485 3877.39
R366 VSS.t1189 VSS.t1294 3877.39
R367 VSS.t1303 VSS.t1195 3877.39
R368 VSS.t1204 VSS.t1309 3877.39
R369 VSS.t1318 VSS.t1210 3877.39
R370 VSS.t1219 VSS.t1324 3877.39
R371 VSS.t1333 VSS.t1225 3877.39
R372 VSS.t1234 VSS.t1339 3877.39
R373 VSS.t1348 VSS.t1240 3877.39
R374 VSS.t1249 VSS.t1354 3877.39
R375 VSS.t1363 VSS.t1255 3877.39
R376 VSS.t1264 VSS.t1369 3877.39
R377 VSS.t1378 VSS.t1270 3877.39
R378 VSS.t974 VSS.t1079 3877.39
R379 VSS.t1088 VSS.t980 3877.39
R380 VSS.t989 VSS.t1094 3877.39
R381 VSS.t1103 VSS.t995 3877.39
R382 VSS.t1004 VSS.t1109 3877.39
R383 VSS.t1118 VSS.t1010 3877.39
R384 VSS.t1019 VSS.t1124 3877.39
R385 VSS.t1133 VSS.t1025 3877.39
R386 VSS.t1034 VSS.t1139 3877.39
R387 VSS.t1148 VSS.t1040 3877.39
R388 VSS.t1049 VSS.t1154 3877.39
R389 VSS.t1163 VSS.t1055 3877.39
R390 VSS.t864 VSS.t759 3877.39
R391 VSS.t765 VSS.t873 3877.39
R392 VSS.t879 VSS.t774 3877.39
R393 VSS.t780 VSS.t888 3877.39
R394 VSS.t894 VSS.t789 3877.39
R395 VSS.t795 VSS.t903 3877.39
R396 VSS.t909 VSS.t804 3877.39
R397 VSS.t810 VSS.t918 3877.39
R398 VSS.t924 VSS.t819 3877.39
R399 VSS.t825 VSS.t933 3877.39
R400 VSS.t939 VSS.t834 3877.39
R401 VSS.t948 VSS.t840 3877.39
R402 VSS.t654 VSS.t564 3877.39
R403 VSS.t570 VSS.t663 3877.39
R404 VSS.t669 VSS.t579 3877.39
R405 VSS.t585 VSS.t678 3877.39
R406 VSS.t591 VSS.t681 3877.39
R407 VSS.t700 VSS.t603 3877.39
R408 VSS.t703 VSS.t606 3877.39
R409 VSS.t615 VSS.t718 3877.39
R410 VSS.t724 VSS.t624 3877.39
R411 VSS.t733 VSS.t630 3877.39
R412 VSS.t454 VSS.t529 3877.39
R413 VSS.t538 VSS.t460 3877.39
R414 VSS.n3741 VSS.t3008 3489.66
R415 VSS.t2912 VSS.n3701 3489.66
R416 VSS.t3029 VSS.n3676 3489.66
R417 VSS.t2927 VSS.n3651 3489.66
R418 VSS.t3044 VSS.n3626 3489.66
R419 VSS.t2942 VSS.n3601 3489.66
R420 VSS.t3059 VSS.n3576 3489.66
R421 VSS.t2957 VSS.n3551 3489.66
R422 VSS.t3074 VSS.n3526 3489.66
R423 VSS.t2972 VSS.n3501 3489.66
R424 VSS.t3089 VSS.n3476 3489.66
R425 VSS.n4397 VSS.t2987 3489.66
R426 VSS.t2996 VSS.t3104 3489.66
R427 VSS.n5798 VSS.t2790 3489.66
R428 VSS.n5119 VSS.t2697 3489.66
R429 VSS.n5120 VSS.t2811 3489.66
R430 VSS.n5121 VSS.t2712 3489.66
R431 VSS.n5122 VSS.t2826 3489.66
R432 VSS.n5123 VSS.t2727 3489.66
R433 VSS.n5124 VSS.t2841 3489.66
R434 VSS.n5125 VSS.t2742 3489.66
R435 VSS.n5126 VSS.t2856 3489.66
R436 VSS.n5127 VSS.t2757 3489.66
R437 VSS.n5128 VSS.t2871 3489.66
R438 VSS.n5129 VSS.t2772 3489.66
R439 VSS.t2781 VSS.t2886 3489.66
R440 VSS.n4764 VSS.t2575 3489.66
R441 VSS.t2482 VSS.n4724 3489.66
R442 VSS.t2596 VSS.n4699 3489.66
R443 VSS.t2497 VSS.n4674 3489.66
R444 VSS.t2611 VSS.n4649 3489.66
R445 VSS.t2512 VSS.n4624 3489.66
R446 VSS.t2626 VSS.n4599 3489.66
R447 VSS.t2527 VSS.n4574 3489.66
R448 VSS.t2641 VSS.n4549 3489.66
R449 VSS.t2542 VSS.n4524 3489.66
R450 VSS.t2656 VSS.n4499 3489.66
R451 VSS.n6478 VSS.t2557 3489.66
R452 VSS.t2566 VSS.t2671 3489.66
R453 VSS.n6845 VSS.t2360 3489.66
R454 VSS.t2267 VSS.n6805 3489.66
R455 VSS.t2381 VSS.n6780 3489.66
R456 VSS.t2282 VSS.n6755 3489.66
R457 VSS.t2396 VSS.n6730 3489.66
R458 VSS.t2297 VSS.n6705 3489.66
R459 VSS.t2411 VSS.n6680 3489.66
R460 VSS.t2312 VSS.n6655 3489.66
R461 VSS.t2426 VSS.n6630 3489.66
R462 VSS.t2327 VSS.n6605 3489.66
R463 VSS.t2441 VSS.n6580 3489.66
R464 VSS.n7520 VSS.t2342 3489.66
R465 VSS.t2351 VSS.t2456 3489.66
R466 VSS.n8280 VSS.t2145 3489.66
R467 VSS.n7596 VSS.t2052 3489.66
R468 VSS.n7597 VSS.t2166 3489.66
R469 VSS.n7598 VSS.t2067 3489.66
R470 VSS.n7599 VSS.t2181 3489.66
R471 VSS.n7600 VSS.t2082 3489.66
R472 VSS.n7601 VSS.t2196 3489.66
R473 VSS.n7602 VSS.t2097 3489.66
R474 VSS.n7603 VSS.t2211 3489.66
R475 VSS.n7604 VSS.t2112 3489.66
R476 VSS.n7605 VSS.t2226 3489.66
R477 VSS.n7606 VSS.t2127 3489.66
R478 VSS.t2136 VSS.t2241 3489.66
R479 VSS.n9318 VSS.t1930 3489.66
R480 VSS.n8639 VSS.t1837 3489.66
R481 VSS.n8640 VSS.t1951 3489.66
R482 VSS.n8641 VSS.t1852 3489.66
R483 VSS.n8642 VSS.t1966 3489.66
R484 VSS.n8643 VSS.t1867 3489.66
R485 VSS.n8644 VSS.t1981 3489.66
R486 VSS.n8645 VSS.t1882 3489.66
R487 VSS.n8646 VSS.t1996 3489.66
R488 VSS.n8647 VSS.t1897 3489.66
R489 VSS.n8648 VSS.t2011 3489.66
R490 VSS.n8649 VSS.t1912 3489.66
R491 VSS.t1921 VSS.t2026 3489.66
R492 VSS.n2211 VSS.t1715 3489.66
R493 VSS.t1619 VSS.n2171 3489.66
R494 VSS.t1736 VSS.n2146 3489.66
R495 VSS.t1634 VSS.n2121 3489.66
R496 VSS.t1751 VSS.n2096 3489.66
R497 VSS.t1649 VSS.n2071 3489.66
R498 VSS.t1766 VSS.n2046 3489.66
R499 VSS.t1664 VSS.n2021 3489.66
R500 VSS.t1781 VSS.n1996 3489.66
R501 VSS.t1679 VSS.n1971 3489.66
R502 VSS.t1796 VSS.n1946 3489.66
R503 VSS.n9998 VSS.t1694 3489.66
R504 VSS.t1703 VSS.t1811 3489.66
R505 VSS.n10365 VSS.t1497 3489.66
R506 VSS.t1404 VSS.n10325 3489.66
R507 VSS.t1518 VSS.n10300 3489.66
R508 VSS.t1419 VSS.n10275 3489.66
R509 VSS.t1533 VSS.n10250 3489.66
R510 VSS.t1434 VSS.n10225 3489.66
R511 VSS.t1548 VSS.n10200 3489.66
R512 VSS.t1449 VSS.n10175 3489.66
R513 VSS.t1563 VSS.n10150 3489.66
R514 VSS.t1464 VSS.n10125 3489.66
R515 VSS.t1578 VSS.n10100 3489.66
R516 VSS.n11040 VSS.t1479 3489.66
R517 VSS.t1488 VSS.t1593 3489.66
R518 VSS.n11800 VSS.t1282 3489.66
R519 VSS.n11116 VSS.t1189 3489.66
R520 VSS.n11117 VSS.t1303 3489.66
R521 VSS.n11118 VSS.t1204 3489.66
R522 VSS.n11119 VSS.t1318 3489.66
R523 VSS.n11120 VSS.t1219 3489.66
R524 VSS.n11121 VSS.t1333 3489.66
R525 VSS.n11122 VSS.t1234 3489.66
R526 VSS.n11123 VSS.t1348 3489.66
R527 VSS.n11124 VSS.t1249 3489.66
R528 VSS.n11125 VSS.t1363 3489.66
R529 VSS.n11126 VSS.t1264 3489.66
R530 VSS.t1273 VSS.t1378 3489.66
R531 VSS.n12838 VSS.t1067 3489.66
R532 VSS.n12159 VSS.t974 3489.66
R533 VSS.n12160 VSS.t1088 3489.66
R534 VSS.n12161 VSS.t989 3489.66
R535 VSS.n12162 VSS.t1103 3489.66
R536 VSS.n12163 VSS.t1004 3489.66
R537 VSS.n12164 VSS.t1118 3489.66
R538 VSS.n12165 VSS.t1019 3489.66
R539 VSS.n12166 VSS.t1133 3489.66
R540 VSS.n12167 VSS.t1034 3489.66
R541 VSS.n12168 VSS.t1148 3489.66
R542 VSS.n12169 VSS.t1049 3489.66
R543 VSS.t1058 VSS.t1163 3489.66
R544 VSS.n1570 VSS.t852 3489.66
R545 VSS.t759 VSS.n1530 3489.66
R546 VSS.t873 VSS.n1505 3489.66
R547 VSS.t774 VSS.n1480 3489.66
R548 VSS.t888 VSS.n1455 3489.66
R549 VSS.t789 VSS.n1430 3489.66
R550 VSS.t903 VSS.n1405 3489.66
R551 VSS.t804 VSS.n1380 3489.66
R552 VSS.t918 VSS.n1355 3489.66
R553 VSS.t819 VSS.n1330 3489.66
R554 VSS.t933 VSS.n1305 3489.66
R555 VSS.n13518 VSS.t834 3489.66
R556 VSS.t843 VSS.t948 3489.66
R557 VSS.n13852 VSS.t642 3489.66
R558 VSS.t564 VSS.n13812 3489.66
R559 VSS.t663 VSS.n13787 3489.66
R560 VSS.t579 VSS.n13762 3489.66
R561 VSS.n14215 VSS.t678 3489.66
R562 VSS.t603 VSS.n14313 3489.66
R563 VSS.t718 VSS.n13620 3489.66
R564 VSS.n14483 VSS.t624 3489.66
R565 VSS.t633 VSS.t733 3489.66
R566 VSS.t434 VSS.n14562 3489.66
R567 VSS.n14566 VSS.t454 3489.66
R568 VSS.t463 VSS.t538 3489.66
R569 VSS.t3341 VSS.t591 3287.36
R570 VSS.t255 VSS.t3354 3203.07
R571 VSS.t594 VSS.t3393 3186.21
R572 VSS.t3330 VSS.t709 3186.21
R573 VSS.t8 VSS.t264 3135.63
R574 VSS.t432 VSS.t248 3135.63
R575 VSS.t2894 VSS.t3003 3101.92
R576 VSS.t2906 VSS.t3017 3101.92
R577 VSS.t2909 VSS.t3020 3101.92
R578 VSS.t3023 VSS.t2915 3101.92
R579 VSS.t3026 VSS.t2918 3101.92
R580 VSS.t2921 VSS.t3032 3101.92
R581 VSS.t2924 VSS.t3035 3101.92
R582 VSS.t3038 VSS.t2930 3101.92
R583 VSS.t3041 VSS.t2933 3101.92
R584 VSS.t2936 VSS.t3047 3101.92
R585 VSS.t2939 VSS.t3050 3101.92
R586 VSS.t3053 VSS.t2945 3101.92
R587 VSS.t3056 VSS.t2948 3101.92
R588 VSS.t2951 VSS.t3062 3101.92
R589 VSS.t2954 VSS.t3065 3101.92
R590 VSS.t3068 VSS.t2960 3101.92
R591 VSS.t3071 VSS.t2963 3101.92
R592 VSS.t2966 VSS.t3077 3101.92
R593 VSS.t2969 VSS.t3080 3101.92
R594 VSS.t3083 VSS.t2975 3101.92
R595 VSS.t3086 VSS.t2978 3101.92
R596 VSS.t2981 VSS.t3092 3101.92
R597 VSS.t2984 VSS.t3095 3101.92
R598 VSS.t2990 VSS.t3098 3101.92
R599 VSS.t2993 VSS.t3101 3101.92
R600 VSS.t2799 VSS.t2691 3101.92
R601 VSS.t2802 VSS.t2694 3101.92
R602 VSS.t2700 VSS.t2805 3101.92
R603 VSS.t2703 VSS.t2808 3101.92
R604 VSS.t2814 VSS.t2706 3101.92
R605 VSS.t2817 VSS.t2709 3101.92
R606 VSS.t2715 VSS.t2820 3101.92
R607 VSS.t2718 VSS.t2823 3101.92
R608 VSS.t2829 VSS.t2721 3101.92
R609 VSS.t2832 VSS.t2724 3101.92
R610 VSS.t2730 VSS.t2835 3101.92
R611 VSS.t2733 VSS.t2838 3101.92
R612 VSS.t2844 VSS.t2736 3101.92
R613 VSS.t2847 VSS.t2739 3101.92
R614 VSS.t2745 VSS.t2850 3101.92
R615 VSS.t2748 VSS.t2853 3101.92
R616 VSS.t2859 VSS.t2751 3101.92
R617 VSS.t2862 VSS.t2754 3101.92
R618 VSS.t2760 VSS.t2865 3101.92
R619 VSS.t2763 VSS.t2868 3101.92
R620 VSS.t2874 VSS.t2766 3101.92
R621 VSS.t2877 VSS.t2769 3101.92
R622 VSS.t2775 VSS.t2880 3101.92
R623 VSS.t2778 VSS.t2883 3101.92
R624 VSS.t2476 VSS.t2584 3101.92
R625 VSS.t2479 VSS.t2587 3101.92
R626 VSS.t2590 VSS.t2485 3101.92
R627 VSS.t2593 VSS.t2488 3101.92
R628 VSS.t2491 VSS.t2599 3101.92
R629 VSS.t2494 VSS.t2602 3101.92
R630 VSS.t2605 VSS.t2500 3101.92
R631 VSS.t2608 VSS.t2503 3101.92
R632 VSS.t2506 VSS.t2614 3101.92
R633 VSS.t2509 VSS.t2617 3101.92
R634 VSS.t2620 VSS.t2515 3101.92
R635 VSS.t2623 VSS.t2518 3101.92
R636 VSS.t2521 VSS.t2629 3101.92
R637 VSS.t2524 VSS.t2632 3101.92
R638 VSS.t2635 VSS.t2530 3101.92
R639 VSS.t2638 VSS.t2533 3101.92
R640 VSS.t2536 VSS.t2644 3101.92
R641 VSS.t2539 VSS.t2647 3101.92
R642 VSS.t2650 VSS.t2545 3101.92
R643 VSS.t2653 VSS.t2548 3101.92
R644 VSS.t2551 VSS.t2659 3101.92
R645 VSS.t2554 VSS.t2662 3101.92
R646 VSS.t2560 VSS.t2665 3101.92
R647 VSS.t2563 VSS.t2668 3101.92
R648 VSS.t2261 VSS.t2369 3101.92
R649 VSS.t2264 VSS.t2372 3101.92
R650 VSS.t2375 VSS.t2270 3101.92
R651 VSS.t2378 VSS.t2273 3101.92
R652 VSS.t2276 VSS.t2384 3101.92
R653 VSS.t2279 VSS.t2387 3101.92
R654 VSS.t2390 VSS.t2285 3101.92
R655 VSS.t2393 VSS.t2288 3101.92
R656 VSS.t2291 VSS.t2399 3101.92
R657 VSS.t2294 VSS.t2402 3101.92
R658 VSS.t2405 VSS.t2300 3101.92
R659 VSS.t2408 VSS.t2303 3101.92
R660 VSS.t2306 VSS.t2414 3101.92
R661 VSS.t2309 VSS.t2417 3101.92
R662 VSS.t2420 VSS.t2315 3101.92
R663 VSS.t2423 VSS.t2318 3101.92
R664 VSS.t2321 VSS.t2429 3101.92
R665 VSS.t2324 VSS.t2432 3101.92
R666 VSS.t2435 VSS.t2330 3101.92
R667 VSS.t2438 VSS.t2333 3101.92
R668 VSS.t2336 VSS.t2444 3101.92
R669 VSS.t2339 VSS.t2447 3101.92
R670 VSS.t2345 VSS.t2450 3101.92
R671 VSS.t2348 VSS.t2453 3101.92
R672 VSS.t2154 VSS.t2046 3101.92
R673 VSS.t2157 VSS.t2049 3101.92
R674 VSS.t2055 VSS.t2160 3101.92
R675 VSS.t2058 VSS.t2163 3101.92
R676 VSS.t2169 VSS.t2061 3101.92
R677 VSS.t2172 VSS.t2064 3101.92
R678 VSS.t2070 VSS.t2175 3101.92
R679 VSS.t2073 VSS.t2178 3101.92
R680 VSS.t2184 VSS.t2076 3101.92
R681 VSS.t2187 VSS.t2079 3101.92
R682 VSS.t2085 VSS.t2190 3101.92
R683 VSS.t2088 VSS.t2193 3101.92
R684 VSS.t2199 VSS.t2091 3101.92
R685 VSS.t2202 VSS.t2094 3101.92
R686 VSS.t2100 VSS.t2205 3101.92
R687 VSS.t2103 VSS.t2208 3101.92
R688 VSS.t2214 VSS.t2106 3101.92
R689 VSS.t2217 VSS.t2109 3101.92
R690 VSS.t2115 VSS.t2220 3101.92
R691 VSS.t2118 VSS.t2223 3101.92
R692 VSS.t2229 VSS.t2121 3101.92
R693 VSS.t2232 VSS.t2124 3101.92
R694 VSS.t2130 VSS.t2235 3101.92
R695 VSS.t2133 VSS.t2238 3101.92
R696 VSS.t1939 VSS.t1831 3101.92
R697 VSS.t1942 VSS.t1834 3101.92
R698 VSS.t1840 VSS.t1945 3101.92
R699 VSS.t1843 VSS.t1948 3101.92
R700 VSS.t1954 VSS.t1846 3101.92
R701 VSS.t1957 VSS.t1849 3101.92
R702 VSS.t1855 VSS.t1960 3101.92
R703 VSS.t1858 VSS.t1963 3101.92
R704 VSS.t1969 VSS.t1861 3101.92
R705 VSS.t1972 VSS.t1864 3101.92
R706 VSS.t1870 VSS.t1975 3101.92
R707 VSS.t1873 VSS.t1978 3101.92
R708 VSS.t1984 VSS.t1876 3101.92
R709 VSS.t1987 VSS.t1879 3101.92
R710 VSS.t1885 VSS.t1990 3101.92
R711 VSS.t1888 VSS.t1993 3101.92
R712 VSS.t1999 VSS.t1891 3101.92
R713 VSS.t2002 VSS.t1894 3101.92
R714 VSS.t1900 VSS.t2005 3101.92
R715 VSS.t1903 VSS.t2008 3101.92
R716 VSS.t2014 VSS.t1906 3101.92
R717 VSS.t2017 VSS.t1909 3101.92
R718 VSS.t1915 VSS.t2020 3101.92
R719 VSS.t1918 VSS.t2023 3101.92
R720 VSS.t1601 VSS.t1710 3101.92
R721 VSS.t1613 VSS.t1724 3101.92
R722 VSS.t1616 VSS.t1727 3101.92
R723 VSS.t1730 VSS.t1622 3101.92
R724 VSS.t1733 VSS.t1625 3101.92
R725 VSS.t1628 VSS.t1739 3101.92
R726 VSS.t1631 VSS.t1742 3101.92
R727 VSS.t1745 VSS.t1637 3101.92
R728 VSS.t1748 VSS.t1640 3101.92
R729 VSS.t1643 VSS.t1754 3101.92
R730 VSS.t1646 VSS.t1757 3101.92
R731 VSS.t1760 VSS.t1652 3101.92
R732 VSS.t1763 VSS.t1655 3101.92
R733 VSS.t1658 VSS.t1769 3101.92
R734 VSS.t1661 VSS.t1772 3101.92
R735 VSS.t1775 VSS.t1667 3101.92
R736 VSS.t1778 VSS.t1670 3101.92
R737 VSS.t1673 VSS.t1784 3101.92
R738 VSS.t1676 VSS.t1787 3101.92
R739 VSS.t1790 VSS.t1682 3101.92
R740 VSS.t1793 VSS.t1685 3101.92
R741 VSS.t1688 VSS.t1799 3101.92
R742 VSS.t1691 VSS.t1802 3101.92
R743 VSS.t1697 VSS.t1805 3101.92
R744 VSS.t1700 VSS.t1808 3101.92
R745 VSS.t1398 VSS.t1506 3101.92
R746 VSS.t1401 VSS.t1509 3101.92
R747 VSS.t1512 VSS.t1407 3101.92
R748 VSS.t1515 VSS.t1410 3101.92
R749 VSS.t1413 VSS.t1521 3101.92
R750 VSS.t1416 VSS.t1524 3101.92
R751 VSS.t1527 VSS.t1422 3101.92
R752 VSS.t1530 VSS.t1425 3101.92
R753 VSS.t1428 VSS.t1536 3101.92
R754 VSS.t1431 VSS.t1539 3101.92
R755 VSS.t1542 VSS.t1437 3101.92
R756 VSS.t1545 VSS.t1440 3101.92
R757 VSS.t1443 VSS.t1551 3101.92
R758 VSS.t1446 VSS.t1554 3101.92
R759 VSS.t1557 VSS.t1452 3101.92
R760 VSS.t1560 VSS.t1455 3101.92
R761 VSS.t1458 VSS.t1566 3101.92
R762 VSS.t1461 VSS.t1569 3101.92
R763 VSS.t1572 VSS.t1467 3101.92
R764 VSS.t1575 VSS.t1470 3101.92
R765 VSS.t1473 VSS.t1581 3101.92
R766 VSS.t1476 VSS.t1584 3101.92
R767 VSS.t1482 VSS.t1587 3101.92
R768 VSS.t1485 VSS.t1590 3101.92
R769 VSS.t1291 VSS.t1183 3101.92
R770 VSS.t1294 VSS.t1186 3101.92
R771 VSS.t1192 VSS.t1297 3101.92
R772 VSS.t1195 VSS.t1300 3101.92
R773 VSS.t1306 VSS.t1198 3101.92
R774 VSS.t1309 VSS.t1201 3101.92
R775 VSS.t1207 VSS.t1312 3101.92
R776 VSS.t1210 VSS.t1315 3101.92
R777 VSS.t1321 VSS.t1213 3101.92
R778 VSS.t1324 VSS.t1216 3101.92
R779 VSS.t1222 VSS.t1327 3101.92
R780 VSS.t1225 VSS.t1330 3101.92
R781 VSS.t1336 VSS.t1228 3101.92
R782 VSS.t1339 VSS.t1231 3101.92
R783 VSS.t1237 VSS.t1342 3101.92
R784 VSS.t1240 VSS.t1345 3101.92
R785 VSS.t1351 VSS.t1243 3101.92
R786 VSS.t1354 VSS.t1246 3101.92
R787 VSS.t1252 VSS.t1357 3101.92
R788 VSS.t1255 VSS.t1360 3101.92
R789 VSS.t1366 VSS.t1258 3101.92
R790 VSS.t1369 VSS.t1261 3101.92
R791 VSS.t1267 VSS.t1372 3101.92
R792 VSS.t1270 VSS.t1375 3101.92
R793 VSS.t1076 VSS.t968 3101.92
R794 VSS.t1079 VSS.t971 3101.92
R795 VSS.t977 VSS.t1082 3101.92
R796 VSS.t980 VSS.t1085 3101.92
R797 VSS.t1091 VSS.t983 3101.92
R798 VSS.t1094 VSS.t986 3101.92
R799 VSS.t992 VSS.t1097 3101.92
R800 VSS.t995 VSS.t1100 3101.92
R801 VSS.t1106 VSS.t998 3101.92
R802 VSS.t1109 VSS.t1001 3101.92
R803 VSS.t1007 VSS.t1112 3101.92
R804 VSS.t1010 VSS.t1115 3101.92
R805 VSS.t1121 VSS.t1013 3101.92
R806 VSS.t1124 VSS.t1016 3101.92
R807 VSS.t1022 VSS.t1127 3101.92
R808 VSS.t1025 VSS.t1130 3101.92
R809 VSS.t1136 VSS.t1028 3101.92
R810 VSS.t1139 VSS.t1031 3101.92
R811 VSS.t1037 VSS.t1142 3101.92
R812 VSS.t1040 VSS.t1145 3101.92
R813 VSS.t1151 VSS.t1043 3101.92
R814 VSS.t1154 VSS.t1046 3101.92
R815 VSS.t1052 VSS.t1157 3101.92
R816 VSS.t1055 VSS.t1160 3101.92
R817 VSS.t753 VSS.t861 3101.92
R818 VSS.t756 VSS.t864 3101.92
R819 VSS.t867 VSS.t762 3101.92
R820 VSS.t870 VSS.t765 3101.92
R821 VSS.t768 VSS.t876 3101.92
R822 VSS.t771 VSS.t879 3101.92
R823 VSS.t882 VSS.t777 3101.92
R824 VSS.t885 VSS.t780 3101.92
R825 VSS.t783 VSS.t891 3101.92
R826 VSS.t786 VSS.t894 3101.92
R827 VSS.t897 VSS.t792 3101.92
R828 VSS.t900 VSS.t795 3101.92
R829 VSS.t798 VSS.t906 3101.92
R830 VSS.t801 VSS.t909 3101.92
R831 VSS.t912 VSS.t807 3101.92
R832 VSS.t915 VSS.t810 3101.92
R833 VSS.t813 VSS.t921 3101.92
R834 VSS.t816 VSS.t924 3101.92
R835 VSS.t927 VSS.t822 3101.92
R836 VSS.t930 VSS.t825 3101.92
R837 VSS.t828 VSS.t936 3101.92
R838 VSS.t831 VSS.t939 3101.92
R839 VSS.t837 VSS.t942 3101.92
R840 VSS.t840 VSS.t945 3101.92
R841 VSS.t558 VSS.t651 3101.92
R842 VSS.t561 VSS.t654 3101.92
R843 VSS.t657 VSS.t567 3101.92
R844 VSS.t660 VSS.t570 3101.92
R845 VSS.t573 VSS.t666 3101.92
R846 VSS.t576 VSS.t669 3101.92
R847 VSS.t672 VSS.t582 3101.92
R848 VSS.t675 VSS.t585 3101.92
R849 VSS.t681 VSS.t588 3101.92
R850 VSS.t687 VSS.t597 3101.92
R851 VSS.t597 VSS.t690 3101.92
R852 VSS.t712 VSS.t612 3101.92
R853 VSS.t715 VSS.t615 3101.92
R854 VSS.t618 VSS.t721 3101.92
R855 VSS.t621 VSS.t724 3101.92
R856 VSS.t627 VSS.t727 3101.92
R857 VSS.t630 VSS.t730 3101.92
R858 VSS.t426 VSS.t506 3101.92
R859 VSS.t526 VSS.t448 3101.92
R860 VSS.t529 VSS.t451 3101.92
R861 VSS.t457 VSS.t532 3101.92
R862 VSS.t460 VSS.t535 3101.92
R863 VSS.t3014 VSS.n3726 2714.18
R864 VSS.t2796 VSS.n5797 2714.18
R865 VSS.t2581 VSS.n4749 2714.18
R866 VSS.t2366 VSS.n6830 2714.18
R867 VSS.t2151 VSS.n8279 2714.18
R868 VSS.t1936 VSS.n9317 2714.18
R869 VSS.t1721 VSS.n2196 2714.18
R870 VSS.t1503 VSS.n10350 2714.18
R871 VSS.t1288 VSS.n11799 2714.18
R872 VSS.t1073 VSS.n12837 2714.18
R873 VSS.t858 VSS.n1555 2714.18
R874 VSS.t648 VSS.n13837 2714.18
R875 VSS.n14216 VSS.t594 2714.18
R876 VSS.n13739 VSS.t600 2714.18
R877 VSS.t500 VSS.n14560 2714.18
R878 VSS.t440 VSS.t511 2714.18
R879 VSS.n2884 VSS.t3125 2620.06
R880 VSS.t3134 VSS.n2883 2620.06
R881 VSS.t3143 VSS.n2882 2620.06
R882 VSS.t3152 VSS.n2881 2620.06
R883 VSS.t3161 VSS.n2880 2620.06
R884 VSS.t3170 VSS.n2879 2620.06
R885 VSS.t3179 VSS.n2878 2620.06
R886 VSS.t3188 VSS.n2877 2620.06
R887 VSS.t3197 VSS.n2876 2620.06
R888 VSS.t3206 VSS.n2875 2620.06
R889 VSS.n3427 VSS.t3215 2620.06
R890 VSS.n3428 VSS.t3224 2620.06
R891 VSS.t3233 VSS.t3236 2620.06
R892 VSS.t3003 VSS.t3432 2351.72
R893 VSS.t1710 VSS.t3400 2351.72
R894 VSS.t690 VSS.t126 2343.29
R895 VSS.t600 VSS.t695 2326.44
R896 VSS.t709 VSS.t609 2326.44
R897 VSS.t520 VSS.t442 2326.44
R898 VSS.t523 VSS.t445 2326.44
R899 VSS.t3355 VSS.t2892 1955.56
R900 VSS.t3442 VSS.t1599 1955.56
R901 VSS.t55 VSS.t99 1955.56
R902 VSS.t3298 VSS.t192 1955.56
R903 VSS.t103 VSS.t440 1955.56
R904 VSS.t263 VSS.t515 1955.56
R905 VSS.n3726 VSS.t2906 1938.7
R906 VSS.n3701 VSS.t3023 1938.7
R907 VSS.n3676 VSS.t2921 1938.7
R908 VSS.n3651 VSS.t3038 1938.7
R909 VSS.n3626 VSS.t2936 1938.7
R910 VSS.n3601 VSS.t3053 1938.7
R911 VSS.n3576 VSS.t2951 1938.7
R912 VSS.n3551 VSS.t3068 1938.7
R913 VSS.n3526 VSS.t2966 1938.7
R914 VSS.n3501 VSS.t3083 1938.7
R915 VSS.n3476 VSS.t2981 1938.7
R916 VSS.t3098 VSS.n4397 1938.7
R917 VSS.n5797 VSS.t2691 1938.7
R918 VSS.t2805 VSS.n5119 1938.7
R919 VSS.t2706 VSS.n5120 1938.7
R920 VSS.t2820 VSS.n5121 1938.7
R921 VSS.t2721 VSS.n5122 1938.7
R922 VSS.t2835 VSS.n5123 1938.7
R923 VSS.t2736 VSS.n5124 1938.7
R924 VSS.t2850 VSS.n5125 1938.7
R925 VSS.t2751 VSS.n5126 1938.7
R926 VSS.t2865 VSS.n5127 1938.7
R927 VSS.t2766 VSS.n5128 1938.7
R928 VSS.t2880 VSS.n5129 1938.7
R929 VSS.n4749 VSS.t2476 1938.7
R930 VSS.n4724 VSS.t2590 1938.7
R931 VSS.n4699 VSS.t2491 1938.7
R932 VSS.n4674 VSS.t2605 1938.7
R933 VSS.n4649 VSS.t2506 1938.7
R934 VSS.n4624 VSS.t2620 1938.7
R935 VSS.n4599 VSS.t2521 1938.7
R936 VSS.n4574 VSS.t2635 1938.7
R937 VSS.n4549 VSS.t2536 1938.7
R938 VSS.n4524 VSS.t2650 1938.7
R939 VSS.n4499 VSS.t2551 1938.7
R940 VSS.t2665 VSS.n6478 1938.7
R941 VSS.n6830 VSS.t2261 1938.7
R942 VSS.n6805 VSS.t2375 1938.7
R943 VSS.n6780 VSS.t2276 1938.7
R944 VSS.n6755 VSS.t2390 1938.7
R945 VSS.n6730 VSS.t2291 1938.7
R946 VSS.n6705 VSS.t2405 1938.7
R947 VSS.n6680 VSS.t2306 1938.7
R948 VSS.n6655 VSS.t2420 1938.7
R949 VSS.n6630 VSS.t2321 1938.7
R950 VSS.n6605 VSS.t2435 1938.7
R951 VSS.n6580 VSS.t2336 1938.7
R952 VSS.t2450 VSS.n7520 1938.7
R953 VSS.n8279 VSS.t2046 1938.7
R954 VSS.t2160 VSS.n7596 1938.7
R955 VSS.t2061 VSS.n7597 1938.7
R956 VSS.t2175 VSS.n7598 1938.7
R957 VSS.t2076 VSS.n7599 1938.7
R958 VSS.t2190 VSS.n7600 1938.7
R959 VSS.t2091 VSS.n7601 1938.7
R960 VSS.t2205 VSS.n7602 1938.7
R961 VSS.t2106 VSS.n7603 1938.7
R962 VSS.t2220 VSS.n7604 1938.7
R963 VSS.t2121 VSS.n7605 1938.7
R964 VSS.t2235 VSS.n7606 1938.7
R965 VSS.n9317 VSS.t1831 1938.7
R966 VSS.t1945 VSS.n8639 1938.7
R967 VSS.t1846 VSS.n8640 1938.7
R968 VSS.t1960 VSS.n8641 1938.7
R969 VSS.t1861 VSS.n8642 1938.7
R970 VSS.t1975 VSS.n8643 1938.7
R971 VSS.t1876 VSS.n8644 1938.7
R972 VSS.t1990 VSS.n8645 1938.7
R973 VSS.t1891 VSS.n8646 1938.7
R974 VSS.t2005 VSS.n8647 1938.7
R975 VSS.t1906 VSS.n8648 1938.7
R976 VSS.t2020 VSS.n8649 1938.7
R977 VSS.n2196 VSS.t1613 1938.7
R978 VSS.n2171 VSS.t1730 1938.7
R979 VSS.n2146 VSS.t1628 1938.7
R980 VSS.n2121 VSS.t1745 1938.7
R981 VSS.n2096 VSS.t1643 1938.7
R982 VSS.n2071 VSS.t1760 1938.7
R983 VSS.n2046 VSS.t1658 1938.7
R984 VSS.n2021 VSS.t1775 1938.7
R985 VSS.n1996 VSS.t1673 1938.7
R986 VSS.n1971 VSS.t1790 1938.7
R987 VSS.n1946 VSS.t1688 1938.7
R988 VSS.t1805 VSS.n9998 1938.7
R989 VSS.n10350 VSS.t1398 1938.7
R990 VSS.n10325 VSS.t1512 1938.7
R991 VSS.n10300 VSS.t1413 1938.7
R992 VSS.n10275 VSS.t1527 1938.7
R993 VSS.n10250 VSS.t1428 1938.7
R994 VSS.n10225 VSS.t1542 1938.7
R995 VSS.n10200 VSS.t1443 1938.7
R996 VSS.n10175 VSS.t1557 1938.7
R997 VSS.n10150 VSS.t1458 1938.7
R998 VSS.n10125 VSS.t1572 1938.7
R999 VSS.n10100 VSS.t1473 1938.7
R1000 VSS.t1587 VSS.n11040 1938.7
R1001 VSS.n11799 VSS.t1183 1938.7
R1002 VSS.t1297 VSS.n11116 1938.7
R1003 VSS.t1198 VSS.n11117 1938.7
R1004 VSS.t1312 VSS.n11118 1938.7
R1005 VSS.t1213 VSS.n11119 1938.7
R1006 VSS.t1327 VSS.n11120 1938.7
R1007 VSS.t1228 VSS.n11121 1938.7
R1008 VSS.t1342 VSS.n11122 1938.7
R1009 VSS.t1243 VSS.n11123 1938.7
R1010 VSS.t1357 VSS.n11124 1938.7
R1011 VSS.t1258 VSS.n11125 1938.7
R1012 VSS.t1372 VSS.n11126 1938.7
R1013 VSS.n12837 VSS.t968 1938.7
R1014 VSS.t1082 VSS.n12159 1938.7
R1015 VSS.t983 VSS.n12160 1938.7
R1016 VSS.t1097 VSS.n12161 1938.7
R1017 VSS.t998 VSS.n12162 1938.7
R1018 VSS.t1112 VSS.n12163 1938.7
R1019 VSS.t1013 VSS.n12164 1938.7
R1020 VSS.t1127 VSS.n12165 1938.7
R1021 VSS.t1028 VSS.n12166 1938.7
R1022 VSS.t1142 VSS.n12167 1938.7
R1023 VSS.t1043 VSS.n12168 1938.7
R1024 VSS.t1157 VSS.n12169 1938.7
R1025 VSS.n1555 VSS.t753 1938.7
R1026 VSS.n1530 VSS.t867 1938.7
R1027 VSS.n1505 VSS.t768 1938.7
R1028 VSS.n1480 VSS.t882 1938.7
R1029 VSS.n1455 VSS.t783 1938.7
R1030 VSS.n1430 VSS.t897 1938.7
R1031 VSS.n1405 VSS.t798 1938.7
R1032 VSS.n1380 VSS.t912 1938.7
R1033 VSS.n1355 VSS.t813 1938.7
R1034 VSS.n1330 VSS.t927 1938.7
R1035 VSS.n1305 VSS.t828 1938.7
R1036 VSS.t942 VSS.n13518 1938.7
R1037 VSS.n13837 VSS.t558 1938.7
R1038 VSS.n13812 VSS.t657 1938.7
R1039 VSS.n13787 VSS.t573 1938.7
R1040 VSS.n13762 VSS.t672 1938.7
R1041 VSS.t588 VSS.n14215 1938.7
R1042 VSS.n14216 VSS.t687 1938.7
R1043 VSS.n13645 VSS.t712 1938.7
R1044 VSS.n13620 VSS.t618 1938.7
R1045 VSS.t727 VSS.n14483 1938.7
R1046 VSS.t448 VSS.n14565 1938.7
R1047 VSS.t532 VSS.n14566 1938.7
R1048 VSS.t286 VSS.t283 1702.63
R1049 VSS.t301 VSS.t304 1702.63
R1050 VSS.t322 VSS.t319 1702.63
R1051 VSS.t337 VSS.t334 1702.63
R1052 VSS.t352 VSS.t349 1702.63
R1053 VSS.t364 VSS.t367 1702.63
R1054 VSS.t382 VSS.t385 1702.63
R1055 VSS.t3395 VSS.t184 1593.1
R1056 VSS.t3329 VSS.t231 1593.1
R1057 VSS.t3414 VSS.t250 1593.1
R1058 VSS.t112 VSS.t3425 1593.1
R1059 VSS.t3312 VSS.t3296 1584.67
R1060 VSS.t3345 VSS.t3338 1584.67
R1061 VSS.t3291 VSS.t238 1584.67
R1062 VSS.t3287 VSS.t3245 1584.67
R1063 VSS.t2897 VSS.t3006 1550.96
R1064 VSS.t3008 VSS.t2900 1550.96
R1065 VSS.t3011 VSS.t2903 1550.96
R1066 VSS.t2790 VSS.t2685 1550.96
R1067 VSS.t2793 VSS.t2688 1550.96
R1068 VSS.t2575 VSS.t2470 1550.96
R1069 VSS.t2578 VSS.t2473 1550.96
R1070 VSS.t2360 VSS.t2255 1550.96
R1071 VSS.t2363 VSS.t2258 1550.96
R1072 VSS.t2145 VSS.t2040 1550.96
R1073 VSS.t2148 VSS.t2043 1550.96
R1074 VSS.t1930 VSS.t1825 1550.96
R1075 VSS.t1933 VSS.t1828 1550.96
R1076 VSS.t1604 VSS.t1713 1550.96
R1077 VSS.t1715 VSS.t1607 1550.96
R1078 VSS.t1718 VSS.t1610 1550.96
R1079 VSS.t1497 VSS.t1392 1550.96
R1080 VSS.t1500 VSS.t1395 1550.96
R1081 VSS.t1282 VSS.t1177 1550.96
R1082 VSS.t1285 VSS.t1180 1550.96
R1083 VSS.t1067 VSS.t962 1550.96
R1084 VSS.t1070 VSS.t965 1550.96
R1085 VSS.t852 VSS.t747 1550.96
R1086 VSS.t855 VSS.t750 1550.96
R1087 VSS.t642 VSS.t552 1550.96
R1088 VSS.t645 VSS.t555 1550.96
R1089 VSS.n14559 VSS.t498 1550.96
R1090 VSS.t508 VSS.t432 1550.96
R1091 VSS.t511 VSS.t437 1550.96
R1092 VSS.t47 VSS.t3365 1517.24
R1093 VSS.t515 VSS.t3387 1508.81
R1094 VSS.n15269 VSS.t2892 1483.52
R1095 VSS.n15268 VSS.t2677 1483.52
R1096 VSS.n15267 VSS.t2462 1483.52
R1097 VSS.n15266 VSS.t2247 1483.52
R1098 VSS.n15265 VSS.t2032 1483.52
R1099 VSS.n15264 VSS.t1817 1483.52
R1100 VSS.n15263 VSS.t1599 1483.52
R1101 VSS.n15262 VSS.t1384 1483.52
R1102 VSS.n15261 VSS.t1169 1483.52
R1103 VSS.n15260 VSS.t954 1483.52
R1104 VSS.n15259 VSS.t739 1483.52
R1105 VSS.n15258 VSS.t544 1483.52
R1106 VSS.n15257 VSS.t396 1483.52
R1107 VSS.n15223 VSS.t42 1483.52
R1108 VSS.n14314 VSS.t71 1416.09
R1109 VSS.t124 VSS.t492 1331.8
R1110 VSS.t43 VSS.t503 1289.66
R1111 VSS.t277 VSS.t240 1281.6
R1112 VSS.t379 VSS.t376 1276.97
R1113 VSS.n14313 VSS.t3397 1247.51
R1114 VSS.n14560 VSS.t3438 1247.51
R1115 VSS.n14564 VSS.t3424 1247.51
R1116 VSS.n15271 VSS.n15270 1198.25
R1117 VSS.t391 VSS.n526 1198.25
R1118 VSS.n1258 VSS.n1257 1198.25
R1119 VSS.n1256 VSS.n1255 1198.25
R1120 VSS.n559 VSS.n546 1198.25
R1121 VSS.n1107 VSS.n1106 1198.25
R1122 VSS.n1105 VSS.n1104 1198.25
R1123 VSS.n992 VSS.n991 1198.25
R1124 VSS.n990 VSS.n989 1198.25
R1125 VSS.n880 VSS.n879 1198.25
R1126 VSS.n878 VSS.n877 1198.25
R1127 VSS.n664 VSS.n610 1198.25
R1128 VSS.n665 VSS.n630 1198.25
R1129 VSS.n667 VSS.n666 1198.25
R1130 VSS.n15256 VSS.n15255 1198.25
R1131 VSS.n14315 VSS.n14314 1198.25
R1132 VSS.n13739 VSS.n13720 1198.25
R1133 VSS.n15041 VSS.n15040 1198.25
R1134 VSS.t3236 VSS.n2606 1198.25
R1135 VSS.n3429 VSS.n3428 1198.25
R1136 VSS.n3427 VSS.n3426 1198.25
R1137 VSS.n2875 VSS.n2695 1198.25
R1138 VSS.n2876 VSS.n2715 1198.25
R1139 VSS.n2877 VSS.n2735 1198.25
R1140 VSS.n2878 VSS.n2755 1198.25
R1141 VSS.n2879 VSS.n2775 1198.25
R1142 VSS.n2880 VSS.n2795 1198.25
R1143 VSS.n2881 VSS.n2815 1198.25
R1144 VSS.n2882 VSS.n2835 1198.25
R1145 VSS.n2883 VSS.n2855 1198.25
R1146 VSS.n2885 VSS.n2884 1198.25
R1147 VSS.n14563 VSS.t104 1197.9
R1148 VSS.n15224 VSS.n15223 1196.86
R1149 VSS.n14217 VSS.n14216 1196.22
R1150 VSS.n14360 VSS.n13645 1196.21
R1151 VSS.n3792 VSS.n3741 1195.68
R1152 VSS.n5870 VSS.n5798 1195.68
R1153 VSS.n4834 VSS.n4764 1195.68
R1154 VSS.n6915 VSS.n6845 1195.68
R1155 VSS.n8352 VSS.n8280 1195.68
R1156 VSS.n9390 VSS.n9318 1195.68
R1157 VSS.n2262 VSS.n2211 1195.68
R1158 VSS.n10435 VSS.n10365 1195.68
R1159 VSS.n11872 VSS.n11800 1195.68
R1160 VSS.n12910 VSS.n12838 1195.68
R1161 VSS.n1640 VSS.n1570 1195.68
R1162 VSS.n13922 VSS.n13852 1195.68
R1163 VSS.n4397 VSS.n4396 1195.49
R1164 VSS.n4274 VSS.n3501 1195.49
R1165 VSS.n4173 VSS.n3551 1195.49
R1166 VSS.n4072 VSS.n3601 1195.49
R1167 VSS.n3971 VSS.n3651 1195.49
R1168 VSS.n3870 VSS.n3701 1195.49
R1169 VSS.n5129 VSS.n5097 1195.49
R1170 VSS.n5127 VSS.n5055 1195.49
R1171 VSS.n5125 VSS.n5013 1195.49
R1172 VSS.n5123 VSS.n4971 1195.49
R1173 VSS.n5121 VSS.n4929 1195.49
R1174 VSS.n5119 VSS.n4887 1195.49
R1175 VSS.n6478 VSS.n6477 1195.49
R1176 VSS.n6355 VSS.n4524 1195.49
R1177 VSS.n6254 VSS.n4574 1195.49
R1178 VSS.n6153 VSS.n4624 1195.49
R1179 VSS.n6052 VSS.n4674 1195.49
R1180 VSS.n5951 VSS.n4724 1195.49
R1181 VSS.n7520 VSS.n7519 1195.49
R1182 VSS.n7397 VSS.n6605 1195.49
R1183 VSS.n7296 VSS.n6655 1195.49
R1184 VSS.n7195 VSS.n6705 1195.49
R1185 VSS.n7094 VSS.n6755 1195.49
R1186 VSS.n6993 VSS.n6805 1195.49
R1187 VSS.n7606 VSS.n2525 1195.49
R1188 VSS.n7604 VSS.n2483 1195.49
R1189 VSS.n7602 VSS.n2441 1195.49
R1190 VSS.n7600 VSS.n2399 1195.49
R1191 VSS.n7598 VSS.n2357 1195.49
R1192 VSS.n7596 VSS.n2315 1195.49
R1193 VSS.n8649 VSS.n8617 1195.49
R1194 VSS.n8647 VSS.n8575 1195.49
R1195 VSS.n8645 VSS.n8533 1195.49
R1196 VSS.n8643 VSS.n8491 1195.49
R1197 VSS.n8641 VSS.n8449 1195.49
R1198 VSS.n8639 VSS.n8407 1195.49
R1199 VSS.n9998 VSS.n9997 1195.49
R1200 VSS.n9875 VSS.n1971 1195.49
R1201 VSS.n9774 VSS.n2021 1195.49
R1202 VSS.n9673 VSS.n2071 1195.49
R1203 VSS.n9572 VSS.n2121 1195.49
R1204 VSS.n9471 VSS.n2171 1195.49
R1205 VSS.n11040 VSS.n11039 1195.49
R1206 VSS.n10917 VSS.n10125 1195.49
R1207 VSS.n10816 VSS.n10175 1195.49
R1208 VSS.n10715 VSS.n10225 1195.49
R1209 VSS.n10614 VSS.n10275 1195.49
R1210 VSS.n10513 VSS.n10325 1195.49
R1211 VSS.n11126 VSS.n1903 1195.49
R1212 VSS.n11124 VSS.n1861 1195.49
R1213 VSS.n11122 VSS.n1819 1195.49
R1214 VSS.n11120 VSS.n1777 1195.49
R1215 VSS.n11118 VSS.n1735 1195.49
R1216 VSS.n11116 VSS.n1693 1195.49
R1217 VSS.n12169 VSS.n12137 1195.49
R1218 VSS.n12167 VSS.n12095 1195.49
R1219 VSS.n12165 VSS.n12053 1195.49
R1220 VSS.n12163 VSS.n12011 1195.49
R1221 VSS.n12161 VSS.n11969 1195.49
R1222 VSS.n12159 VSS.n11927 1195.49
R1223 VSS.n13518 VSS.n13517 1195.49
R1224 VSS.n13395 VSS.n1330 1195.49
R1225 VSS.n13294 VSS.n1380 1195.49
R1226 VSS.n13193 VSS.n1430 1195.49
R1227 VSS.n13092 VSS.n1480 1195.49
R1228 VSS.n12991 VSS.n1530 1195.49
R1229 VSS.n14483 VSS.n14482 1195.49
R1230 VSS.n14101 VSS.n13762 1195.49
R1231 VSS.n14000 VSS.n13812 1195.49
R1232 VSS.n14566 VSS.n451 1195.49
R1233 VSS.n4398 VSS.t2996 1194.5
R1234 VSS.n4324 VSS.n3476 1194.5
R1235 VSS.n4223 VSS.n3526 1194.5
R1236 VSS.n4122 VSS.n3576 1194.5
R1237 VSS.n4021 VSS.n3626 1194.5
R1238 VSS.n3920 VSS.n3676 1194.5
R1239 VSS.n3819 VSS.n3726 1194.5
R1240 VSS.n5130 VSS.t2781 1194.5
R1241 VSS.n5128 VSS.n5078 1194.5
R1242 VSS.n5126 VSS.n5036 1194.5
R1243 VSS.n5124 VSS.n4994 1194.5
R1244 VSS.n5122 VSS.n4952 1194.5
R1245 VSS.n5120 VSS.n4910 1194.5
R1246 VSS.n5797 VSS.n5796 1194.5
R1247 VSS.n6479 VSS.t2566 1194.5
R1248 VSS.n6405 VSS.n4499 1194.5
R1249 VSS.n6304 VSS.n4549 1194.5
R1250 VSS.n6203 VSS.n4599 1194.5
R1251 VSS.n6102 VSS.n4649 1194.5
R1252 VSS.n6001 VSS.n4699 1194.5
R1253 VSS.n5900 VSS.n4749 1194.5
R1254 VSS.n7521 VSS.t2351 1194.5
R1255 VSS.n7447 VSS.n6580 1194.5
R1256 VSS.n7346 VSS.n6630 1194.5
R1257 VSS.n7245 VSS.n6680 1194.5
R1258 VSS.n7144 VSS.n6730 1194.5
R1259 VSS.n7043 VSS.n6780 1194.5
R1260 VSS.n6942 VSS.n6830 1194.5
R1261 VSS.n7607 VSS.t2136 1194.5
R1262 VSS.n7605 VSS.n2506 1194.5
R1263 VSS.n7603 VSS.n2464 1194.5
R1264 VSS.n7601 VSS.n2422 1194.5
R1265 VSS.n7599 VSS.n2380 1194.5
R1266 VSS.n7597 VSS.n2338 1194.5
R1267 VSS.n8279 VSS.n8278 1194.5
R1268 VSS.n8650 VSS.t1921 1194.5
R1269 VSS.n8648 VSS.n8598 1194.5
R1270 VSS.n8646 VSS.n8556 1194.5
R1271 VSS.n8644 VSS.n8514 1194.5
R1272 VSS.n8642 VSS.n8472 1194.5
R1273 VSS.n8640 VSS.n8430 1194.5
R1274 VSS.n9317 VSS.n9316 1194.5
R1275 VSS.n9999 VSS.t1703 1194.5
R1276 VSS.n9925 VSS.n1946 1194.5
R1277 VSS.n9824 VSS.n1996 1194.5
R1278 VSS.n9723 VSS.n2046 1194.5
R1279 VSS.n9622 VSS.n2096 1194.5
R1280 VSS.n9521 VSS.n2146 1194.5
R1281 VSS.n9420 VSS.n2196 1194.5
R1282 VSS.n11041 VSS.t1488 1194.5
R1283 VSS.n10967 VSS.n10100 1194.5
R1284 VSS.n10866 VSS.n10150 1194.5
R1285 VSS.n10765 VSS.n10200 1194.5
R1286 VSS.n10664 VSS.n10250 1194.5
R1287 VSS.n10563 VSS.n10300 1194.5
R1288 VSS.n10462 VSS.n10350 1194.5
R1289 VSS.n11127 VSS.t1273 1194.5
R1290 VSS.n11125 VSS.n1884 1194.5
R1291 VSS.n11123 VSS.n1842 1194.5
R1292 VSS.n11121 VSS.n1800 1194.5
R1293 VSS.n11119 VSS.n1758 1194.5
R1294 VSS.n11117 VSS.n1716 1194.5
R1295 VSS.n11799 VSS.n11798 1194.5
R1296 VSS.n12170 VSS.t1058 1194.5
R1297 VSS.n12168 VSS.n12118 1194.5
R1298 VSS.n12166 VSS.n12076 1194.5
R1299 VSS.n12164 VSS.n12034 1194.5
R1300 VSS.n12162 VSS.n11992 1194.5
R1301 VSS.n12160 VSS.n11950 1194.5
R1302 VSS.n12837 VSS.n12836 1194.5
R1303 VSS.n13519 VSS.t843 1194.5
R1304 VSS.n13445 VSS.n1305 1194.5
R1305 VSS.n13344 VSS.n1355 1194.5
R1306 VSS.n13243 VSS.n1405 1194.5
R1307 VSS.n13142 VSS.n1455 1194.5
R1308 VSS.n13041 VSS.n1505 1194.5
R1309 VSS.n12940 VSS.n1555 1194.5
R1310 VSS.n14484 VSS.t633 1194.5
R1311 VSS.n14410 VSS.n13620 1194.5
R1312 VSS.n14215 VSS.n14214 1194.5
R1313 VSS.n14050 VSS.n13787 1194.5
R1314 VSS.n13949 VSS.n13837 1194.5
R1315 VSS.n14313 VSS.n14312 1194.5
R1316 VSS.n14567 VSS.t463 1194.5
R1317 VSS.n14565 VSS.n432 1194.5
R1318 VSS.n14561 VSS.n194 1194.5
R1319 VSS.n14559 VSS.n337 1194.5
R1320 VSS.n14564 VSS.n394 1194.5
R1321 VSS.n14562 VSS.n373 1194.5
R1322 VSS.n14560 VSS.n352 1194.5
R1323 VSS.n15136 VSS.n15135 1194.5
R1324 VSS.n15222 VSS.n15221 1194.5
R1325 VSS.t3357 VSS.n14559 1188.51
R1326 VSS.t503 VSS.t206 1188.51
R1327 VSS.t3299 VSS.n14561 1188.51
R1328 VSS.t3253 VSS.n15136 1180.08
R1329 VSS.t3323 VSS.t194 1180.08
R1330 VSS.n15039 VSS.n196 1194.67
R1331 VSS.t404 VSS.t478 1163.22
R1332 VSS.t492 VSS.t406 1163.22
R1333 VSS.n14561 VSS.t426 1163.22
R1334 VSS.n14562 VSS.t508 1163.22
R1335 VSS.n196 VSS.n15038 15.3525
R1336 VSS.t135 VSS.t3337 1104.21
R1337 VSS.t87 VSS.t489 1095.79
R1338 VSS.t274 VSS.t277 1064.14
R1339 VSS.t289 VSS.t286 1064.14
R1340 VSS.t304 VSS.t307 1064.14
R1341 VSS.t325 VSS.t322 1064.14
R1342 VSS.t340 VSS.t337 1064.14
R1343 VSS.t355 VSS.t352 1064.14
R1344 VSS.t367 VSS.t370 1064.14
R1345 VSS.t385 VSS.t388 1064.14
R1346 VSS.n14239 VSS.n14238 1010.37
R1347 VSS.t3394 VSS.t3320 1003.07
R1348 VSS.t3266 VSS.t3314 1003.07
R1349 VSS.t3342 VSS.t3315 1003.07
R1350 VSS.t3318 VSS.t3420 1003.07
R1351 VSS.t3388 VSS.t11 1003.07
R1352 VSS.n3792 VSS.n3791 999.448
R1353 VSS.n2262 VSS.n2261 999.448
R1354 VSS.t310 VSS.t25 997.827
R1355 VSS.t328 VSS.t91 997.827
R1356 VSS.t131 VSS.t346 997.827
R1357 VSS.t376 VSS.t97 997.827
R1358 VSS.t3243 VSS.t3421 994.636
R1359 VSS.t271 VSS.t61 994.636
R1360 VSS.t3250 VSS.t3312 944.062
R1361 VSS.t3338 VSS.t3346 944.062
R1362 VSS.t238 VSS.t3262 944.062
R1363 VSS.t15 VSS.t135 944.062
R1364 VSS.n15256 VSS.t283 922.258
R1365 VSS.n665 VSS.t301 922.258
R1366 VSS.n664 VSS.t310 922.258
R1367 VSS.t319 VSS.n878 922.258
R1368 VSS.t334 VSS.n990 922.258
R1369 VSS.n1105 VSS.t346 922.258
R1370 VSS.t349 VSS.n1105 922.258
R1371 VSS.n559 VSS.t364 922.258
R1372 VSS.n1257 VSS.t382 922.258
R1373 VSS.t180 VSS.t3298 910.346
R1374 VSS.t194 VSS.t3311 910.346
R1375 VSS.t3251 VSS.t272 893.487
R1376 VSS.t123 VSS.t199 893.487
R1377 VSS.t3344 VSS.t3347 893.487
R1378 VSS.t31 VSS.t85 893.487
R1379 VSS.t254 VSS.t3419 893.487
R1380 VSS.t3383 VSS.t259 893.487
R1381 VSS.t18 VSS.t3248 893.487
R1382 VSS.t16 VSS.t3274 893.487
R1383 VSS.t156 VSS.t472 859.77
R1384 VSS.t272 VSS.t3394 851.341
R1385 VSS.t3314 VSS.t123 851.341
R1386 VSS.t3315 VSS.t3344 851.341
R1387 VSS.t9 VSS.t31 851.341
R1388 VSS.t3420 VSS.t254 851.341
R1389 VSS.t259 VSS.t262 851.341
R1390 VSS.t3274 VSS.t3388 851.341
R1391 VSS.t196 VSS.t177 842.913
R1392 VSS.t3279 VSS.t3427 842.913
R1393 VSS.t3320 VSS.t273 834.484
R1394 VSS.t3346 VSS.t3343 834.484
R1395 VSS.t32 VSS.t3334 834.484
R1396 VSS.t3262 VSS.t32 834.484
R1397 VSS.t253 VSS.t3318 834.484
R1398 VSS.t256 VSS.t483 834.484
R1399 VSS.t684 VSS.t108 826.054
R1400 VSS.t695 VSS.t222 826.054
R1401 VSS.t3421 VSS.t43 826.054
R1402 VSS.t2 VSS.t18 826.054
R1403 VSS.t3427 VSS.t3265 826.054
R1404 VSS.t148 VSS.t271 826.054
R1405 VSS.t145 VSS.t3253 809.196
R1406 VSS.t3413 VSS.t114 809.196
R1407 VSS.t506 VSS.t233 809.196
R1408 VSS.t3282 VSS.t434 809.196
R1409 VSS.t3431 VSS.t3355 800.766
R1410 VSS.t3398 VSS.t3442 800.766
R1411 VSS.t199 VSS.t3395 800.766
R1412 VSS.t3347 VSS.t3329 800.766
R1413 VSS.t85 VSS.t3414 800.766
R1414 VSS.t3419 VSS.t256 800.766
R1415 VSS.t3425 VSS.t16 800.766
R1416 VSS.t3363 VSS.t703 792.337
R1417 VSS.t478 VSS.t186 792.337
R1418 VSS.t205 VSS.t486 792.337
R1419 VSS.t489 VSS.t3263 792.337
R1420 VSS.t406 VSS.t3289 792.337
R1421 VSS.t3384 VSS.t3325 783.909
R1422 VSS.t298 VSS.n665 780.372
R1423 VSS.t313 VSS.t316 780.372
R1424 VSS.n15223 VSS.t404 775.48
R1425 VSS.t423 VSS.t500 775.48
R1426 VSS.t83 VSS.t684 758.621
R1427 VSS.t483 VSS.t101 758.621
R1428 VSS.t35 VSS.t55 741.763
R1429 VSS.t3289 VSS.t3323 741.763
R1430 VSS.t3281 VSS.t200 724.904
R1431 VSS.t90 VSS.t3281 724.904
R1432 VSS.t152 VSS.t150 724.904
R1433 VSS.t150 VSS.t221 724.904
R1434 VSS.t144 VSS.t142 724.904
R1435 VSS.t117 VSS.t115 724.904
R1436 VSS.t3302 VSS.t3304 724.904
R1437 VSS.t3304 VSS.t3305 724.904
R1438 VSS.t3359 VSS.t3357 724.904
R1439 VSS.t3362 VSS.t3361 724.904
R1440 VSS.t167 VSS.t3362 724.904
R1441 VSS.t166 VSS.t167 724.904
R1442 VSS.t164 VSS.t166 724.904
R1443 VSS.t163 VSS.t164 724.904
R1444 VSS.t161 VSS.t163 724.904
R1445 VSS.t160 VSS.t161 724.904
R1446 VSS.t80 VSS.t81 724.904
R1447 VSS.t75 VSS.t77 724.904
R1448 VSS.t3259 VSS.t73 724.904
R1449 VSS.t3248 VSS.t19 724.904
R1450 VSS.t3307 VSS.t3299 724.904
R1451 VSS.t3309 VSS.t3307 724.904
R1452 VSS.t3310 VSS.t3309 724.904
R1453 VSS.t171 VSS.t172 724.904
R1454 VSS.t3412 VSS.t169 724.904
R1455 VSS.t3410 VSS.t3412 724.904
R1456 VSS.t3409 VSS.t3410 724.904
R1457 VSS.t213 VSS.t215 724.904
R1458 VSS.t212 VSS.t213 724.904
R1459 VSS.t343 VSS.t62 721.768
R1460 VSS.t429 VSS.t171 716.476
R1461 VSS.t203 VSS.t298 712.514
R1462 VSS.t3364 VSS.t313 712.514
R1463 VSS.t3432 VSS.t3431 708.047
R1464 VSS.t3400 VSS.t3398 708.047
R1465 VSS.t108 VSS.t224 708.047
R1466 VSS.t3393 VSS.t83 708.047
R1467 VSS.t3349 VSS.t3351 708.047
R1468 VSS.t3296 VSS.t265 708.047
R1469 VSS.t222 VSS.t8 708.047
R1470 VSS.t264 VSS.t196 708.047
R1471 VSS.t177 VSS.t225 708.047
R1472 VSS.t66 VSS.t3363 708.047
R1473 VSS.t68 VSS.t66 708.047
R1474 VSS.t70 VSS.t68 708.047
R1475 VSS.t71 VSS.t70 708.047
R1476 VSS.t267 VSS.t3345 708.047
R1477 VSS.t231 VSS.t3330 708.047
R1478 VSS.t3260 VSS.t156 708.047
R1479 VSS.t146 VSS.t3260 708.047
R1480 VSS.t202 VSS.t146 708.047
R1481 VSS.t252 VSS.t179 708.047
R1482 VSS.t250 VSS.t3416 708.047
R1483 VSS.t186 VSS.t3291 708.047
R1484 VSS.t128 VSS.t3264 708.047
R1485 VSS.t101 VSS.t255 708.047
R1486 VSS.t3354 VSS.t145 708.047
R1487 VSS.t23 VSS.t205 708.047
R1488 VSS.t3252 VSS.t23 708.047
R1489 VSS.t0 VSS.t3252 708.047
R1490 VSS.t3297 VSS.t0 708.047
R1491 VSS.t237 VSS.t3297 708.047
R1492 VSS.t3272 VSS.t237 708.047
R1493 VSS.t3268 VSS.t3295 708.047
R1494 VSS.t3261 VSS.t111 708.047
R1495 VSS.t39 VSS.t3413 708.047
R1496 VSS.t3270 VSS.t39 708.047
R1497 VSS.t3263 VSS.t3270 708.047
R1498 VSS.t3311 VSS.t87 708.047
R1499 VSS.t3325 VSS.t3324 708.047
R1500 VSS.t3438 VSS.t3384 708.047
R1501 VSS.t3247 VSS.t2 708.047
R1502 VSS.t233 VSS.t3247 708.047
R1503 VSS.t248 VSS.t235 708.047
R1504 VSS.t21 VSS.t3282 708.047
R1505 VSS.t3265 VSS.t21 708.047
R1506 VSS.t3340 VSS.t3279 708.047
R1507 VSS.t106 VSS.t105 708.047
R1508 VSS.t3245 VSS.t3244 708.047
R1509 VSS.t3273 VSS.t3327 708.047
R1510 VSS.t3361 VSS.t417 699.617
R1511 VSS.t3439 VSS.t29 699.617
R1512 VSS.t260 VSS.t7 699.617
R1513 VSS.t3518 VSS.n3732 693.76
R1514 VSS.t3588 VSS.n4853 693.76
R1515 VSS.t3658 VSS.n4755 693.76
R1516 VSS.t3728 VSS.n6836 693.76
R1517 VSS.t3798 VSS.n2281 693.76
R1518 VSS.t3868 VSS.n8373 693.76
R1519 VSS.t3938 VSS.n2202 693.76
R1520 VSS.t4008 VSS.n10356 693.76
R1521 VSS.t4078 VSS.n1659 693.76
R1522 VSS.t4148 VSS.n11893 693.76
R1523 VSS.t4218 VSS.n1561 693.76
R1524 VSS.t4287 VSS.n13843 693.76
R1525 VSS.t697 VSS.t3397 691.188
R1526 VSS.t3424 VSS.t517 691.188
R1527 VSS.t81 VSS.t420 682.76
R1528 VSS.t182 VSS.t226 674.331
R1529 VSS.t155 VSS.t190 674.331
R1530 VSS.t53 VSS.t75 674.331
R1531 VSS.t596 VSS.t4306 667.915
R1532 VSS.t262 VSS.t3254 665.9
R1533 VSS.t153 VSS.t3389 657.471
R1534 VSS.t3402 VSS.t219 657.471
R1535 VSS.t3441 VSS.t141 657.471
R1536 VSS.t249 VSS.t3406 649.043
R1537 VSS.t3423 VSS.t3404 649.043
R1538 VSS.t3428 VSS.t3348 640.614
R1539 VSS.t120 VSS.t3349 640.614
R1540 VSS.t3249 VSS.t3417 640.614
R1541 VSS.t280 VSS.n15256 638.486
R1542 VSS.n879 VSS.t328 638.486
R1543 VSS.t3283 VSS.t331 638.486
R1544 VSS.n1257 VSS.t379 638.486
R1545 VSS.t110 VSS.t86 629.232
R1546 VSS.t692 VSS.t3250 623.755
R1547 VSS.t3285 VSS.t158 615.327
R1548 VSS.t224 VSS.t3341 606.898
R1549 VSS.t210 VSS.t3332 606.898
R1550 VSS.t358 VSS.t3241 599.931
R1551 VSS.t174 VSS.t6 598.467
R1552 VSS.t115 VSS.t56 581.61
R1553 VSS.t175 VSS.t137 581.61
R1554 VSS.t50 VSS.t3272 573.181
R1555 VSS.t295 VSS.t244 572.17
R1556 VSS.t3271 VSS.t280 570.628
R1557 VSS.t3343 VSS.t706 564.751
R1558 VSS.t3301 VSS.t60 564.751
R1559 VSS.t3258 VSS.t3382 556.322
R1560 VSS.t188 VSS.t80 547.894
R1561 VSS.t3386 VSS.t88 547.894
R1562 VSS.t3381 VSS.t78 539.465
R1563 VSS.t4369 VSS.n461 538.312
R1564 VSS.n511 VSS.t4368 538.312
R1565 VSS.n1022 VSS.t4380 538.312
R1566 VSS.n1091 VSS.t4379 538.312
R1567 VSS.n1066 VSS.t4378 538.312
R1568 VSS.n1159 VSS.t4374 538.312
R1569 VSS.n1182 VSS.t4373 538.312
R1570 VSS.n1232 VSS.t4370 538.312
R1571 VSS.n976 VSS.t4383 538.312
R1572 VSS.n951 VSS.t4382 538.312
R1573 VSS.n15242 VSS.t4399 538.312
R1574 VSS.n654 VSS.t4398 538.312
R1575 VSS.n720 VSS.t4393 538.312
R1576 VSS.n743 VSS.t4392 538.312
R1577 VSS.n772 VSS.t4390 538.312
R1578 VSS.n864 VSS.t4387 538.312
R1579 VSS.n839 VSS.t4386 538.312
R1580 VSS.n4420 VSS.t3487 538.312
R1581 VSS.t3491 VSS.n3458 538.312
R1582 VSS.t3496 VSS.n3508 538.312
R1583 VSS.t3501 VSS.n3558 538.312
R1584 VSS.t3506 VSS.n3608 538.312
R1585 VSS.t3511 VSS.n3658 538.312
R1586 VSS.t3516 VSS.n3708 538.312
R1587 VSS.n3728 VSS.t3554 538.312
R1588 VSS.n3844 VSS.t3553 538.312
R1589 VSS.n3879 VSS.t3551 538.312
R1590 VSS.n3889 VSS.t3514 538.312
R1591 VSS.t3550 VSS.n3690 538.312
R1592 VSS.n3678 VSS.t3549 538.312
R1593 VSS.n3945 VSS.t3548 538.312
R1594 VSS.n3980 VSS.t3546 538.312
R1595 VSS.n3990 VSS.t3509 538.312
R1596 VSS.t3545 VSS.n3640 538.312
R1597 VSS.n3628 VSS.t3544 538.312
R1598 VSS.n4046 VSS.t3543 538.312
R1599 VSS.n4081 VSS.t3541 538.312
R1600 VSS.n4091 VSS.t3504 538.312
R1601 VSS.t3540 VSS.n3590 538.312
R1602 VSS.n3578 VSS.t3539 538.312
R1603 VSS.n4147 VSS.t3538 538.312
R1604 VSS.n4182 VSS.t3536 538.312
R1605 VSS.n4192 VSS.t3499 538.312
R1606 VSS.t3535 VSS.n3540 538.312
R1607 VSS.n3528 VSS.t3534 538.312
R1608 VSS.n4248 VSS.t3533 538.312
R1609 VSS.n4283 VSS.t3531 538.312
R1610 VSS.n4293 VSS.t3494 538.312
R1611 VSS.t3530 VSS.n3490 538.312
R1612 VSS.n3478 VSS.t3529 538.312
R1613 VSS.n4349 VSS.t3528 538.312
R1614 VSS.n4377 VSS.t3526 538.312
R1615 VSS.n3444 VSS.t3489 538.312
R1616 VSS.n4452 VSS.t3525 538.312
R1617 VSS.n4432 VSS.t3524 538.312
R1618 VSS.t3556 VSS.n3751 538.312
R1619 VSS.t3522 VSS.n3753 538.312
R1620 VSS.n5152 VSS.t3557 538.312
R1621 VSS.t3561 VSS.n5219 538.312
R1622 VSS.t3566 VSS.n5325 538.312
R1623 VSS.t3571 VSS.n5431 538.312
R1624 VSS.t3576 VSS.n5537 538.312
R1625 VSS.t3581 VSS.n5643 538.312
R1626 VSS.t3586 VSS.n5749 538.312
R1627 VSS.n5787 VSS.t3624 538.312
R1628 VSS.n5762 VSS.t3623 538.312
R1629 VSS.n4892 VSS.t3621 538.312
R1630 VSS.n4899 VSS.t3584 538.312
R1631 VSS.n5704 VSS.t3620 538.312
R1632 VSS.n5680 VSS.t3619 538.312
R1633 VSS.n5656 VSS.t3618 538.312
R1634 VSS.n4934 VSS.t3616 538.312
R1635 VSS.n4941 VSS.t3579 538.312
R1636 VSS.n5598 VSS.t3615 538.312
R1637 VSS.n5574 VSS.t3614 538.312
R1638 VSS.n5550 VSS.t3613 538.312
R1639 VSS.n4976 VSS.t3611 538.312
R1640 VSS.n4983 VSS.t3574 538.312
R1641 VSS.n5492 VSS.t3610 538.312
R1642 VSS.n5468 VSS.t3609 538.312
R1643 VSS.n5444 VSS.t3608 538.312
R1644 VSS.n5018 VSS.t3606 538.312
R1645 VSS.n5025 VSS.t3569 538.312
R1646 VSS.n5386 VSS.t3605 538.312
R1647 VSS.n5362 VSS.t3604 538.312
R1648 VSS.n5338 VSS.t3603 538.312
R1649 VSS.n5060 VSS.t3601 538.312
R1650 VSS.n5067 VSS.t3564 538.312
R1651 VSS.n5280 VSS.t3600 538.312
R1652 VSS.n5256 VSS.t3599 538.312
R1653 VSS.n5232 VSS.t3598 538.312
R1654 VSS.n5102 VSS.t3596 538.312
R1655 VSS.t3559 VSS.n5105 538.312
R1656 VSS.n5184 VSS.t3595 538.312
R1657 VSS.n5164 VSS.t3594 538.312
R1658 VSS.t3591 VSS.n5803 538.312
R1659 VSS.n5857 VSS.t3625 538.312
R1660 VSS.t3592 VSS.n5816 538.312
R1661 VSS.n5834 VSS.t3626 538.312
R1662 VSS.n6501 VSS.t3627 538.312
R1663 VSS.t3631 VSS.n4481 538.312
R1664 VSS.t3636 VSS.n4531 538.312
R1665 VSS.t3641 VSS.n4581 538.312
R1666 VSS.t3646 VSS.n4631 538.312
R1667 VSS.t3651 VSS.n4681 538.312
R1668 VSS.t3656 VSS.n4731 538.312
R1669 VSS.n4751 VSS.t3694 538.312
R1670 VSS.n5925 VSS.t3693 538.312
R1671 VSS.n5960 VSS.t3691 538.312
R1672 VSS.n5970 VSS.t3654 538.312
R1673 VSS.t3690 VSS.n4713 538.312
R1674 VSS.n4701 VSS.t3689 538.312
R1675 VSS.n6026 VSS.t3688 538.312
R1676 VSS.n6061 VSS.t3686 538.312
R1677 VSS.n6071 VSS.t3649 538.312
R1678 VSS.t3685 VSS.n4663 538.312
R1679 VSS.n4651 VSS.t3684 538.312
R1680 VSS.n6127 VSS.t3683 538.312
R1681 VSS.n6162 VSS.t3681 538.312
R1682 VSS.n6172 VSS.t3644 538.312
R1683 VSS.t3680 VSS.n4613 538.312
R1684 VSS.n4601 VSS.t3679 538.312
R1685 VSS.n6228 VSS.t3678 538.312
R1686 VSS.n6263 VSS.t3676 538.312
R1687 VSS.n6273 VSS.t3639 538.312
R1688 VSS.t3675 VSS.n4563 538.312
R1689 VSS.n4551 VSS.t3674 538.312
R1690 VSS.n6329 VSS.t3673 538.312
R1691 VSS.n6364 VSS.t3671 538.312
R1692 VSS.n6374 VSS.t3634 538.312
R1693 VSS.t3670 VSS.n4513 538.312
R1694 VSS.n4501 VSS.t3669 538.312
R1695 VSS.n6430 VSS.t3668 538.312
R1696 VSS.n6458 VSS.t3666 538.312
R1697 VSS.n4467 VSS.t3629 538.312
R1698 VSS.n6533 VSS.t3665 538.312
R1699 VSS.n6513 VSS.t3664 538.312
R1700 VSS.t3661 VSS.n4774 538.312
R1701 VSS.t3695 VSS.n4772 538.312
R1702 VSS.t3662 VSS.n4788 538.312
R1703 VSS.t3696 VSS.n4786 538.312
R1704 VSS.n7543 VSS.t3697 538.312
R1705 VSS.t3701 VSS.n6562 538.312
R1706 VSS.t3706 VSS.n6612 538.312
R1707 VSS.t3711 VSS.n6662 538.312
R1708 VSS.t3716 VSS.n6712 538.312
R1709 VSS.t3721 VSS.n6762 538.312
R1710 VSS.t3726 VSS.n6812 538.312
R1711 VSS.n6832 VSS.t3764 538.312
R1712 VSS.n6967 VSS.t3763 538.312
R1713 VSS.n7002 VSS.t3761 538.312
R1714 VSS.n7012 VSS.t3724 538.312
R1715 VSS.t3760 VSS.n6794 538.312
R1716 VSS.n6782 VSS.t3759 538.312
R1717 VSS.n7068 VSS.t3758 538.312
R1718 VSS.n7103 VSS.t3756 538.312
R1719 VSS.n7113 VSS.t3719 538.312
R1720 VSS.t3755 VSS.n6744 538.312
R1721 VSS.n6732 VSS.t3754 538.312
R1722 VSS.n7169 VSS.t3753 538.312
R1723 VSS.n7204 VSS.t3751 538.312
R1724 VSS.n7214 VSS.t3714 538.312
R1725 VSS.t3750 VSS.n6694 538.312
R1726 VSS.n6682 VSS.t3749 538.312
R1727 VSS.n7270 VSS.t3748 538.312
R1728 VSS.n7305 VSS.t3746 538.312
R1729 VSS.n7315 VSS.t3709 538.312
R1730 VSS.t3745 VSS.n6644 538.312
R1731 VSS.n6632 VSS.t3744 538.312
R1732 VSS.n7371 VSS.t3743 538.312
R1733 VSS.n7406 VSS.t3741 538.312
R1734 VSS.n7416 VSS.t3704 538.312
R1735 VSS.t3740 VSS.n6594 538.312
R1736 VSS.n6582 VSS.t3739 538.312
R1737 VSS.n7472 VSS.t3738 538.312
R1738 VSS.n7500 VSS.t3736 538.312
R1739 VSS.n6548 VSS.t3699 538.312
R1740 VSS.n7575 VSS.t3735 538.312
R1741 VSS.n7555 VSS.t3734 538.312
R1742 VSS.t3731 VSS.n6855 538.312
R1743 VSS.t3765 VSS.n6853 538.312
R1744 VSS.t3732 VSS.n6869 538.312
R1745 VSS.t3766 VSS.n6867 538.312
R1746 VSS.n7629 VSS.t3767 538.312
R1747 VSS.t3771 VSS.n7701 538.312
R1748 VSS.t3776 VSS.n7807 538.312
R1749 VSS.t3781 VSS.n7913 538.312
R1750 VSS.t3786 VSS.n8019 538.312
R1751 VSS.t3791 VSS.n8125 538.312
R1752 VSS.t3796 VSS.n8231 538.312
R1753 VSS.n8269 VSS.t3834 538.312
R1754 VSS.n8244 VSS.t3833 538.312
R1755 VSS.n2320 VSS.t3831 538.312
R1756 VSS.n2327 VSS.t3794 538.312
R1757 VSS.n8186 VSS.t3830 538.312
R1758 VSS.n8162 VSS.t3829 538.312
R1759 VSS.n8138 VSS.t3828 538.312
R1760 VSS.n2362 VSS.t3826 538.312
R1761 VSS.n2369 VSS.t3789 538.312
R1762 VSS.n8080 VSS.t3825 538.312
R1763 VSS.n8056 VSS.t3824 538.312
R1764 VSS.n8032 VSS.t3823 538.312
R1765 VSS.n2404 VSS.t3821 538.312
R1766 VSS.n2411 VSS.t3784 538.312
R1767 VSS.n7974 VSS.t3820 538.312
R1768 VSS.n7950 VSS.t3819 538.312
R1769 VSS.n7926 VSS.t3818 538.312
R1770 VSS.n2446 VSS.t3816 538.312
R1771 VSS.n2453 VSS.t3779 538.312
R1772 VSS.n7868 VSS.t3815 538.312
R1773 VSS.n7844 VSS.t3814 538.312
R1774 VSS.n7820 VSS.t3813 538.312
R1775 VSS.n2488 VSS.t3811 538.312
R1776 VSS.n2495 VSS.t3774 538.312
R1777 VSS.n7762 VSS.t3810 538.312
R1778 VSS.n7738 VSS.t3809 538.312
R1779 VSS.n7714 VSS.t3808 538.312
R1780 VSS.n2530 VSS.t3806 538.312
R1781 VSS.n7589 VSS.t3769 538.312
R1782 VSS.n7661 VSS.t3805 538.312
R1783 VSS.n7641 VSS.t3804 538.312
R1784 VSS.t3801 VSS.n8285 538.312
R1785 VSS.n8339 VSS.t3835 538.312
R1786 VSS.t3802 VSS.n8298 538.312
R1787 VSS.n8316 VSS.t3836 538.312
R1788 VSS.n8672 VSS.t3837 538.312
R1789 VSS.t3841 VSS.n8739 538.312
R1790 VSS.t3846 VSS.n8845 538.312
R1791 VSS.t3851 VSS.n8951 538.312
R1792 VSS.t3856 VSS.n9057 538.312
R1793 VSS.t3861 VSS.n9163 538.312
R1794 VSS.t3866 VSS.n9269 538.312
R1795 VSS.n9307 VSS.t3904 538.312
R1796 VSS.n9282 VSS.t3903 538.312
R1797 VSS.n8412 VSS.t3901 538.312
R1798 VSS.n8419 VSS.t3864 538.312
R1799 VSS.n9224 VSS.t3900 538.312
R1800 VSS.n9200 VSS.t3899 538.312
R1801 VSS.n9176 VSS.t3898 538.312
R1802 VSS.n8454 VSS.t3896 538.312
R1803 VSS.n8461 VSS.t3859 538.312
R1804 VSS.n9118 VSS.t3895 538.312
R1805 VSS.n9094 VSS.t3894 538.312
R1806 VSS.n9070 VSS.t3893 538.312
R1807 VSS.n8496 VSS.t3891 538.312
R1808 VSS.n8503 VSS.t3854 538.312
R1809 VSS.n9012 VSS.t3890 538.312
R1810 VSS.n8988 VSS.t3889 538.312
R1811 VSS.n8964 VSS.t3888 538.312
R1812 VSS.n8538 VSS.t3886 538.312
R1813 VSS.n8545 VSS.t3849 538.312
R1814 VSS.n8906 VSS.t3885 538.312
R1815 VSS.n8882 VSS.t3884 538.312
R1816 VSS.n8858 VSS.t3883 538.312
R1817 VSS.n8580 VSS.t3881 538.312
R1818 VSS.n8587 VSS.t3844 538.312
R1819 VSS.n8800 VSS.t3880 538.312
R1820 VSS.n8776 VSS.t3879 538.312
R1821 VSS.n8752 VSS.t3878 538.312
R1822 VSS.n8622 VSS.t3876 538.312
R1823 VSS.t3839 VSS.n8625 538.312
R1824 VSS.n8704 VSS.t3875 538.312
R1825 VSS.n8684 VSS.t3874 538.312
R1826 VSS.t3871 VSS.n9323 538.312
R1827 VSS.n9377 VSS.t3905 538.312
R1828 VSS.t3872 VSS.n9336 538.312
R1829 VSS.n9354 VSS.t3906 538.312
R1830 VSS.n10021 VSS.t3907 538.312
R1831 VSS.t3911 VSS.n1928 538.312
R1832 VSS.t3916 VSS.n1978 538.312
R1833 VSS.t3921 VSS.n2028 538.312
R1834 VSS.t3926 VSS.n2078 538.312
R1835 VSS.t3931 VSS.n2128 538.312
R1836 VSS.t3936 VSS.n2178 538.312
R1837 VSS.n2198 VSS.t3974 538.312
R1838 VSS.n9445 VSS.t3973 538.312
R1839 VSS.n9480 VSS.t3971 538.312
R1840 VSS.n9490 VSS.t3934 538.312
R1841 VSS.t3970 VSS.n2160 538.312
R1842 VSS.n2148 VSS.t3969 538.312
R1843 VSS.n9546 VSS.t3968 538.312
R1844 VSS.n9581 VSS.t3966 538.312
R1845 VSS.n9591 VSS.t3929 538.312
R1846 VSS.t3965 VSS.n2110 538.312
R1847 VSS.n2098 VSS.t3964 538.312
R1848 VSS.n9647 VSS.t3963 538.312
R1849 VSS.n9682 VSS.t3961 538.312
R1850 VSS.n9692 VSS.t3924 538.312
R1851 VSS.t3960 VSS.n2060 538.312
R1852 VSS.n2048 VSS.t3959 538.312
R1853 VSS.n9748 VSS.t3958 538.312
R1854 VSS.n9783 VSS.t3956 538.312
R1855 VSS.n9793 VSS.t3919 538.312
R1856 VSS.t3955 VSS.n2010 538.312
R1857 VSS.n1998 VSS.t3954 538.312
R1858 VSS.n9849 VSS.t3953 538.312
R1859 VSS.n9884 VSS.t3951 538.312
R1860 VSS.n9894 VSS.t3914 538.312
R1861 VSS.t3950 VSS.n1960 538.312
R1862 VSS.n1948 VSS.t3949 538.312
R1863 VSS.n9950 VSS.t3948 538.312
R1864 VSS.n9978 VSS.t3946 538.312
R1865 VSS.n1914 VSS.t3909 538.312
R1866 VSS.n10053 VSS.t3945 538.312
R1867 VSS.n10033 VSS.t3944 538.312
R1868 VSS.t3976 VSS.n2221 538.312
R1869 VSS.t3942 VSS.n2223 538.312
R1870 VSS.n11063 VSS.t3977 538.312
R1871 VSS.t3981 VSS.n10082 538.312
R1872 VSS.t3986 VSS.n10132 538.312
R1873 VSS.t3991 VSS.n10182 538.312
R1874 VSS.t3996 VSS.n10232 538.312
R1875 VSS.t4001 VSS.n10282 538.312
R1876 VSS.t4006 VSS.n10332 538.312
R1877 VSS.n10352 VSS.t4044 538.312
R1878 VSS.n10487 VSS.t4043 538.312
R1879 VSS.n10522 VSS.t4041 538.312
R1880 VSS.n10532 VSS.t4004 538.312
R1881 VSS.t4040 VSS.n10314 538.312
R1882 VSS.n10302 VSS.t4039 538.312
R1883 VSS.n10588 VSS.t4038 538.312
R1884 VSS.n10623 VSS.t4036 538.312
R1885 VSS.n10633 VSS.t3999 538.312
R1886 VSS.t4035 VSS.n10264 538.312
R1887 VSS.n10252 VSS.t4034 538.312
R1888 VSS.n10689 VSS.t4033 538.312
R1889 VSS.n10724 VSS.t4031 538.312
R1890 VSS.n10734 VSS.t3994 538.312
R1891 VSS.t4030 VSS.n10214 538.312
R1892 VSS.n10202 VSS.t4029 538.312
R1893 VSS.n10790 VSS.t4028 538.312
R1894 VSS.n10825 VSS.t4026 538.312
R1895 VSS.n10835 VSS.t3989 538.312
R1896 VSS.t4025 VSS.n10164 538.312
R1897 VSS.n10152 VSS.t4024 538.312
R1898 VSS.n10891 VSS.t4023 538.312
R1899 VSS.n10926 VSS.t4021 538.312
R1900 VSS.n10936 VSS.t3984 538.312
R1901 VSS.t4020 VSS.n10114 538.312
R1902 VSS.n10102 VSS.t4019 538.312
R1903 VSS.n10992 VSS.t4018 538.312
R1904 VSS.n11020 VSS.t4016 538.312
R1905 VSS.n10068 VSS.t3979 538.312
R1906 VSS.n11095 VSS.t4015 538.312
R1907 VSS.n11075 VSS.t4014 538.312
R1908 VSS.t4011 VSS.n10375 538.312
R1909 VSS.t4045 VSS.n10373 538.312
R1910 VSS.t4012 VSS.n10389 538.312
R1911 VSS.t4046 VSS.n10387 538.312
R1912 VSS.n11149 VSS.t4047 538.312
R1913 VSS.t4051 VSS.n11221 538.312
R1914 VSS.t4056 VSS.n11327 538.312
R1915 VSS.t4061 VSS.n11433 538.312
R1916 VSS.t4066 VSS.n11539 538.312
R1917 VSS.t4071 VSS.n11645 538.312
R1918 VSS.t4076 VSS.n11751 538.312
R1919 VSS.n11789 VSS.t4114 538.312
R1920 VSS.n11764 VSS.t4113 538.312
R1921 VSS.n1698 VSS.t4111 538.312
R1922 VSS.n1705 VSS.t4074 538.312
R1923 VSS.n11706 VSS.t4110 538.312
R1924 VSS.n11682 VSS.t4109 538.312
R1925 VSS.n11658 VSS.t4108 538.312
R1926 VSS.n1740 VSS.t4106 538.312
R1927 VSS.n1747 VSS.t4069 538.312
R1928 VSS.n11600 VSS.t4105 538.312
R1929 VSS.n11576 VSS.t4104 538.312
R1930 VSS.n11552 VSS.t4103 538.312
R1931 VSS.n1782 VSS.t4101 538.312
R1932 VSS.n1789 VSS.t4064 538.312
R1933 VSS.n11494 VSS.t4100 538.312
R1934 VSS.n11470 VSS.t4099 538.312
R1935 VSS.n11446 VSS.t4098 538.312
R1936 VSS.n1824 VSS.t4096 538.312
R1937 VSS.n1831 VSS.t4059 538.312
R1938 VSS.n11388 VSS.t4095 538.312
R1939 VSS.n11364 VSS.t4094 538.312
R1940 VSS.n11340 VSS.t4093 538.312
R1941 VSS.n1866 VSS.t4091 538.312
R1942 VSS.n1873 VSS.t4054 538.312
R1943 VSS.n11282 VSS.t4090 538.312
R1944 VSS.n11258 VSS.t4089 538.312
R1945 VSS.n11234 VSS.t4088 538.312
R1946 VSS.n1908 VSS.t4086 538.312
R1947 VSS.n11109 VSS.t4049 538.312
R1948 VSS.n11181 VSS.t4085 538.312
R1949 VSS.n11161 VSS.t4084 538.312
R1950 VSS.t4081 VSS.n11805 538.312
R1951 VSS.n11859 VSS.t4115 538.312
R1952 VSS.t4082 VSS.n11818 538.312
R1953 VSS.n11836 VSS.t4116 538.312
R1954 VSS.n12192 VSS.t4117 538.312
R1955 VSS.t4121 VSS.n12259 538.312
R1956 VSS.t4126 VSS.n12365 538.312
R1957 VSS.t4131 VSS.n12471 538.312
R1958 VSS.t4136 VSS.n12577 538.312
R1959 VSS.t4141 VSS.n12683 538.312
R1960 VSS.t4146 VSS.n12789 538.312
R1961 VSS.n12827 VSS.t4184 538.312
R1962 VSS.n12802 VSS.t4183 538.312
R1963 VSS.n11932 VSS.t4181 538.312
R1964 VSS.n11939 VSS.t4144 538.312
R1965 VSS.n12744 VSS.t4180 538.312
R1966 VSS.n12720 VSS.t4179 538.312
R1967 VSS.n12696 VSS.t4178 538.312
R1968 VSS.n11974 VSS.t4176 538.312
R1969 VSS.n11981 VSS.t4139 538.312
R1970 VSS.n12638 VSS.t4175 538.312
R1971 VSS.n12614 VSS.t4174 538.312
R1972 VSS.n12590 VSS.t4173 538.312
R1973 VSS.n12016 VSS.t4171 538.312
R1974 VSS.n12023 VSS.t4134 538.312
R1975 VSS.n12532 VSS.t4170 538.312
R1976 VSS.n12508 VSS.t4169 538.312
R1977 VSS.n12484 VSS.t4168 538.312
R1978 VSS.n12058 VSS.t4166 538.312
R1979 VSS.n12065 VSS.t4129 538.312
R1980 VSS.n12426 VSS.t4165 538.312
R1981 VSS.n12402 VSS.t4164 538.312
R1982 VSS.n12378 VSS.t4163 538.312
R1983 VSS.n12100 VSS.t4161 538.312
R1984 VSS.n12107 VSS.t4124 538.312
R1985 VSS.n12320 VSS.t4160 538.312
R1986 VSS.n12296 VSS.t4159 538.312
R1987 VSS.n12272 VSS.t4158 538.312
R1988 VSS.n12142 VSS.t4156 538.312
R1989 VSS.t4119 VSS.n12145 538.312
R1990 VSS.n12224 VSS.t4155 538.312
R1991 VSS.n12204 VSS.t4154 538.312
R1992 VSS.t4151 VSS.n12843 538.312
R1993 VSS.n12897 VSS.t4185 538.312
R1994 VSS.t4152 VSS.n12856 538.312
R1995 VSS.n12874 VSS.t4186 538.312
R1996 VSS.n13541 VSS.t4187 538.312
R1997 VSS.t4191 VSS.n1287 538.312
R1998 VSS.t4196 VSS.n1337 538.312
R1999 VSS.t4201 VSS.n1387 538.312
R2000 VSS.t4206 VSS.n1437 538.312
R2001 VSS.t4211 VSS.n1487 538.312
R2002 VSS.t4216 VSS.n1537 538.312
R2003 VSS.n1557 VSS.t4254 538.312
R2004 VSS.n12965 VSS.t4253 538.312
R2005 VSS.n13000 VSS.t4251 538.312
R2006 VSS.n13010 VSS.t4214 538.312
R2007 VSS.t4250 VSS.n1519 538.312
R2008 VSS.n1507 VSS.t4249 538.312
R2009 VSS.n13066 VSS.t4248 538.312
R2010 VSS.n13101 VSS.t4246 538.312
R2011 VSS.n13111 VSS.t4209 538.312
R2012 VSS.t4245 VSS.n1469 538.312
R2013 VSS.n1457 VSS.t4244 538.312
R2014 VSS.n13167 VSS.t4243 538.312
R2015 VSS.n13202 VSS.t4241 538.312
R2016 VSS.n13212 VSS.t4204 538.312
R2017 VSS.t4240 VSS.n1419 538.312
R2018 VSS.n1407 VSS.t4239 538.312
R2019 VSS.n13268 VSS.t4238 538.312
R2020 VSS.n13303 VSS.t4236 538.312
R2021 VSS.n13313 VSS.t4199 538.312
R2022 VSS.t4235 VSS.n1369 538.312
R2023 VSS.n1357 VSS.t4234 538.312
R2024 VSS.n13369 VSS.t4233 538.312
R2025 VSS.n13404 VSS.t4231 538.312
R2026 VSS.n13414 VSS.t4194 538.312
R2027 VSS.t4230 VSS.n1319 538.312
R2028 VSS.n1307 VSS.t4229 538.312
R2029 VSS.n13470 VSS.t4228 538.312
R2030 VSS.n13498 VSS.t4226 538.312
R2031 VSS.n1273 VSS.t4189 538.312
R2032 VSS.n13573 VSS.t4225 538.312
R2033 VSS.n13553 VSS.t4224 538.312
R2034 VSS.t4221 VSS.n1580 538.312
R2035 VSS.t4255 VSS.n1578 538.312
R2036 VSS.t4222 VSS.n1594 538.312
R2037 VSS.t4256 VSS.n1592 538.312
R2038 VSS.n14506 VSS.t4257 538.312
R2039 VSS.t4261 VSS.n13602 538.312
R2040 VSS.t4276 VSS.n14192 538.312
R2041 VSS.t4280 VSS.n13769 538.312
R2042 VSS.t4285 VSS.n13819 538.312
R2043 VSS.n13839 VSS.t4318 538.312
R2044 VSS.n13974 VSS.t4317 538.312
R2045 VSS.n14009 VSS.t4315 538.312
R2046 VSS.n14019 VSS.t4283 538.312
R2047 VSS.t4314 VSS.n13801 538.312
R2048 VSS.n13789 VSS.t4313 538.312
R2049 VSS.n14075 VSS.t4312 538.312
R2050 VSS.n14110 VSS.t4310 538.312
R2051 VSS.n14120 VSS.t4278 538.312
R2052 VSS.t4309 VSS.n13751 538.312
R2053 VSS.n14205 VSS.t4308 538.312
R2054 VSS.t4275 VSS.n14171 538.312
R2055 VSS.t4305 VSS.n13736 538.312
R2056 VSS.n14275 VSS.t4271 538.312
R2057 VSS.n14305 VSS.t4270 538.312
R2058 VSS.n14327 VSS.t4267 538.312
R2059 VSS.t4301 VSS.n13652 538.312
R2060 VSS.n14369 VSS.t4300 538.312
R2061 VSS.n14379 VSS.t4264 538.312
R2062 VSS.t4299 VSS.n13634 538.312
R2063 VSS.n13622 VSS.t4298 538.312
R2064 VSS.n14435 VSS.t4297 538.312
R2065 VSS.n14463 VSS.t4295 538.312
R2066 VSS.n13588 VSS.t4259 538.312
R2067 VSS.n14538 VSS.t4294 538.312
R2068 VSS.n14518 VSS.t4293 538.312
R2069 VSS.t4290 VSS.n13862 538.312
R2070 VSS.t4319 VSS.n13860 538.312
R2071 VSS.t4291 VSS.n13876 538.312
R2072 VSS.t4320 VSS.n13874 538.312
R2073 VSS.n14589 VSS.t4321 538.312
R2074 VSS.t4325 VSS.n14661 538.312
R2075 VSS.n399 VSS.t4353 538.312
R2076 VSS.t4328 VSS.n403 538.312
R2077 VSS.n417 VSS.t4352 538.312
R2078 VSS.t4327 VSS.n421 538.312
R2079 VSS.n14698 VSS.t4351 538.312
R2080 VSS.n14674 VSS.t4350 538.312
R2081 VSS.n456 VSS.t4348 538.312
R2082 VSS.n14552 VSS.t4323 538.312
R2083 VSS.n14621 VSS.t4347 538.312
R2084 VSS.n14601 VSS.t4346 538.312
R2085 VSS.n14988 VSS.t4335 538.312
R2086 VSS.n14990 VSS.t4362 538.312
R2087 VSS.t4334 VSS.n14959 538.312
R2088 VSS.n14962 VSS.t4361 538.312
R2089 VSS.n14935 VSS.t4360 538.312
R2090 VSS.n15119 VSS.t4339 538.312
R2091 VSS.n15231 VSS.t4341 538.312
R2092 VSS.t4343 VSS.n15158 538.312
R2093 VSS.t4363 VSS.n15156 538.312
R2094 VSS.t4344 VSS.n15172 538.312
R2095 VSS.t4364 VSS.n15170 538.312
R2096 VSS.n268 VSS.t4400 538.312
R2097 VSS.n2895 VSS.t3482 538.312
R2098 VSS.n15354 VSS.t3483 538.312
R2099 VSS.t3484 VSS.n15279 538.312
R2100 VSS.t3485 VSS.n15289 538.312
R2101 VSS.n2569 VSS.t3444 538.312
R2102 VSS.t3447 VSS.n2535 538.312
R2103 VSS.n2591 VSS.t3446 538.312
R2104 VSS.n2665 VSS.t3450 538.312
R2105 VSS.n2640 VSS.t3449 538.312
R2106 VSS.n3385 VSS.t3453 538.312
R2107 VSS.n3408 VSS.t3452 538.312
R2108 VSS.n3333 VSS.t3456 538.312
R2109 VSS.n3356 VSS.t3455 538.312
R2110 VSS.n3281 VSS.t3459 538.312
R2111 VSS.n3304 VSS.t3458 538.312
R2112 VSS.n3229 VSS.t3462 538.312
R2113 VSS.n3252 VSS.t3461 538.312
R2114 VSS.n3177 VSS.t3465 538.312
R2115 VSS.n3200 VSS.t3464 538.312
R2116 VSS.n3125 VSS.t3468 538.312
R2117 VSS.n3148 VSS.t3467 538.312
R2118 VSS.n3073 VSS.t3471 538.312
R2119 VSS.n3096 VSS.t3470 538.312
R2120 VSS.n3021 VSS.t3474 538.312
R2121 VSS.n3044 VSS.t3473 538.312
R2122 VSS.n2969 VSS.t3477 538.312
R2123 VSS.n2992 VSS.t3476 538.312
R2124 VSS.n2917 VSS.t3480 538.312
R2125 VSS.n2940 VSS.t3479 538.312
R2126 VSS.t34 VSS.t139 531.034
R2127 VSS.t229 VSS.t3266 522.606
R2128 VSS.t13 VSS.t3335 522.606
R2129 VSS.t216 VSS.t269 514.177
R2130 VSS.t172 VSS.t3436 514.177
R2131 VSS.n1106 VSS.t40 505.853
R2132 VSS.t99 VSS.t3379 505.748
R2133 VSS.t3334 VSS.t475 505.748
R2134 VSS.n15040 VSS.t155 505.748
R2135 VSS.t208 VSS.t3437 505.748
R2136 VSS.t513 VSS.t106 505.748
R2137 VSS.n14276 VSS.n13714 497.865
R2138 VSS.t475 VSS.t9 497.318
R2139 VSS.n990 VSS.t331 496.601
R2140 VSS.n991 VSS.t343 496.601
R2141 VSS.t3288 VSS.t37 480.461
R2142 VSS.t3337 VSS.t13 480.461
R2143 VSS.t3295 VSS.t38 472.031
R2144 VSS.t51 VSS.t3261 472.031
R2145 VSS.t17 VSS.t3370 472.031
R2146 VSS.t3429 VSS.t3352 463.603
R2147 VSS.t3276 VSS.t361 462.671
R2148 VSS.t42 VSS.t480 455.173
R2149 VSS.t3256 VSS.t258 446.743
R2150 VSS.t3407 VSS.t45 446.743
R2151 VSS.t3387 VSS.t3275 446.743
R2152 VSS.t11 VSS.t3392 446.743
R2153 VSS.t198 VSS.t228 438.315
R2154 VSS.t179 VSS.t202 438.315
R2155 VSS.t3418 VSS.t49 438.315
R2156 VSS.t3390 VSS.t218 438.315
R2157 VSS.t119 VSS.t58 438.315
R2158 VSS.t3322 VSS.t3435 431.827
R2159 VSS.t3374 VSS.t358 430.284
R2160 VSS.t3371 VSS.t295 428.743
R2161 VSS.t3292 VSS.t373 428.743
R2162 VSS.t265 VSS.n13739 404.599
R2163 VSS.n14314 VSS.t267 404.599
R2164 VSS.t3379 VSS.t252 404.599
R2165 VSS.t111 VSS.t3268 404.599
R2166 VSS.t3317 VSS.t3331 397.897
R2167 VSS.t228 VSS.t122 396.17
R2168 VSS.t49 VSS.t253 396.17
R2169 VSS.t218 VSS.t33 396.17
R2170 VSS.t472 VSS.n15222 387.74
R2171 VSS.n15136 VSS.t486 387.74
R2172 VSS.t133 VSS.t3256 387.74
R2173 VSS.t3392 VSS.t3273 387.74
R2174 VSS.t3422 VSS.t3407 379.31
R2175 VSS.n14563 VSS.t103 370.882
R2176 VSS.t292 VSS.t64 363.969
R2177 VSS.t139 VSS.t3391 362.452
R2178 VSS.t3391 VSS.t119 362.452
R2179 VSS.t361 VSS.n559 354.714
R2180 VSS.t373 VSS.n1256 354.714
R2181 VSS.t3406 VSS.t3422 345.594
R2182 VSS.t3352 VSS.t3251 337.166
R2183 VSS.t3254 VSS.t133 337.166
R2184 VSS.t105 VSS.n14563 337.166
R2185 VSS.t33 VSS.t216 320.307
R2186 VSS.t122 VSS.t229 311.877
R2187 VSS.t3434 VSS.t4 293.026
R2188 VSS.t3367 VSS.t3368 289.94
R2189 VSS.t219 VSS.t3390 286.591
R2190 VSS.t58 VSS.t117 286.591
R2191 VSS.n666 VSS.t289 283.772
R2192 VSS.n666 VSS.t292 283.772
R2193 VSS.t307 VSS.n664 283.772
R2194 VSS.n878 VSS.t316 283.772
R2195 VSS.n879 VSS.t325 283.772
R2196 VSS.n991 VSS.t340 283.772
R2197 VSS.n1106 VSS.t355 283.772
R2198 VSS.n1256 VSS.t370 283.772
R2199 VSS.t388 VSS.t391 283.772
R2200 VSS.t258 VSS.t3258 278.161
R2201 VSS.t226 VSS.t198 269.733
R2202 VSS.t706 VSS.t3342 269.733
R2203 VSS.t45 VSS.t3409 269.733
R2204 VSS.t3275 VSS.t3386 269.733
R2205 VSS.t480 VSS.t180 252.875
R2206 VSS.t3351 VSS.t3429 244.445
R2207 VSS.t3370 VSS.t51 236.016
R2208 VSS.t114 VSS.t17 236.016
R2209 VSS.t2916 VSS.n3700 229.053
R2210 VSS.t2931 VSS.n3650 229.053
R2211 VSS.t2946 VSS.n3600 229.053
R2212 VSS.t2961 VSS.n3550 229.053
R2213 VSS.t2976 VSS.n3500 229.053
R2214 VSS.n4390 VSS.t2991 229.053
R2215 VSS.n3770 VSS.t2896 229.053
R2216 VSS.n5731 VSS.t2701 229.053
R2217 VSS.n5625 VSS.t2716 229.053
R2218 VSS.n5519 VSS.t2731 229.053
R2219 VSS.n5413 VSS.t2746 229.053
R2220 VSS.n5307 VSS.t2761 229.053
R2221 VSS.n5201 VSS.t2776 229.053
R2222 VSS.t2486 VSS.n4723 229.053
R2223 VSS.t2501 VSS.n4673 229.053
R2224 VSS.t2516 VSS.n4623 229.053
R2225 VSS.t2531 VSS.n4573 229.053
R2226 VSS.t2546 VSS.n4523 229.053
R2227 VSS.n6471 VSS.t2561 229.053
R2228 VSS.t2271 VSS.n6804 229.053
R2229 VSS.t2286 VSS.n6754 229.053
R2230 VSS.t2301 VSS.n6704 229.053
R2231 VSS.t2316 VSS.n6654 229.053
R2232 VSS.t2331 VSS.n6604 229.053
R2233 VSS.n7513 VSS.t2346 229.053
R2234 VSS.n8213 VSS.t2056 229.053
R2235 VSS.n8107 VSS.t2071 229.053
R2236 VSS.n8001 VSS.t2086 229.053
R2237 VSS.n7895 VSS.t2101 229.053
R2238 VSS.n7789 VSS.t2116 229.053
R2239 VSS.n7683 VSS.t2131 229.053
R2240 VSS.n9251 VSS.t1841 229.053
R2241 VSS.n9145 VSS.t1856 229.053
R2242 VSS.n9039 VSS.t1871 229.053
R2243 VSS.n8933 VSS.t1886 229.053
R2244 VSS.n8827 VSS.t1901 229.053
R2245 VSS.n8721 VSS.t1916 229.053
R2246 VSS.t1623 VSS.n2170 229.053
R2247 VSS.t1638 VSS.n2120 229.053
R2248 VSS.t1653 VSS.n2070 229.053
R2249 VSS.t1668 VSS.n2020 229.053
R2250 VSS.t1683 VSS.n1970 229.053
R2251 VSS.n9991 VSS.t1698 229.053
R2252 VSS.n2240 VSS.t1603 229.053
R2253 VSS.t1408 VSS.n10324 229.053
R2254 VSS.t1423 VSS.n10274 229.053
R2255 VSS.t1438 VSS.n10224 229.053
R2256 VSS.t1453 VSS.n10174 229.053
R2257 VSS.t1468 VSS.n10124 229.053
R2258 VSS.n11033 VSS.t1483 229.053
R2259 VSS.n11733 VSS.t1193 229.053
R2260 VSS.n11627 VSS.t1208 229.053
R2261 VSS.n11521 VSS.t1223 229.053
R2262 VSS.n11415 VSS.t1238 229.053
R2263 VSS.n11309 VSS.t1253 229.053
R2264 VSS.n11203 VSS.t1268 229.053
R2265 VSS.n12771 VSS.t978 229.053
R2266 VSS.n12665 VSS.t993 229.053
R2267 VSS.n12559 VSS.t1008 229.053
R2268 VSS.n12453 VSS.t1023 229.053
R2269 VSS.n12347 VSS.t1038 229.053
R2270 VSS.n12241 VSS.t1053 229.053
R2271 VSS.t763 VSS.n1529 229.053
R2272 VSS.t778 VSS.n1479 229.053
R2273 VSS.t793 VSS.n1429 229.053
R2274 VSS.t808 VSS.n1379 229.053
R2275 VSS.t823 VSS.n1329 229.053
R2276 VSS.n13511 VSS.t838 229.053
R2277 VSS.t568 VSS.n13811 229.053
R2278 VSS.t583 VSS.n13761 229.053
R2279 VSS.n14223 VSS.t598 229.053
R2280 VSS.t613 VSS.n13644 229.053
R2281 VSS.n14476 VSS.t628 229.053
R2282 VSS.n14643 VSS.t458 229.053
R2283 VSS.t37 VSS.t3287 227.587
R2284 VSS.t88 VSS.t3288 227.587
R2285 VSS.n14179 VSS.n14157 225.964
R2286 VSS.n4429 VSS.n4428 224.643
R2287 VSS.n4356 VSS.n3459 224.643
R2288 VSS.n4255 VSS.n3509 224.643
R2289 VSS.n4154 VSS.n3559 224.643
R2290 VSS.n4053 VSS.n3609 224.643
R2291 VSS.n3952 VSS.n3659 224.643
R2292 VSS.n3851 VSS.n3709 224.643
R2293 VSS.n5161 VSS.n5160 224.643
R2294 VSS.n5228 VSS.n5089 224.643
R2295 VSS.n5334 VSS.n5047 224.643
R2296 VSS.n5440 VSS.n5005 224.643
R2297 VSS.n5546 VSS.n4963 224.643
R2298 VSS.n5652 VSS.n4921 224.643
R2299 VSS.n5758 VSS.n4879 224.643
R2300 VSS.n6510 VSS.n6509 224.643
R2301 VSS.n6437 VSS.n4482 224.643
R2302 VSS.n6336 VSS.n4532 224.643
R2303 VSS.n6235 VSS.n4582 224.643
R2304 VSS.n6134 VSS.n4632 224.643
R2305 VSS.n6033 VSS.n4682 224.643
R2306 VSS.n5932 VSS.n4732 224.643
R2307 VSS.n7552 VSS.n7551 224.643
R2308 VSS.n7479 VSS.n6563 224.643
R2309 VSS.n7378 VSS.n6613 224.643
R2310 VSS.n7277 VSS.n6663 224.643
R2311 VSS.n7176 VSS.n6713 224.643
R2312 VSS.n7075 VSS.n6763 224.643
R2313 VSS.n6974 VSS.n6813 224.643
R2314 VSS.n7638 VSS.n7637 224.643
R2315 VSS.n7710 VSS.n2517 224.643
R2316 VSS.n7816 VSS.n2475 224.643
R2317 VSS.n7922 VSS.n2433 224.643
R2318 VSS.n8028 VSS.n2391 224.643
R2319 VSS.n8134 VSS.n2349 224.643
R2320 VSS.n8240 VSS.n2307 224.643
R2321 VSS.n8681 VSS.n8680 224.643
R2322 VSS.n8748 VSS.n8609 224.643
R2323 VSS.n8854 VSS.n8567 224.643
R2324 VSS.n8960 VSS.n8525 224.643
R2325 VSS.n9066 VSS.n8483 224.643
R2326 VSS.n9172 VSS.n8441 224.643
R2327 VSS.n9278 VSS.n8399 224.643
R2328 VSS.n10030 VSS.n10029 224.643
R2329 VSS.n9957 VSS.n1929 224.643
R2330 VSS.n9856 VSS.n1979 224.643
R2331 VSS.n9755 VSS.n2029 224.643
R2332 VSS.n9654 VSS.n2079 224.643
R2333 VSS.n9553 VSS.n2129 224.643
R2334 VSS.n9452 VSS.n2179 224.643
R2335 VSS.n11072 VSS.n11071 224.643
R2336 VSS.n10999 VSS.n10083 224.643
R2337 VSS.n10898 VSS.n10133 224.643
R2338 VSS.n10797 VSS.n10183 224.643
R2339 VSS.n10696 VSS.n10233 224.643
R2340 VSS.n10595 VSS.n10283 224.643
R2341 VSS.n10494 VSS.n10333 224.643
R2342 VSS.n11158 VSS.n11157 224.643
R2343 VSS.n11230 VSS.n1895 224.643
R2344 VSS.n11336 VSS.n1853 224.643
R2345 VSS.n11442 VSS.n1811 224.643
R2346 VSS.n11548 VSS.n1769 224.643
R2347 VSS.n11654 VSS.n1727 224.643
R2348 VSS.n11760 VSS.n1685 224.643
R2349 VSS.n12201 VSS.n12200 224.643
R2350 VSS.n12268 VSS.n12129 224.643
R2351 VSS.n12374 VSS.n12087 224.643
R2352 VSS.n12480 VSS.n12045 224.643
R2353 VSS.n12586 VSS.n12003 224.643
R2354 VSS.n12692 VSS.n11961 224.643
R2355 VSS.n12798 VSS.n11919 224.643
R2356 VSS.n13550 VSS.n13549 224.643
R2357 VSS.n13477 VSS.n1288 224.643
R2358 VSS.n13376 VSS.n1338 224.643
R2359 VSS.n13275 VSS.n1388 224.643
R2360 VSS.n13174 VSS.n1438 224.643
R2361 VSS.n13073 VSS.n1488 224.643
R2362 VSS.n12972 VSS.n1538 224.643
R2363 VSS.n14515 VSS.n14514 224.643
R2364 VSS.n14442 VSS.n13603 224.643
R2365 VSS.n14201 VSS.n14149 224.643
R2366 VSS.n14082 VSS.n13770 224.643
R2367 VSS.n13981 VSS.n13820 224.643
R2368 VSS.n14598 VSS.n14597 224.643
R2369 VSS.n14670 VSS.n443 224.643
R2370 VSS.n15040 VSS.t124 219.157
R2371 VSS.t3437 VSS.t210 219.157
R2372 VSS.n1265 VSS.n462 214.956
R2373 VSS.n507 VSS.n506 214.956
R2374 VSS.n1014 VSS.n1013 214.956
R2375 VSS.n1099 VSS.n1098 214.956
R2376 VSS.n1077 VSS.n1076 214.956
R2377 VSS.n1151 VSS.n1150 214.956
R2378 VSS.n1174 VSS.n1173 214.956
R2379 VSS.n1240 VSS.n1239 214.956
R2380 VSS.n984 VSS.n983 214.956
R2381 VSS.n962 VSS.n961 214.956
R2382 VSS.n15250 VSS.n15249 214.956
R2383 VSS.n650 VSS.n649 214.956
R2384 VSS.n712 VSS.n711 214.956
R2385 VSS.n735 VSS.n734 214.956
R2386 VSS.n764 VSS.n763 214.956
R2387 VSS.n872 VSS.n871 214.956
R2388 VSS.n850 VSS.n849 214.956
R2389 VSS.n3817 VSS.n3816 214.956
R2390 VSS.n3836 VSS.n3835 214.956
R2391 VSS.n3899 VSS.n3691 214.956
R2392 VSS.n3918 VSS.n3917 214.956
R2393 VSS.n3937 VSS.n3936 214.956
R2394 VSS.n4000 VSS.n3641 214.956
R2395 VSS.n4019 VSS.n4018 214.956
R2396 VSS.n4038 VSS.n4037 214.956
R2397 VSS.n4101 VSS.n3591 214.956
R2398 VSS.n4120 VSS.n4119 214.956
R2399 VSS.n4139 VSS.n4138 214.956
R2400 VSS.n4202 VSS.n3541 214.956
R2401 VSS.n4221 VSS.n4220 214.956
R2402 VSS.n4240 VSS.n4239 214.956
R2403 VSS.n4303 VSS.n3491 214.956
R2404 VSS.n4322 VSS.n4321 214.956
R2405 VSS.n4341 VSS.n4340 214.956
R2406 VSS.n4458 VSS.n4457 214.956
R2407 VSS.n4443 VSS.n4442 214.956
R2408 VSS.n3760 VSS.n3754 214.956
R2409 VSS.n5791 VSS.n5790 214.956
R2410 VSS.n5765 VSS.n4875 214.956
R2411 VSS.n5714 VSS.n5713 214.956
R2412 VSS.n5691 VSS.n5690 214.956
R2413 VSS.n5659 VSS.n4917 214.956
R2414 VSS.n5608 VSS.n5607 214.956
R2415 VSS.n5585 VSS.n5584 214.956
R2416 VSS.n5553 VSS.n4959 214.956
R2417 VSS.n5502 VSS.n5501 214.956
R2418 VSS.n5479 VSS.n5478 214.956
R2419 VSS.n5447 VSS.n5001 214.956
R2420 VSS.n5396 VSS.n5395 214.956
R2421 VSS.n5373 VSS.n5372 214.956
R2422 VSS.n5341 VSS.n5043 214.956
R2423 VSS.n5290 VSS.n5289 214.956
R2424 VSS.n5267 VSS.n5266 214.956
R2425 VSS.n5235 VSS.n5085 214.956
R2426 VSS.n5190 VSS.n5189 214.956
R2427 VSS.n5175 VSS.n5174 214.956
R2428 VSS.n5849 VSS.n5811 214.956
R2429 VSS.n5849 VSS.n5848 214.956
R2430 VSS.n5826 VSS.n5824 214.956
R2431 VSS.n5826 VSS.n5825 214.956
R2432 VSS.n5898 VSS.n5897 214.956
R2433 VSS.n5917 VSS.n5916 214.956
R2434 VSS.n5980 VSS.n4714 214.956
R2435 VSS.n5999 VSS.n5998 214.956
R2436 VSS.n6018 VSS.n6017 214.956
R2437 VSS.n6081 VSS.n4664 214.956
R2438 VSS.n6100 VSS.n6099 214.956
R2439 VSS.n6119 VSS.n6118 214.956
R2440 VSS.n6182 VSS.n4614 214.956
R2441 VSS.n6201 VSS.n6200 214.956
R2442 VSS.n6220 VSS.n6219 214.956
R2443 VSS.n6283 VSS.n4564 214.956
R2444 VSS.n6302 VSS.n6301 214.956
R2445 VSS.n6321 VSS.n6320 214.956
R2446 VSS.n6384 VSS.n4514 214.956
R2447 VSS.n6403 VSS.n6402 214.956
R2448 VSS.n6422 VSS.n6421 214.956
R2449 VSS.n6539 VSS.n6538 214.956
R2450 VSS.n6524 VSS.n6523 214.956
R2451 VSS.n4776 VSS.n4773 214.956
R2452 VSS.n4818 VSS.n4773 214.956
R2453 VSS.n4790 VSS.n4787 214.956
R2454 VSS.n4796 VSS.n4787 214.956
R2455 VSS.n6940 VSS.n6939 214.956
R2456 VSS.n6959 VSS.n6958 214.956
R2457 VSS.n7022 VSS.n6795 214.956
R2458 VSS.n7041 VSS.n7040 214.956
R2459 VSS.n7060 VSS.n7059 214.956
R2460 VSS.n7123 VSS.n6745 214.956
R2461 VSS.n7142 VSS.n7141 214.956
R2462 VSS.n7161 VSS.n7160 214.956
R2463 VSS.n7224 VSS.n6695 214.956
R2464 VSS.n7243 VSS.n7242 214.956
R2465 VSS.n7262 VSS.n7261 214.956
R2466 VSS.n7325 VSS.n6645 214.956
R2467 VSS.n7344 VSS.n7343 214.956
R2468 VSS.n7363 VSS.n7362 214.956
R2469 VSS.n7426 VSS.n6595 214.956
R2470 VSS.n7445 VSS.n7444 214.956
R2471 VSS.n7464 VSS.n7463 214.956
R2472 VSS.n7581 VSS.n7580 214.956
R2473 VSS.n7566 VSS.n7565 214.956
R2474 VSS.n6857 VSS.n6854 214.956
R2475 VSS.n6899 VSS.n6854 214.956
R2476 VSS.n6871 VSS.n6868 214.956
R2477 VSS.n6877 VSS.n6868 214.956
R2478 VSS.n8273 VSS.n8272 214.956
R2479 VSS.n8247 VSS.n2303 214.956
R2480 VSS.n8196 VSS.n8195 214.956
R2481 VSS.n8173 VSS.n8172 214.956
R2482 VSS.n8141 VSS.n2345 214.956
R2483 VSS.n8090 VSS.n8089 214.956
R2484 VSS.n8067 VSS.n8066 214.956
R2485 VSS.n8035 VSS.n2387 214.956
R2486 VSS.n7984 VSS.n7983 214.956
R2487 VSS.n7961 VSS.n7960 214.956
R2488 VSS.n7929 VSS.n2429 214.956
R2489 VSS.n7878 VSS.n7877 214.956
R2490 VSS.n7855 VSS.n7854 214.956
R2491 VSS.n7823 VSS.n2471 214.956
R2492 VSS.n7772 VSS.n7771 214.956
R2493 VSS.n7749 VSS.n7748 214.956
R2494 VSS.n7717 VSS.n2513 214.956
R2495 VSS.n7667 VSS.n7666 214.956
R2496 VSS.n7652 VSS.n7651 214.956
R2497 VSS.n8331 VSS.n8293 214.956
R2498 VSS.n8331 VSS.n8330 214.956
R2499 VSS.n8308 VSS.n8306 214.956
R2500 VSS.n8308 VSS.n8307 214.956
R2501 VSS.n9311 VSS.n9310 214.956
R2502 VSS.n9285 VSS.n8395 214.956
R2503 VSS.n9234 VSS.n9233 214.956
R2504 VSS.n9211 VSS.n9210 214.956
R2505 VSS.n9179 VSS.n8437 214.956
R2506 VSS.n9128 VSS.n9127 214.956
R2507 VSS.n9105 VSS.n9104 214.956
R2508 VSS.n9073 VSS.n8479 214.956
R2509 VSS.n9022 VSS.n9021 214.956
R2510 VSS.n8999 VSS.n8998 214.956
R2511 VSS.n8967 VSS.n8521 214.956
R2512 VSS.n8916 VSS.n8915 214.956
R2513 VSS.n8893 VSS.n8892 214.956
R2514 VSS.n8861 VSS.n8563 214.956
R2515 VSS.n8810 VSS.n8809 214.956
R2516 VSS.n8787 VSS.n8786 214.956
R2517 VSS.n8755 VSS.n8605 214.956
R2518 VSS.n8710 VSS.n8709 214.956
R2519 VSS.n8695 VSS.n8694 214.956
R2520 VSS.n9369 VSS.n9331 214.956
R2521 VSS.n9369 VSS.n9368 214.956
R2522 VSS.n9346 VSS.n9344 214.956
R2523 VSS.n9346 VSS.n9345 214.956
R2524 VSS.n9418 VSS.n9417 214.956
R2525 VSS.n9437 VSS.n9436 214.956
R2526 VSS.n9500 VSS.n2161 214.956
R2527 VSS.n9519 VSS.n9518 214.956
R2528 VSS.n9538 VSS.n9537 214.956
R2529 VSS.n9601 VSS.n2111 214.956
R2530 VSS.n9620 VSS.n9619 214.956
R2531 VSS.n9639 VSS.n9638 214.956
R2532 VSS.n9702 VSS.n2061 214.956
R2533 VSS.n9721 VSS.n9720 214.956
R2534 VSS.n9740 VSS.n9739 214.956
R2535 VSS.n9803 VSS.n2011 214.956
R2536 VSS.n9822 VSS.n9821 214.956
R2537 VSS.n9841 VSS.n9840 214.956
R2538 VSS.n9904 VSS.n1961 214.956
R2539 VSS.n9923 VSS.n9922 214.956
R2540 VSS.n9942 VSS.n9941 214.956
R2541 VSS.n10059 VSS.n10058 214.956
R2542 VSS.n10044 VSS.n10043 214.956
R2543 VSS.n2230 VSS.n2224 214.956
R2544 VSS.n10460 VSS.n10459 214.956
R2545 VSS.n10479 VSS.n10478 214.956
R2546 VSS.n10542 VSS.n10315 214.956
R2547 VSS.n10561 VSS.n10560 214.956
R2548 VSS.n10580 VSS.n10579 214.956
R2549 VSS.n10643 VSS.n10265 214.956
R2550 VSS.n10662 VSS.n10661 214.956
R2551 VSS.n10681 VSS.n10680 214.956
R2552 VSS.n10744 VSS.n10215 214.956
R2553 VSS.n10763 VSS.n10762 214.956
R2554 VSS.n10782 VSS.n10781 214.956
R2555 VSS.n10845 VSS.n10165 214.956
R2556 VSS.n10864 VSS.n10863 214.956
R2557 VSS.n10883 VSS.n10882 214.956
R2558 VSS.n10946 VSS.n10115 214.956
R2559 VSS.n10965 VSS.n10964 214.956
R2560 VSS.n10984 VSS.n10983 214.956
R2561 VSS.n11101 VSS.n11100 214.956
R2562 VSS.n11086 VSS.n11085 214.956
R2563 VSS.n10377 VSS.n10374 214.956
R2564 VSS.n10419 VSS.n10374 214.956
R2565 VSS.n10391 VSS.n10388 214.956
R2566 VSS.n10397 VSS.n10388 214.956
R2567 VSS.n11793 VSS.n11792 214.956
R2568 VSS.n11767 VSS.n1681 214.956
R2569 VSS.n11716 VSS.n11715 214.956
R2570 VSS.n11693 VSS.n11692 214.956
R2571 VSS.n11661 VSS.n1723 214.956
R2572 VSS.n11610 VSS.n11609 214.956
R2573 VSS.n11587 VSS.n11586 214.956
R2574 VSS.n11555 VSS.n1765 214.956
R2575 VSS.n11504 VSS.n11503 214.956
R2576 VSS.n11481 VSS.n11480 214.956
R2577 VSS.n11449 VSS.n1807 214.956
R2578 VSS.n11398 VSS.n11397 214.956
R2579 VSS.n11375 VSS.n11374 214.956
R2580 VSS.n11343 VSS.n1849 214.956
R2581 VSS.n11292 VSS.n11291 214.956
R2582 VSS.n11269 VSS.n11268 214.956
R2583 VSS.n11237 VSS.n1891 214.956
R2584 VSS.n11187 VSS.n11186 214.956
R2585 VSS.n11172 VSS.n11171 214.956
R2586 VSS.n11851 VSS.n11813 214.956
R2587 VSS.n11851 VSS.n11850 214.956
R2588 VSS.n11828 VSS.n11826 214.956
R2589 VSS.n11828 VSS.n11827 214.956
R2590 VSS.n12831 VSS.n12830 214.956
R2591 VSS.n12805 VSS.n11915 214.956
R2592 VSS.n12754 VSS.n12753 214.956
R2593 VSS.n12731 VSS.n12730 214.956
R2594 VSS.n12699 VSS.n11957 214.956
R2595 VSS.n12648 VSS.n12647 214.956
R2596 VSS.n12625 VSS.n12624 214.956
R2597 VSS.n12593 VSS.n11999 214.956
R2598 VSS.n12542 VSS.n12541 214.956
R2599 VSS.n12519 VSS.n12518 214.956
R2600 VSS.n12487 VSS.n12041 214.956
R2601 VSS.n12436 VSS.n12435 214.956
R2602 VSS.n12413 VSS.n12412 214.956
R2603 VSS.n12381 VSS.n12083 214.956
R2604 VSS.n12330 VSS.n12329 214.956
R2605 VSS.n12307 VSS.n12306 214.956
R2606 VSS.n12275 VSS.n12125 214.956
R2607 VSS.n12230 VSS.n12229 214.956
R2608 VSS.n12215 VSS.n12214 214.956
R2609 VSS.n12889 VSS.n12851 214.956
R2610 VSS.n12889 VSS.n12888 214.956
R2611 VSS.n12866 VSS.n12864 214.956
R2612 VSS.n12866 VSS.n12865 214.956
R2613 VSS.n12938 VSS.n12937 214.956
R2614 VSS.n12957 VSS.n12956 214.956
R2615 VSS.n13020 VSS.n1520 214.956
R2616 VSS.n13039 VSS.n13038 214.956
R2617 VSS.n13058 VSS.n13057 214.956
R2618 VSS.n13121 VSS.n1470 214.956
R2619 VSS.n13140 VSS.n13139 214.956
R2620 VSS.n13159 VSS.n13158 214.956
R2621 VSS.n13222 VSS.n1420 214.956
R2622 VSS.n13241 VSS.n13240 214.956
R2623 VSS.n13260 VSS.n13259 214.956
R2624 VSS.n13323 VSS.n1370 214.956
R2625 VSS.n13342 VSS.n13341 214.956
R2626 VSS.n13361 VSS.n13360 214.956
R2627 VSS.n13424 VSS.n1320 214.956
R2628 VSS.n13443 VSS.n13442 214.956
R2629 VSS.n13462 VSS.n13461 214.956
R2630 VSS.n13579 VSS.n13578 214.956
R2631 VSS.n13564 VSS.n13563 214.956
R2632 VSS.n1582 VSS.n1579 214.956
R2633 VSS.n1624 VSS.n1579 214.956
R2634 VSS.n1596 VSS.n1593 214.956
R2635 VSS.n1602 VSS.n1593 214.956
R2636 VSS.n13947 VSS.n13946 214.956
R2637 VSS.n13966 VSS.n13965 214.956
R2638 VSS.n14029 VSS.n13802 214.956
R2639 VSS.n14048 VSS.n14047 214.956
R2640 VSS.n14067 VSS.n14066 214.956
R2641 VSS.n14130 VSS.n13752 214.956
R2642 VSS.n14209 VSS.n14208 214.956
R2643 VSS.n14268 VSS.n14267 214.956
R2644 VSS.n14297 VSS.n14296 214.956
R2645 VSS.n14319 VSS.n14318 214.956
R2646 VSS.n13656 VSS.n14341 214.956
R2647 VSS.n14389 VSS.n13635 214.956
R2648 VSS.n14408 VSS.n14407 214.956
R2649 VSS.n14427 VSS.n14426 214.956
R2650 VSS.n14544 VSS.n14543 214.956
R2651 VSS.n14529 VSS.n14528 214.956
R2652 VSS.n13864 VSS.n13861 214.956
R2653 VSS.n13906 VSS.n13861 214.956
R2654 VSS.n13878 VSS.n13875 214.956
R2655 VSS.n13884 VSS.n13875 214.956
R2656 VSS.n14746 VSS.n14745 214.956
R2657 VSS.n14728 VSS.n14727 214.956
R2658 VSS.n14709 VSS.n14708 214.956
R2659 VSS.n14677 VSS.n439 214.956
R2660 VSS.n14627 VSS.n14626 214.956
R2661 VSS.n14612 VSS.n14611 214.956
R2662 VSS.n14998 VSS.n321 214.956
R2663 VSS.n14998 VSS.n14997 214.956
R2664 VSS.n14973 VSS.n329 214.956
R2665 VSS.n14973 VSS.n14972 214.956
R2666 VSS.n14945 VSS.n14944 214.956
R2667 VSS.n14903 VSS.n14902 214.956
R2668 VSS.n15111 VSS.n15110 214.956
R2669 VSS.n15238 VSS.n15237 214.956
R2670 VSS.n15160 VSS.n15157 214.956
R2671 VSS.n15202 VSS.n15157 214.956
R2672 VSS.n15174 VSS.n15171 214.956
R2673 VSS.n15180 VSS.n15171 214.956
R2674 VSS.n260 VSS.n259 214.956
R2675 VSS.n2890 VSS.n2889 214.956
R2676 VSS.n15346 VSS.n15345 214.956
R2677 VSS.n15324 VSS.n15280 214.956
R2678 VSS.n15302 VSS.n15290 214.956
R2679 VSS.n2577 VSS.n2576 214.956
R2680 VSS.n3436 VSS.n2536 214.956
R2681 VSS.n2587 VSS.n2586 214.956
R2682 VSS.n2673 VSS.n2672 214.956
R2683 VSS.n2651 VSS.n2650 214.956
R2684 VSS.n3377 VSS.n3376 214.956
R2685 VSS.n3400 VSS.n3399 214.956
R2686 VSS.n3325 VSS.n3324 214.956
R2687 VSS.n3348 VSS.n3347 214.956
R2688 VSS.n3273 VSS.n3272 214.956
R2689 VSS.n3296 VSS.n3295 214.956
R2690 VSS.n3221 VSS.n3220 214.956
R2691 VSS.n3244 VSS.n3243 214.956
R2692 VSS.n3169 VSS.n3168 214.956
R2693 VSS.n3192 VSS.n3191 214.956
R2694 VSS.n3117 VSS.n3116 214.956
R2695 VSS.n3140 VSS.n3139 214.956
R2696 VSS.n3065 VSS.n3064 214.956
R2697 VSS.n3088 VSS.n3087 214.956
R2698 VSS.n3013 VSS.n3012 214.956
R2699 VSS.n3036 VSS.n3035 214.956
R2700 VSS.n2961 VSS.n2960 214.956
R2701 VSS.n2984 VSS.n2983 214.956
R2702 VSS.n2909 VSS.n2908 214.956
R2703 VSS.n2932 VSS.n2931 214.956
R2704 VSS.t273 VSS.t692 210.728
R2705 VSS.t269 VSS.t144 210.728
R2706 VSS.t3436 VSS.t174 210.728
R2707 VSS.t235 VSS.t208 202.299
R2708 VSS.t3244 VSS.t513 202.299
R2709 VSS.n491 VSS.n490 200.692
R2710 VSS.n697 VSS.n635 200.692
R2711 VSS.n791 VSS.n790 200.692
R2712 VSS.n886 VSS.n589 200.692
R2713 VSS.n14254 VSS.n13725 200.692
R2714 VSS.n14873 VSS.n14872 200.692
R2715 VSS.n15059 VSS.n15058 200.692
R2716 VSS.t3241 VSS.t3317 200.492
R2717 VSS.t141 VSS.t34 193.87
R2718 VSS.n472 VSS.t4366 190.399
R2719 VSS.n698 VSS.t4394 190.399
R2720 VSS.t4389 VSS.n597 190.399
R2721 VSS.n887 VSS.t4384 190.399
R2722 VSS.n14255 VSS.t4272 190.399
R2723 VSS.n362 VSS.t4331 190.399
R2724 VSS.n313 VSS.t4337 190.399
R2725 VSS.t77 VSS.t3381 185.441
R2726 VSS.t3335 VSS.t263 185.441
R2727 VSS.t3331 VSS.t3276 183.526
R2728 VSS.t3264 VSS.t3418 168.583
R2729 VSS.t78 VSS.t188 168.583
R2730 VSS.t3382 VSS.t3259 168.583
R2731 VSS.t3378 VSS.t3283 166.562
R2732 VSS.n4460 VSS.n3443 164.8
R2733 VSS.n4295 VSS.n4292 164.8
R2734 VSS.n4194 VSS.n4191 164.8
R2735 VSS.n4093 VSS.n4090 164.8
R2736 VSS.n3992 VSS.n3989 164.8
R2737 VSS.n3891 VSS.n3888 164.8
R2738 VSS.n5107 VSS.n5106 164.8
R2739 VSS.n5292 VSS.n5066 164.8
R2740 VSS.n5398 VSS.n5024 164.8
R2741 VSS.n5504 VSS.n4982 164.8
R2742 VSS.n5610 VSS.n4940 164.8
R2743 VSS.n5716 VSS.n4898 164.8
R2744 VSS.n6541 VSS.n4466 164.8
R2745 VSS.n6376 VSS.n6373 164.8
R2746 VSS.n6275 VSS.n6272 164.8
R2747 VSS.n6174 VSS.n6171 164.8
R2748 VSS.n6073 VSS.n6070 164.8
R2749 VSS.n5972 VSS.n5969 164.8
R2750 VSS.n7583 VSS.n6547 164.8
R2751 VSS.n7418 VSS.n7415 164.8
R2752 VSS.n7317 VSS.n7314 164.8
R2753 VSS.n7216 VSS.n7213 164.8
R2754 VSS.n7115 VSS.n7112 164.8
R2755 VSS.n7014 VSS.n7011 164.8
R2756 VSS.n7669 VSS.n7588 164.8
R2757 VSS.n7774 VSS.n2494 164.8
R2758 VSS.n7880 VSS.n2452 164.8
R2759 VSS.n7986 VSS.n2410 164.8
R2760 VSS.n8092 VSS.n2368 164.8
R2761 VSS.n8198 VSS.n2326 164.8
R2762 VSS.n8627 VSS.n8626 164.8
R2763 VSS.n8812 VSS.n8586 164.8
R2764 VSS.n8918 VSS.n8544 164.8
R2765 VSS.n9024 VSS.n8502 164.8
R2766 VSS.n9130 VSS.n8460 164.8
R2767 VSS.n9236 VSS.n8418 164.8
R2768 VSS.n10061 VSS.n1913 164.8
R2769 VSS.n9896 VSS.n9893 164.8
R2770 VSS.n9795 VSS.n9792 164.8
R2771 VSS.n9694 VSS.n9691 164.8
R2772 VSS.n9593 VSS.n9590 164.8
R2773 VSS.n9492 VSS.n9489 164.8
R2774 VSS.n11103 VSS.n10067 164.8
R2775 VSS.n10938 VSS.n10935 164.8
R2776 VSS.n10837 VSS.n10834 164.8
R2777 VSS.n10736 VSS.n10733 164.8
R2778 VSS.n10635 VSS.n10632 164.8
R2779 VSS.n10534 VSS.n10531 164.8
R2780 VSS.n11189 VSS.n11108 164.8
R2781 VSS.n11294 VSS.n1872 164.8
R2782 VSS.n11400 VSS.n1830 164.8
R2783 VSS.n11506 VSS.n1788 164.8
R2784 VSS.n11612 VSS.n1746 164.8
R2785 VSS.n11718 VSS.n1704 164.8
R2786 VSS.n12147 VSS.n12146 164.8
R2787 VSS.n12332 VSS.n12106 164.8
R2788 VSS.n12438 VSS.n12064 164.8
R2789 VSS.n12544 VSS.n12022 164.8
R2790 VSS.n12650 VSS.n11980 164.8
R2791 VSS.n12756 VSS.n11938 164.8
R2792 VSS.n13581 VSS.n1272 164.8
R2793 VSS.n13416 VSS.n13413 164.8
R2794 VSS.n13315 VSS.n13312 164.8
R2795 VSS.n13214 VSS.n13211 164.8
R2796 VSS.n13113 VSS.n13110 164.8
R2797 VSS.n13012 VSS.n13009 164.8
R2798 VSS.n14546 VSS.n13587 164.8
R2799 VSS.n14381 VSS.n14378 164.8
R2800 VSS.n14122 VSS.n14119 164.8
R2801 VSS.n14021 VSS.n14018 164.8
R2802 VSS.n14629 VSS.n14551 164.8
R2803 VSS.n426 VSS.n421 164.431
R2804 VSS.n408 VSS.n403 164.431
R2805 VSS.n3764 VSS.n3753 163.157
R2806 VSS.n2234 VSS.n2223 163.157
R2807 VSS.t60 VSS.t3302 160.154
R2808 VSS.n4459 VSS.n3444 156.554
R2809 VSS.n4294 VSS.n4293 156.554
R2810 VSS.n4193 VSS.n4192 156.554
R2811 VSS.n4092 VSS.n4091 156.554
R2812 VSS.n3991 VSS.n3990 156.554
R2813 VSS.n3890 VSS.n3889 156.554
R2814 VSS.n5111 VSS.n5105 156.554
R2815 VSS.n5291 VSS.n5067 156.554
R2816 VSS.n5397 VSS.n5025 156.554
R2817 VSS.n5503 VSS.n4983 156.554
R2818 VSS.n5609 VSS.n4941 156.554
R2819 VSS.n5715 VSS.n4899 156.554
R2820 VSS.n6540 VSS.n4467 156.554
R2821 VSS.n6375 VSS.n6374 156.554
R2822 VSS.n6274 VSS.n6273 156.554
R2823 VSS.n6173 VSS.n6172 156.554
R2824 VSS.n6072 VSS.n6071 156.554
R2825 VSS.n5971 VSS.n5970 156.554
R2826 VSS.n7582 VSS.n6548 156.554
R2827 VSS.n7417 VSS.n7416 156.554
R2828 VSS.n7316 VSS.n7315 156.554
R2829 VSS.n7215 VSS.n7214 156.554
R2830 VSS.n7114 VSS.n7113 156.554
R2831 VSS.n7013 VSS.n7012 156.554
R2832 VSS.n7668 VSS.n7589 156.554
R2833 VSS.n7773 VSS.n2495 156.554
R2834 VSS.n7879 VSS.n2453 156.554
R2835 VSS.n7985 VSS.n2411 156.554
R2836 VSS.n8091 VSS.n2369 156.554
R2837 VSS.n8197 VSS.n2327 156.554
R2838 VSS.n8631 VSS.n8625 156.554
R2839 VSS.n8811 VSS.n8587 156.554
R2840 VSS.n8917 VSS.n8545 156.554
R2841 VSS.n9023 VSS.n8503 156.554
R2842 VSS.n9129 VSS.n8461 156.554
R2843 VSS.n9235 VSS.n8419 156.554
R2844 VSS.n10060 VSS.n1914 156.554
R2845 VSS.n9895 VSS.n9894 156.554
R2846 VSS.n9794 VSS.n9793 156.554
R2847 VSS.n9693 VSS.n9692 156.554
R2848 VSS.n9592 VSS.n9591 156.554
R2849 VSS.n9491 VSS.n9490 156.554
R2850 VSS.n11102 VSS.n10068 156.554
R2851 VSS.n10937 VSS.n10936 156.554
R2852 VSS.n10836 VSS.n10835 156.554
R2853 VSS.n10735 VSS.n10734 156.554
R2854 VSS.n10634 VSS.n10633 156.554
R2855 VSS.n10533 VSS.n10532 156.554
R2856 VSS.n11188 VSS.n11109 156.554
R2857 VSS.n11293 VSS.n1873 156.554
R2858 VSS.n11399 VSS.n1831 156.554
R2859 VSS.n11505 VSS.n1789 156.554
R2860 VSS.n11611 VSS.n1747 156.554
R2861 VSS.n11717 VSS.n1705 156.554
R2862 VSS.n12151 VSS.n12145 156.554
R2863 VSS.n12331 VSS.n12107 156.554
R2864 VSS.n12437 VSS.n12065 156.554
R2865 VSS.n12543 VSS.n12023 156.554
R2866 VSS.n12649 VSS.n11981 156.554
R2867 VSS.n12755 VSS.n11939 156.554
R2868 VSS.n13580 VSS.n1273 156.554
R2869 VSS.n13415 VSS.n13414 156.554
R2870 VSS.n13314 VSS.n13313 156.554
R2871 VSS.n13213 VSS.n13212 156.554
R2872 VSS.n13112 VSS.n13111 156.554
R2873 VSS.n13011 VSS.n13010 156.554
R2874 VSS.n14545 VSS.n13588 156.554
R2875 VSS.n14380 VSS.n14379 156.554
R2876 VSS.n14121 VSS.n14120 156.554
R2877 VSS.n14020 VSS.n14019 156.554
R2878 VSS.n14628 VSS.n14552 156.554
R2879 VSS.n15289 VSS.n15287 152
R2880 VSS.n15305 VSS.n15304 152
R2881 VSS.n15302 VSS.n15301 152
R2882 VSS.n15279 VSS.n15277 152
R2883 VSS.n15327 VSS.n15326 152
R2884 VSS.n15324 VSS.n15323 152
R2885 VSS.n490 VSS.n489 152
R2886 VSS.n512 VSS.n511 152
R2887 VSS.n510 VSS.n509 152
R2888 VSS.n506 VSS.n505 152
R2889 VSS.n461 VSS.n459 152
R2890 VSS.n1268 VSS.n1267 152
R2891 VSS.n1265 VSS.n1264 152
R2892 VSS.n1233 VSS.n1232 152
R2893 VSS.n1231 VSS.n1207 152
R2894 VSS.n1239 VSS.n1238 152
R2895 VSS.n1183 VSS.n1182 152
R2896 VSS.n1181 VSS.n1180 152
R2897 VSS.n1173 VSS.n534 152
R2898 VSS.n1160 VSS.n1159 152
R2899 VSS.n1158 VSS.n1157 152
R2900 VSS.n1150 VSS.n543 152
R2901 VSS.n1066 VSS.n1065 152
R2902 VSS.n1068 VSS.n1067 152
R2903 VSS.n1076 VSS.n1075 152
R2904 VSS.n1092 VSS.n1091 152
R2905 VSS.n1090 VSS.n1038 152
R2906 VSS.n1098 VSS.n1097 152
R2907 VSS.n1023 VSS.n1022 152
R2908 VSS.n1021 VSS.n1020 152
R2909 VSS.n1013 VSS.n566 152
R2910 VSS.n951 VSS.n950 152
R2911 VSS.n953 VSS.n952 152
R2912 VSS.n961 VSS.n960 152
R2913 VSS.n977 VSS.n976 152
R2914 VSS.n975 VSS.n924 152
R2915 VSS.n983 VSS.n982 152
R2916 VSS.n886 VSS.n885 152
R2917 VSS.n839 VSS.n838 152
R2918 VSS.n841 VSS.n840 152
R2919 VSS.n849 VSS.n848 152
R2920 VSS.n865 VSS.n864 152
R2921 VSS.n863 VSS.n811 152
R2922 VSS.n871 VSS.n870 152
R2923 VSS.n792 VSS.n791 152
R2924 VSS.n773 VSS.n772 152
R2925 VSS.n771 VSS.n770 152
R2926 VSS.n763 VSS.n607 152
R2927 VSS.n744 VSS.n743 152
R2928 VSS.n742 VSS.n741 152
R2929 VSS.n734 VSS.n618 152
R2930 VSS.n721 VSS.n720 152
R2931 VSS.n719 VSS.n718 152
R2932 VSS.n711 VSS.n627 152
R2933 VSS.n697 VSS.n696 152
R2934 VSS.n53 VSS.n654 152
R2935 VSS.n653 VSS.n652 152
R2936 VSS.n649 VSS.n648 152
R2937 VSS.n15243 VSS.n15242 152
R2938 VSS.n15241 VSS.n300 152
R2939 VSS.n15249 VSS.n15248 152
R2940 VSS.n3763 VSS.n3762 152
R2941 VSS.n3760 VSS.n3759 152
R2942 VSS.n3751 VSS.n3748 152
R2943 VSS.n3773 VSS.n3772 152
R2944 VSS.n3770 VSS.n3769 152
R2945 VSS.n4432 VSS.n4431 152
R2946 VSS.n4434 VSS.n4433 152
R2947 VSS.n4442 VSS.n4441 152
R2948 VSS.n4421 VSS.n4420 152
R2949 VSS.n4419 VSS.n4403 152
R2950 VSS.n4428 VSS.n4427 152
R2951 VSS.n4452 VSS.n4451 152
R2952 VSS.n4454 VSS.n4453 152
R2953 VSS.n4457 VSS.n4456 152
R2954 VSS.n4378 VSS.n4377 152
R2955 VSS.n4388 VSS.n4387 152
R2956 VSS.n4391 VSS.n4390 152
R2957 VSS.n3458 VSS.n3456 152
R2958 VSS.n4359 VSS.n4358 152
R2959 VSS.n4356 VSS.n4355 152
R2960 VSS.n4350 VSS.n4349 152
R2961 VSS.n4348 VSS.n4347 152
R2962 VSS.n4340 VSS.n3464 152
R2963 VSS.n3478 VSS.n3472 152
R2964 VSS.n3479 VSS.n3473 152
R2965 VSS.n4323 VSS.n4322 152
R2966 VSS.n3490 VSS.n3488 152
R2967 VSS.n4306 VSS.n4305 152
R2968 VSS.n4303 VSS.n4302 152
R2969 VSS.n4284 VSS.n4283 152
R2970 VSS.n4282 VSS.n4281 152
R2971 VSS.n3500 VSS.n3497 152
R2972 VSS.n3508 VSS.n3506 152
R2973 VSS.n4258 VSS.n4257 152
R2974 VSS.n4255 VSS.n4254 152
R2975 VSS.n4249 VSS.n4248 152
R2976 VSS.n4247 VSS.n4246 152
R2977 VSS.n4239 VSS.n3514 152
R2978 VSS.n3528 VSS.n3522 152
R2979 VSS.n3529 VSS.n3523 152
R2980 VSS.n4222 VSS.n4221 152
R2981 VSS.n3540 VSS.n3538 152
R2982 VSS.n4205 VSS.n4204 152
R2983 VSS.n4202 VSS.n4201 152
R2984 VSS.n4183 VSS.n4182 152
R2985 VSS.n4181 VSS.n4180 152
R2986 VSS.n3550 VSS.n3547 152
R2987 VSS.n3558 VSS.n3556 152
R2988 VSS.n4157 VSS.n4156 152
R2989 VSS.n4154 VSS.n4153 152
R2990 VSS.n4148 VSS.n4147 152
R2991 VSS.n4146 VSS.n4145 152
R2992 VSS.n4138 VSS.n3564 152
R2993 VSS.n3578 VSS.n3572 152
R2994 VSS.n3579 VSS.n3573 152
R2995 VSS.n4121 VSS.n4120 152
R2996 VSS.n3590 VSS.n3588 152
R2997 VSS.n4104 VSS.n4103 152
R2998 VSS.n4101 VSS.n4100 152
R2999 VSS.n4082 VSS.n4081 152
R3000 VSS.n4080 VSS.n4079 152
R3001 VSS.n3600 VSS.n3597 152
R3002 VSS.n3608 VSS.n3606 152
R3003 VSS.n4056 VSS.n4055 152
R3004 VSS.n4053 VSS.n4052 152
R3005 VSS.n4047 VSS.n4046 152
R3006 VSS.n4045 VSS.n4044 152
R3007 VSS.n4037 VSS.n3614 152
R3008 VSS.n3628 VSS.n3622 152
R3009 VSS.n3629 VSS.n3623 152
R3010 VSS.n4020 VSS.n4019 152
R3011 VSS.n3640 VSS.n3638 152
R3012 VSS.n4003 VSS.n4002 152
R3013 VSS.n4000 VSS.n3999 152
R3014 VSS.n3981 VSS.n3980 152
R3015 VSS.n3979 VSS.n3978 152
R3016 VSS.n3650 VSS.n3647 152
R3017 VSS.n3658 VSS.n3656 152
R3018 VSS.n3955 VSS.n3954 152
R3019 VSS.n3952 VSS.n3951 152
R3020 VSS.n3946 VSS.n3945 152
R3021 VSS.n3944 VSS.n3943 152
R3022 VSS.n3936 VSS.n3664 152
R3023 VSS.n3678 VSS.n3672 152
R3024 VSS.n3679 VSS.n3673 152
R3025 VSS.n3919 VSS.n3918 152
R3026 VSS.n3690 VSS.n3688 152
R3027 VSS.n3902 VSS.n3901 152
R3028 VSS.n3899 VSS.n3898 152
R3029 VSS.n3880 VSS.n3879 152
R3030 VSS.n3878 VSS.n3877 152
R3031 VSS.n3700 VSS.n3697 152
R3032 VSS.n3708 VSS.n3706 152
R3033 VSS.n3854 VSS.n3853 152
R3034 VSS.n3851 VSS.n3850 152
R3035 VSS.n3845 VSS.n3844 152
R3036 VSS.n3843 VSS.n3842 152
R3037 VSS.n3835 VSS.n3714 152
R3038 VSS.n3728 VSS.n3722 152
R3039 VSS.n3729 VSS.n3723 152
R3040 VSS.n3818 VSS.n3817 152
R3041 VSS.n5835 VSS.n5834 152
R3042 VSS.n5833 VSS.n5832 152
R3043 VSS.n5825 VSS.n5820 152
R3044 VSS.n5835 VSS.n5816 152
R3045 VSS.n5832 VSS.n5819 152
R3046 VSS.n5824 VSS.n5820 152
R3047 VSS.n5858 VSS.n5857 152
R3048 VSS.n5856 VSS.n5855 152
R3049 VSS.n5848 VSS.n5807 152
R3050 VSS.n5858 VSS.n5803 152
R3051 VSS.n5855 VSS.n5806 152
R3052 VSS.n5811 VSS.n5807 152
R3053 VSS.n5164 VSS.n5163 152
R3054 VSS.n5166 VSS.n5165 152
R3055 VSS.n5174 VSS.n5173 152
R3056 VSS.n5153 VSS.n5152 152
R3057 VSS.n5151 VSS.n5135 152
R3058 VSS.n5160 VSS.n5159 152
R3059 VSS.n5185 VSS.n5184 152
R3060 VSS.n5183 VSS.n5113 152
R3061 VSS.n5189 VSS.n5188 152
R3062 VSS.n5103 VSS.n5102 152
R3063 VSS.n5199 VSS.n5198 152
R3064 VSS.n5202 VSS.n5201 152
R3065 VSS.n5219 VSS.n5218 152
R3066 VSS.n5222 VSS.n5221 152
R3067 VSS.n5090 VSS.n5089 152
R3068 VSS.n5232 VSS.n5231 152
R3069 VSS.n5233 VSS.n5087 152
R3070 VSS.n5236 VSS.n5235 152
R3071 VSS.n5256 VSS.n5255 152
R3072 VSS.n5258 VSS.n5257 152
R3073 VSS.n5266 VSS.n5265 152
R3074 VSS.n5280 VSS.n5279 152
R3075 VSS.n5282 VSS.n5281 152
R3076 VSS.n5289 VSS.n5288 152
R3077 VSS.n5061 VSS.n5060 152
R3078 VSS.n5305 VSS.n5304 152
R3079 VSS.n5308 VSS.n5307 152
R3080 VSS.n5325 VSS.n5324 152
R3081 VSS.n5328 VSS.n5327 152
R3082 VSS.n5048 VSS.n5047 152
R3083 VSS.n5338 VSS.n5337 152
R3084 VSS.n5339 VSS.n5045 152
R3085 VSS.n5342 VSS.n5341 152
R3086 VSS.n5362 VSS.n5361 152
R3087 VSS.n5364 VSS.n5363 152
R3088 VSS.n5372 VSS.n5371 152
R3089 VSS.n5386 VSS.n5385 152
R3090 VSS.n5388 VSS.n5387 152
R3091 VSS.n5395 VSS.n5394 152
R3092 VSS.n5019 VSS.n5018 152
R3093 VSS.n5411 VSS.n5410 152
R3094 VSS.n5414 VSS.n5413 152
R3095 VSS.n5431 VSS.n5430 152
R3096 VSS.n5434 VSS.n5433 152
R3097 VSS.n5006 VSS.n5005 152
R3098 VSS.n5444 VSS.n5443 152
R3099 VSS.n5445 VSS.n5003 152
R3100 VSS.n5448 VSS.n5447 152
R3101 VSS.n5468 VSS.n5467 152
R3102 VSS.n5470 VSS.n5469 152
R3103 VSS.n5478 VSS.n5477 152
R3104 VSS.n5492 VSS.n5491 152
R3105 VSS.n5494 VSS.n5493 152
R3106 VSS.n5501 VSS.n5500 152
R3107 VSS.n4977 VSS.n4976 152
R3108 VSS.n5517 VSS.n5516 152
R3109 VSS.n5520 VSS.n5519 152
R3110 VSS.n5537 VSS.n5536 152
R3111 VSS.n5540 VSS.n5539 152
R3112 VSS.n4964 VSS.n4963 152
R3113 VSS.n5550 VSS.n5549 152
R3114 VSS.n5551 VSS.n4961 152
R3115 VSS.n5554 VSS.n5553 152
R3116 VSS.n5574 VSS.n5573 152
R3117 VSS.n5576 VSS.n5575 152
R3118 VSS.n5584 VSS.n5583 152
R3119 VSS.n5598 VSS.n5597 152
R3120 VSS.n5600 VSS.n5599 152
R3121 VSS.n5607 VSS.n5606 152
R3122 VSS.n4935 VSS.n4934 152
R3123 VSS.n5623 VSS.n5622 152
R3124 VSS.n5626 VSS.n5625 152
R3125 VSS.n5643 VSS.n5642 152
R3126 VSS.n5646 VSS.n5645 152
R3127 VSS.n4922 VSS.n4921 152
R3128 VSS.n5656 VSS.n5655 152
R3129 VSS.n5657 VSS.n4919 152
R3130 VSS.n5660 VSS.n5659 152
R3131 VSS.n5680 VSS.n5679 152
R3132 VSS.n5682 VSS.n5681 152
R3133 VSS.n5690 VSS.n5689 152
R3134 VSS.n5704 VSS.n5703 152
R3135 VSS.n5706 VSS.n5705 152
R3136 VSS.n5713 VSS.n5712 152
R3137 VSS.n4893 VSS.n4892 152
R3138 VSS.n5729 VSS.n5728 152
R3139 VSS.n5732 VSS.n5731 152
R3140 VSS.n5749 VSS.n5748 152
R3141 VSS.n5752 VSS.n5751 152
R3142 VSS.n4880 VSS.n4879 152
R3143 VSS.n5762 VSS.n5761 152
R3144 VSS.n5763 VSS.n4877 152
R3145 VSS.n5766 VSS.n5765 152
R3146 VSS.n5787 VSS.n5786 152
R3147 VSS.n5788 VSS.n4849 152
R3148 VSS.n5790 VSS.n4850 152
R3149 VSS.n4786 VSS.n4783 152
R3150 VSS.n4799 VSS.n4798 152
R3151 VSS.n4796 VSS.n4795 152
R3152 VSS.n4788 VSS.n4783 152
R3153 VSS.n4799 VSS.n4784 152
R3154 VSS.n4795 VSS.n4790 152
R3155 VSS.n4772 VSS.n4769 152
R3156 VSS.n4821 VSS.n4820 152
R3157 VSS.n4818 VSS.n4817 152
R3158 VSS.n4774 VSS.n4769 152
R3159 VSS.n4821 VSS.n4770 152
R3160 VSS.n4817 VSS.n4776 152
R3161 VSS.n6513 VSS.n6512 152
R3162 VSS.n6515 VSS.n6514 152
R3163 VSS.n6523 VSS.n6522 152
R3164 VSS.n6502 VSS.n6501 152
R3165 VSS.n6500 VSS.n6484 152
R3166 VSS.n6509 VSS.n6508 152
R3167 VSS.n6533 VSS.n6532 152
R3168 VSS.n6535 VSS.n6534 152
R3169 VSS.n6538 VSS.n6537 152
R3170 VSS.n6459 VSS.n6458 152
R3171 VSS.n6469 VSS.n6468 152
R3172 VSS.n6472 VSS.n6471 152
R3173 VSS.n4481 VSS.n4479 152
R3174 VSS.n6440 VSS.n6439 152
R3175 VSS.n6437 VSS.n6436 152
R3176 VSS.n6431 VSS.n6430 152
R3177 VSS.n6429 VSS.n6428 152
R3178 VSS.n6421 VSS.n4487 152
R3179 VSS.n4501 VSS.n4495 152
R3180 VSS.n4502 VSS.n4496 152
R3181 VSS.n6404 VSS.n6403 152
R3182 VSS.n4513 VSS.n4511 152
R3183 VSS.n6387 VSS.n6386 152
R3184 VSS.n6384 VSS.n6383 152
R3185 VSS.n6365 VSS.n6364 152
R3186 VSS.n6363 VSS.n6362 152
R3187 VSS.n4523 VSS.n4520 152
R3188 VSS.n4531 VSS.n4529 152
R3189 VSS.n6339 VSS.n6338 152
R3190 VSS.n6336 VSS.n6335 152
R3191 VSS.n6330 VSS.n6329 152
R3192 VSS.n6328 VSS.n6327 152
R3193 VSS.n6320 VSS.n4537 152
R3194 VSS.n4551 VSS.n4545 152
R3195 VSS.n4552 VSS.n4546 152
R3196 VSS.n6303 VSS.n6302 152
R3197 VSS.n4563 VSS.n4561 152
R3198 VSS.n6286 VSS.n6285 152
R3199 VSS.n6283 VSS.n6282 152
R3200 VSS.n6264 VSS.n6263 152
R3201 VSS.n6262 VSS.n6261 152
R3202 VSS.n4573 VSS.n4570 152
R3203 VSS.n4581 VSS.n4579 152
R3204 VSS.n6238 VSS.n6237 152
R3205 VSS.n6235 VSS.n6234 152
R3206 VSS.n6229 VSS.n6228 152
R3207 VSS.n6227 VSS.n6226 152
R3208 VSS.n6219 VSS.n4587 152
R3209 VSS.n4601 VSS.n4595 152
R3210 VSS.n4602 VSS.n4596 152
R3211 VSS.n6202 VSS.n6201 152
R3212 VSS.n4613 VSS.n4611 152
R3213 VSS.n6185 VSS.n6184 152
R3214 VSS.n6182 VSS.n6181 152
R3215 VSS.n6163 VSS.n6162 152
R3216 VSS.n6161 VSS.n6160 152
R3217 VSS.n4623 VSS.n4620 152
R3218 VSS.n4631 VSS.n4629 152
R3219 VSS.n6137 VSS.n6136 152
R3220 VSS.n6134 VSS.n6133 152
R3221 VSS.n6128 VSS.n6127 152
R3222 VSS.n6126 VSS.n6125 152
R3223 VSS.n6118 VSS.n4637 152
R3224 VSS.n4651 VSS.n4645 152
R3225 VSS.n4652 VSS.n4646 152
R3226 VSS.n6101 VSS.n6100 152
R3227 VSS.n4663 VSS.n4661 152
R3228 VSS.n6084 VSS.n6083 152
R3229 VSS.n6081 VSS.n6080 152
R3230 VSS.n6062 VSS.n6061 152
R3231 VSS.n6060 VSS.n6059 152
R3232 VSS.n4673 VSS.n4670 152
R3233 VSS.n4681 VSS.n4679 152
R3234 VSS.n6036 VSS.n6035 152
R3235 VSS.n6033 VSS.n6032 152
R3236 VSS.n6027 VSS.n6026 152
R3237 VSS.n6025 VSS.n6024 152
R3238 VSS.n6017 VSS.n4687 152
R3239 VSS.n4701 VSS.n4695 152
R3240 VSS.n4702 VSS.n4696 152
R3241 VSS.n6000 VSS.n5999 152
R3242 VSS.n4713 VSS.n4711 152
R3243 VSS.n5983 VSS.n5982 152
R3244 VSS.n5980 VSS.n5979 152
R3245 VSS.n5961 VSS.n5960 152
R3246 VSS.n5959 VSS.n5958 152
R3247 VSS.n4723 VSS.n4720 152
R3248 VSS.n4731 VSS.n4729 152
R3249 VSS.n5935 VSS.n5934 152
R3250 VSS.n5932 VSS.n5931 152
R3251 VSS.n5926 VSS.n5925 152
R3252 VSS.n5924 VSS.n5923 152
R3253 VSS.n5916 VSS.n4737 152
R3254 VSS.n4751 VSS.n4745 152
R3255 VSS.n4752 VSS.n4746 152
R3256 VSS.n5899 VSS.n5898 152
R3257 VSS.n6867 VSS.n6864 152
R3258 VSS.n6880 VSS.n6879 152
R3259 VSS.n6877 VSS.n6876 152
R3260 VSS.n6869 VSS.n6864 152
R3261 VSS.n6880 VSS.n6865 152
R3262 VSS.n6876 VSS.n6871 152
R3263 VSS.n6853 VSS.n6850 152
R3264 VSS.n6902 VSS.n6901 152
R3265 VSS.n6899 VSS.n6898 152
R3266 VSS.n6855 VSS.n6850 152
R3267 VSS.n6902 VSS.n6851 152
R3268 VSS.n6898 VSS.n6857 152
R3269 VSS.n7555 VSS.n7554 152
R3270 VSS.n7557 VSS.n7556 152
R3271 VSS.n7565 VSS.n7564 152
R3272 VSS.n7544 VSS.n7543 152
R3273 VSS.n7542 VSS.n7526 152
R3274 VSS.n7551 VSS.n7550 152
R3275 VSS.n7575 VSS.n7574 152
R3276 VSS.n7577 VSS.n7576 152
R3277 VSS.n7580 VSS.n7579 152
R3278 VSS.n7501 VSS.n7500 152
R3279 VSS.n7511 VSS.n7510 152
R3280 VSS.n7514 VSS.n7513 152
R3281 VSS.n6562 VSS.n6560 152
R3282 VSS.n7482 VSS.n7481 152
R3283 VSS.n7479 VSS.n7478 152
R3284 VSS.n7473 VSS.n7472 152
R3285 VSS.n7471 VSS.n7470 152
R3286 VSS.n7463 VSS.n6568 152
R3287 VSS.n6582 VSS.n6576 152
R3288 VSS.n6583 VSS.n6577 152
R3289 VSS.n7446 VSS.n7445 152
R3290 VSS.n6594 VSS.n6592 152
R3291 VSS.n7429 VSS.n7428 152
R3292 VSS.n7426 VSS.n7425 152
R3293 VSS.n7407 VSS.n7406 152
R3294 VSS.n7405 VSS.n7404 152
R3295 VSS.n6604 VSS.n6601 152
R3296 VSS.n6612 VSS.n6610 152
R3297 VSS.n7381 VSS.n7380 152
R3298 VSS.n7378 VSS.n7377 152
R3299 VSS.n7372 VSS.n7371 152
R3300 VSS.n7370 VSS.n7369 152
R3301 VSS.n7362 VSS.n6618 152
R3302 VSS.n6632 VSS.n6626 152
R3303 VSS.n6633 VSS.n6627 152
R3304 VSS.n7345 VSS.n7344 152
R3305 VSS.n6644 VSS.n6642 152
R3306 VSS.n7328 VSS.n7327 152
R3307 VSS.n7325 VSS.n7324 152
R3308 VSS.n7306 VSS.n7305 152
R3309 VSS.n7304 VSS.n7303 152
R3310 VSS.n6654 VSS.n6651 152
R3311 VSS.n6662 VSS.n6660 152
R3312 VSS.n7280 VSS.n7279 152
R3313 VSS.n7277 VSS.n7276 152
R3314 VSS.n7271 VSS.n7270 152
R3315 VSS.n7269 VSS.n7268 152
R3316 VSS.n7261 VSS.n6668 152
R3317 VSS.n6682 VSS.n6676 152
R3318 VSS.n6683 VSS.n6677 152
R3319 VSS.n7244 VSS.n7243 152
R3320 VSS.n6694 VSS.n6692 152
R3321 VSS.n7227 VSS.n7226 152
R3322 VSS.n7224 VSS.n7223 152
R3323 VSS.n7205 VSS.n7204 152
R3324 VSS.n7203 VSS.n7202 152
R3325 VSS.n6704 VSS.n6701 152
R3326 VSS.n6712 VSS.n6710 152
R3327 VSS.n7179 VSS.n7178 152
R3328 VSS.n7176 VSS.n7175 152
R3329 VSS.n7170 VSS.n7169 152
R3330 VSS.n7168 VSS.n7167 152
R3331 VSS.n7160 VSS.n6718 152
R3332 VSS.n6732 VSS.n6726 152
R3333 VSS.n6733 VSS.n6727 152
R3334 VSS.n7143 VSS.n7142 152
R3335 VSS.n6744 VSS.n6742 152
R3336 VSS.n7126 VSS.n7125 152
R3337 VSS.n7123 VSS.n7122 152
R3338 VSS.n7104 VSS.n7103 152
R3339 VSS.n7102 VSS.n7101 152
R3340 VSS.n6754 VSS.n6751 152
R3341 VSS.n6762 VSS.n6760 152
R3342 VSS.n7078 VSS.n7077 152
R3343 VSS.n7075 VSS.n7074 152
R3344 VSS.n7069 VSS.n7068 152
R3345 VSS.n7067 VSS.n7066 152
R3346 VSS.n7059 VSS.n6768 152
R3347 VSS.n6782 VSS.n6776 152
R3348 VSS.n6783 VSS.n6777 152
R3349 VSS.n7042 VSS.n7041 152
R3350 VSS.n6794 VSS.n6792 152
R3351 VSS.n7025 VSS.n7024 152
R3352 VSS.n7022 VSS.n7021 152
R3353 VSS.n7003 VSS.n7002 152
R3354 VSS.n7001 VSS.n7000 152
R3355 VSS.n6804 VSS.n6801 152
R3356 VSS.n6812 VSS.n6810 152
R3357 VSS.n6977 VSS.n6976 152
R3358 VSS.n6974 VSS.n6973 152
R3359 VSS.n6968 VSS.n6967 152
R3360 VSS.n6966 VSS.n6965 152
R3361 VSS.n6958 VSS.n6818 152
R3362 VSS.n6832 VSS.n6826 152
R3363 VSS.n6833 VSS.n6827 152
R3364 VSS.n6941 VSS.n6940 152
R3365 VSS.n8317 VSS.n8316 152
R3366 VSS.n8315 VSS.n8314 152
R3367 VSS.n8307 VSS.n8302 152
R3368 VSS.n8317 VSS.n8298 152
R3369 VSS.n8314 VSS.n8301 152
R3370 VSS.n8306 VSS.n8302 152
R3371 VSS.n8340 VSS.n8339 152
R3372 VSS.n8338 VSS.n8337 152
R3373 VSS.n8330 VSS.n8289 152
R3374 VSS.n8340 VSS.n8285 152
R3375 VSS.n8337 VSS.n8288 152
R3376 VSS.n8293 VSS.n8289 152
R3377 VSS.n7641 VSS.n7640 152
R3378 VSS.n7643 VSS.n7642 152
R3379 VSS.n7651 VSS.n7650 152
R3380 VSS.n7630 VSS.n7629 152
R3381 VSS.n7628 VSS.n7612 152
R3382 VSS.n7637 VSS.n7636 152
R3383 VSS.n7661 VSS.n7660 152
R3384 VSS.n7663 VSS.n7662 152
R3385 VSS.n7666 VSS.n7665 152
R3386 VSS.n2531 VSS.n2530 152
R3387 VSS.n7681 VSS.n7680 152
R3388 VSS.n7684 VSS.n7683 152
R3389 VSS.n7701 VSS.n7700 152
R3390 VSS.n7704 VSS.n7703 152
R3391 VSS.n2518 VSS.n2517 152
R3392 VSS.n7714 VSS.n7713 152
R3393 VSS.n7715 VSS.n2515 152
R3394 VSS.n7718 VSS.n7717 152
R3395 VSS.n7738 VSS.n7737 152
R3396 VSS.n7740 VSS.n7739 152
R3397 VSS.n7748 VSS.n7747 152
R3398 VSS.n7762 VSS.n7761 152
R3399 VSS.n7764 VSS.n7763 152
R3400 VSS.n7771 VSS.n7770 152
R3401 VSS.n2489 VSS.n2488 152
R3402 VSS.n7787 VSS.n7786 152
R3403 VSS.n7790 VSS.n7789 152
R3404 VSS.n7807 VSS.n7806 152
R3405 VSS.n7810 VSS.n7809 152
R3406 VSS.n2476 VSS.n2475 152
R3407 VSS.n7820 VSS.n7819 152
R3408 VSS.n7821 VSS.n2473 152
R3409 VSS.n7824 VSS.n7823 152
R3410 VSS.n7844 VSS.n7843 152
R3411 VSS.n7846 VSS.n7845 152
R3412 VSS.n7854 VSS.n7853 152
R3413 VSS.n7868 VSS.n7867 152
R3414 VSS.n7870 VSS.n7869 152
R3415 VSS.n7877 VSS.n7876 152
R3416 VSS.n2447 VSS.n2446 152
R3417 VSS.n7893 VSS.n7892 152
R3418 VSS.n7896 VSS.n7895 152
R3419 VSS.n7913 VSS.n7912 152
R3420 VSS.n7916 VSS.n7915 152
R3421 VSS.n2434 VSS.n2433 152
R3422 VSS.n7926 VSS.n7925 152
R3423 VSS.n7927 VSS.n2431 152
R3424 VSS.n7930 VSS.n7929 152
R3425 VSS.n7950 VSS.n7949 152
R3426 VSS.n7952 VSS.n7951 152
R3427 VSS.n7960 VSS.n7959 152
R3428 VSS.n7974 VSS.n7973 152
R3429 VSS.n7976 VSS.n7975 152
R3430 VSS.n7983 VSS.n7982 152
R3431 VSS.n2405 VSS.n2404 152
R3432 VSS.n7999 VSS.n7998 152
R3433 VSS.n8002 VSS.n8001 152
R3434 VSS.n8019 VSS.n8018 152
R3435 VSS.n8022 VSS.n8021 152
R3436 VSS.n2392 VSS.n2391 152
R3437 VSS.n8032 VSS.n8031 152
R3438 VSS.n8033 VSS.n2389 152
R3439 VSS.n8036 VSS.n8035 152
R3440 VSS.n8056 VSS.n8055 152
R3441 VSS.n8058 VSS.n8057 152
R3442 VSS.n8066 VSS.n8065 152
R3443 VSS.n8080 VSS.n8079 152
R3444 VSS.n8082 VSS.n8081 152
R3445 VSS.n8089 VSS.n8088 152
R3446 VSS.n2363 VSS.n2362 152
R3447 VSS.n8105 VSS.n8104 152
R3448 VSS.n8108 VSS.n8107 152
R3449 VSS.n8125 VSS.n8124 152
R3450 VSS.n8128 VSS.n8127 152
R3451 VSS.n2350 VSS.n2349 152
R3452 VSS.n8138 VSS.n8137 152
R3453 VSS.n8139 VSS.n2347 152
R3454 VSS.n8142 VSS.n8141 152
R3455 VSS.n8162 VSS.n8161 152
R3456 VSS.n8164 VSS.n8163 152
R3457 VSS.n8172 VSS.n8171 152
R3458 VSS.n8186 VSS.n8185 152
R3459 VSS.n8188 VSS.n8187 152
R3460 VSS.n8195 VSS.n8194 152
R3461 VSS.n2321 VSS.n2320 152
R3462 VSS.n8211 VSS.n8210 152
R3463 VSS.n8214 VSS.n8213 152
R3464 VSS.n8231 VSS.n8230 152
R3465 VSS.n8234 VSS.n8233 152
R3466 VSS.n2308 VSS.n2307 152
R3467 VSS.n8244 VSS.n8243 152
R3468 VSS.n8245 VSS.n2305 152
R3469 VSS.n8248 VSS.n8247 152
R3470 VSS.n8269 VSS.n8268 152
R3471 VSS.n8270 VSS.n2277 152
R3472 VSS.n8272 VSS.n2278 152
R3473 VSS.n9355 VSS.n9354 152
R3474 VSS.n9353 VSS.n9352 152
R3475 VSS.n9345 VSS.n9340 152
R3476 VSS.n9355 VSS.n9336 152
R3477 VSS.n9352 VSS.n9339 152
R3478 VSS.n9344 VSS.n9340 152
R3479 VSS.n9378 VSS.n9377 152
R3480 VSS.n9376 VSS.n9375 152
R3481 VSS.n9368 VSS.n9327 152
R3482 VSS.n9378 VSS.n9323 152
R3483 VSS.n9375 VSS.n9326 152
R3484 VSS.n9331 VSS.n9327 152
R3485 VSS.n8684 VSS.n8683 152
R3486 VSS.n8686 VSS.n8685 152
R3487 VSS.n8694 VSS.n8693 152
R3488 VSS.n8673 VSS.n8672 152
R3489 VSS.n8671 VSS.n8655 152
R3490 VSS.n8680 VSS.n8679 152
R3491 VSS.n8705 VSS.n8704 152
R3492 VSS.n8703 VSS.n8633 152
R3493 VSS.n8709 VSS.n8708 152
R3494 VSS.n8623 VSS.n8622 152
R3495 VSS.n8719 VSS.n8718 152
R3496 VSS.n8722 VSS.n8721 152
R3497 VSS.n8739 VSS.n8738 152
R3498 VSS.n8742 VSS.n8741 152
R3499 VSS.n8610 VSS.n8609 152
R3500 VSS.n8752 VSS.n8751 152
R3501 VSS.n8753 VSS.n8607 152
R3502 VSS.n8756 VSS.n8755 152
R3503 VSS.n8776 VSS.n8775 152
R3504 VSS.n8778 VSS.n8777 152
R3505 VSS.n8786 VSS.n8785 152
R3506 VSS.n8800 VSS.n8799 152
R3507 VSS.n8802 VSS.n8801 152
R3508 VSS.n8809 VSS.n8808 152
R3509 VSS.n8581 VSS.n8580 152
R3510 VSS.n8825 VSS.n8824 152
R3511 VSS.n8828 VSS.n8827 152
R3512 VSS.n8845 VSS.n8844 152
R3513 VSS.n8848 VSS.n8847 152
R3514 VSS.n8568 VSS.n8567 152
R3515 VSS.n8858 VSS.n8857 152
R3516 VSS.n8859 VSS.n8565 152
R3517 VSS.n8862 VSS.n8861 152
R3518 VSS.n8882 VSS.n8881 152
R3519 VSS.n8884 VSS.n8883 152
R3520 VSS.n8892 VSS.n8891 152
R3521 VSS.n8906 VSS.n8905 152
R3522 VSS.n8908 VSS.n8907 152
R3523 VSS.n8915 VSS.n8914 152
R3524 VSS.n8539 VSS.n8538 152
R3525 VSS.n8931 VSS.n8930 152
R3526 VSS.n8934 VSS.n8933 152
R3527 VSS.n8951 VSS.n8950 152
R3528 VSS.n8954 VSS.n8953 152
R3529 VSS.n8526 VSS.n8525 152
R3530 VSS.n8964 VSS.n8963 152
R3531 VSS.n8965 VSS.n8523 152
R3532 VSS.n8968 VSS.n8967 152
R3533 VSS.n8988 VSS.n8987 152
R3534 VSS.n8990 VSS.n8989 152
R3535 VSS.n8998 VSS.n8997 152
R3536 VSS.n9012 VSS.n9011 152
R3537 VSS.n9014 VSS.n9013 152
R3538 VSS.n9021 VSS.n9020 152
R3539 VSS.n8497 VSS.n8496 152
R3540 VSS.n9037 VSS.n9036 152
R3541 VSS.n9040 VSS.n9039 152
R3542 VSS.n9057 VSS.n9056 152
R3543 VSS.n9060 VSS.n9059 152
R3544 VSS.n8484 VSS.n8483 152
R3545 VSS.n9070 VSS.n9069 152
R3546 VSS.n9071 VSS.n8481 152
R3547 VSS.n9074 VSS.n9073 152
R3548 VSS.n9094 VSS.n9093 152
R3549 VSS.n9096 VSS.n9095 152
R3550 VSS.n9104 VSS.n9103 152
R3551 VSS.n9118 VSS.n9117 152
R3552 VSS.n9120 VSS.n9119 152
R3553 VSS.n9127 VSS.n9126 152
R3554 VSS.n8455 VSS.n8454 152
R3555 VSS.n9143 VSS.n9142 152
R3556 VSS.n9146 VSS.n9145 152
R3557 VSS.n9163 VSS.n9162 152
R3558 VSS.n9166 VSS.n9165 152
R3559 VSS.n8442 VSS.n8441 152
R3560 VSS.n9176 VSS.n9175 152
R3561 VSS.n9177 VSS.n8439 152
R3562 VSS.n9180 VSS.n9179 152
R3563 VSS.n9200 VSS.n9199 152
R3564 VSS.n9202 VSS.n9201 152
R3565 VSS.n9210 VSS.n9209 152
R3566 VSS.n9224 VSS.n9223 152
R3567 VSS.n9226 VSS.n9225 152
R3568 VSS.n9233 VSS.n9232 152
R3569 VSS.n8413 VSS.n8412 152
R3570 VSS.n9249 VSS.n9248 152
R3571 VSS.n9252 VSS.n9251 152
R3572 VSS.n9269 VSS.n9268 152
R3573 VSS.n9272 VSS.n9271 152
R3574 VSS.n8400 VSS.n8399 152
R3575 VSS.n9282 VSS.n9281 152
R3576 VSS.n9283 VSS.n8397 152
R3577 VSS.n9286 VSS.n9285 152
R3578 VSS.n9307 VSS.n9306 152
R3579 VSS.n9308 VSS.n8369 152
R3580 VSS.n9310 VSS.n8370 152
R3581 VSS.n2233 VSS.n2232 152
R3582 VSS.n2230 VSS.n2229 152
R3583 VSS.n2221 VSS.n2218 152
R3584 VSS.n2243 VSS.n2242 152
R3585 VSS.n2240 VSS.n2239 152
R3586 VSS.n10033 VSS.n10032 152
R3587 VSS.n10035 VSS.n10034 152
R3588 VSS.n10043 VSS.n10042 152
R3589 VSS.n10022 VSS.n10021 152
R3590 VSS.n10020 VSS.n10004 152
R3591 VSS.n10029 VSS.n10028 152
R3592 VSS.n10053 VSS.n10052 152
R3593 VSS.n10055 VSS.n10054 152
R3594 VSS.n10058 VSS.n10057 152
R3595 VSS.n9979 VSS.n9978 152
R3596 VSS.n9989 VSS.n9988 152
R3597 VSS.n9992 VSS.n9991 152
R3598 VSS.n1928 VSS.n1926 152
R3599 VSS.n9960 VSS.n9959 152
R3600 VSS.n9957 VSS.n9956 152
R3601 VSS.n9951 VSS.n9950 152
R3602 VSS.n9949 VSS.n9948 152
R3603 VSS.n9941 VSS.n1934 152
R3604 VSS.n1948 VSS.n1942 152
R3605 VSS.n1949 VSS.n1943 152
R3606 VSS.n9924 VSS.n9923 152
R3607 VSS.n1960 VSS.n1958 152
R3608 VSS.n9907 VSS.n9906 152
R3609 VSS.n9904 VSS.n9903 152
R3610 VSS.n9885 VSS.n9884 152
R3611 VSS.n9883 VSS.n9882 152
R3612 VSS.n1970 VSS.n1967 152
R3613 VSS.n1978 VSS.n1976 152
R3614 VSS.n9859 VSS.n9858 152
R3615 VSS.n9856 VSS.n9855 152
R3616 VSS.n9850 VSS.n9849 152
R3617 VSS.n9848 VSS.n9847 152
R3618 VSS.n9840 VSS.n1984 152
R3619 VSS.n1998 VSS.n1992 152
R3620 VSS.n1999 VSS.n1993 152
R3621 VSS.n9823 VSS.n9822 152
R3622 VSS.n2010 VSS.n2008 152
R3623 VSS.n9806 VSS.n9805 152
R3624 VSS.n9803 VSS.n9802 152
R3625 VSS.n9784 VSS.n9783 152
R3626 VSS.n9782 VSS.n9781 152
R3627 VSS.n2020 VSS.n2017 152
R3628 VSS.n2028 VSS.n2026 152
R3629 VSS.n9758 VSS.n9757 152
R3630 VSS.n9755 VSS.n9754 152
R3631 VSS.n9749 VSS.n9748 152
R3632 VSS.n9747 VSS.n9746 152
R3633 VSS.n9739 VSS.n2034 152
R3634 VSS.n2048 VSS.n2042 152
R3635 VSS.n2049 VSS.n2043 152
R3636 VSS.n9722 VSS.n9721 152
R3637 VSS.n2060 VSS.n2058 152
R3638 VSS.n9705 VSS.n9704 152
R3639 VSS.n9702 VSS.n9701 152
R3640 VSS.n9683 VSS.n9682 152
R3641 VSS.n9681 VSS.n9680 152
R3642 VSS.n2070 VSS.n2067 152
R3643 VSS.n2078 VSS.n2076 152
R3644 VSS.n9657 VSS.n9656 152
R3645 VSS.n9654 VSS.n9653 152
R3646 VSS.n9648 VSS.n9647 152
R3647 VSS.n9646 VSS.n9645 152
R3648 VSS.n9638 VSS.n2084 152
R3649 VSS.n2098 VSS.n2092 152
R3650 VSS.n2099 VSS.n2093 152
R3651 VSS.n9621 VSS.n9620 152
R3652 VSS.n2110 VSS.n2108 152
R3653 VSS.n9604 VSS.n9603 152
R3654 VSS.n9601 VSS.n9600 152
R3655 VSS.n9582 VSS.n9581 152
R3656 VSS.n9580 VSS.n9579 152
R3657 VSS.n2120 VSS.n2117 152
R3658 VSS.n2128 VSS.n2126 152
R3659 VSS.n9556 VSS.n9555 152
R3660 VSS.n9553 VSS.n9552 152
R3661 VSS.n9547 VSS.n9546 152
R3662 VSS.n9545 VSS.n9544 152
R3663 VSS.n9537 VSS.n2134 152
R3664 VSS.n2148 VSS.n2142 152
R3665 VSS.n2149 VSS.n2143 152
R3666 VSS.n9520 VSS.n9519 152
R3667 VSS.n2160 VSS.n2158 152
R3668 VSS.n9503 VSS.n9502 152
R3669 VSS.n9500 VSS.n9499 152
R3670 VSS.n9481 VSS.n9480 152
R3671 VSS.n9479 VSS.n9478 152
R3672 VSS.n2170 VSS.n2167 152
R3673 VSS.n2178 VSS.n2176 152
R3674 VSS.n9455 VSS.n9454 152
R3675 VSS.n9452 VSS.n9451 152
R3676 VSS.n9446 VSS.n9445 152
R3677 VSS.n9444 VSS.n9443 152
R3678 VSS.n9436 VSS.n2184 152
R3679 VSS.n2198 VSS.n2192 152
R3680 VSS.n2199 VSS.n2193 152
R3681 VSS.n9419 VSS.n9418 152
R3682 VSS.n10387 VSS.n10384 152
R3683 VSS.n10400 VSS.n10399 152
R3684 VSS.n10397 VSS.n10396 152
R3685 VSS.n10389 VSS.n10384 152
R3686 VSS.n10400 VSS.n10385 152
R3687 VSS.n10396 VSS.n10391 152
R3688 VSS.n10373 VSS.n10370 152
R3689 VSS.n10422 VSS.n10421 152
R3690 VSS.n10419 VSS.n10418 152
R3691 VSS.n10375 VSS.n10370 152
R3692 VSS.n10422 VSS.n10371 152
R3693 VSS.n10418 VSS.n10377 152
R3694 VSS.n11075 VSS.n11074 152
R3695 VSS.n11077 VSS.n11076 152
R3696 VSS.n11085 VSS.n11084 152
R3697 VSS.n11064 VSS.n11063 152
R3698 VSS.n11062 VSS.n11046 152
R3699 VSS.n11071 VSS.n11070 152
R3700 VSS.n11095 VSS.n11094 152
R3701 VSS.n11097 VSS.n11096 152
R3702 VSS.n11100 VSS.n11099 152
R3703 VSS.n11021 VSS.n11020 152
R3704 VSS.n11031 VSS.n11030 152
R3705 VSS.n11034 VSS.n11033 152
R3706 VSS.n10082 VSS.n10080 152
R3707 VSS.n11002 VSS.n11001 152
R3708 VSS.n10999 VSS.n10998 152
R3709 VSS.n10993 VSS.n10992 152
R3710 VSS.n10991 VSS.n10990 152
R3711 VSS.n10983 VSS.n10088 152
R3712 VSS.n10102 VSS.n10096 152
R3713 VSS.n10103 VSS.n10097 152
R3714 VSS.n10966 VSS.n10965 152
R3715 VSS.n10114 VSS.n10112 152
R3716 VSS.n10949 VSS.n10948 152
R3717 VSS.n10946 VSS.n10945 152
R3718 VSS.n10927 VSS.n10926 152
R3719 VSS.n10925 VSS.n10924 152
R3720 VSS.n10124 VSS.n10121 152
R3721 VSS.n10132 VSS.n10130 152
R3722 VSS.n10901 VSS.n10900 152
R3723 VSS.n10898 VSS.n10897 152
R3724 VSS.n10892 VSS.n10891 152
R3725 VSS.n10890 VSS.n10889 152
R3726 VSS.n10882 VSS.n10138 152
R3727 VSS.n10152 VSS.n10146 152
R3728 VSS.n10153 VSS.n10147 152
R3729 VSS.n10865 VSS.n10864 152
R3730 VSS.n10164 VSS.n10162 152
R3731 VSS.n10848 VSS.n10847 152
R3732 VSS.n10845 VSS.n10844 152
R3733 VSS.n10826 VSS.n10825 152
R3734 VSS.n10824 VSS.n10823 152
R3735 VSS.n10174 VSS.n10171 152
R3736 VSS.n10182 VSS.n10180 152
R3737 VSS.n10800 VSS.n10799 152
R3738 VSS.n10797 VSS.n10796 152
R3739 VSS.n10791 VSS.n10790 152
R3740 VSS.n10789 VSS.n10788 152
R3741 VSS.n10781 VSS.n10188 152
R3742 VSS.n10202 VSS.n10196 152
R3743 VSS.n10203 VSS.n10197 152
R3744 VSS.n10764 VSS.n10763 152
R3745 VSS.n10214 VSS.n10212 152
R3746 VSS.n10747 VSS.n10746 152
R3747 VSS.n10744 VSS.n10743 152
R3748 VSS.n10725 VSS.n10724 152
R3749 VSS.n10723 VSS.n10722 152
R3750 VSS.n10224 VSS.n10221 152
R3751 VSS.n10232 VSS.n10230 152
R3752 VSS.n10699 VSS.n10698 152
R3753 VSS.n10696 VSS.n10695 152
R3754 VSS.n10690 VSS.n10689 152
R3755 VSS.n10688 VSS.n10687 152
R3756 VSS.n10680 VSS.n10238 152
R3757 VSS.n10252 VSS.n10246 152
R3758 VSS.n10253 VSS.n10247 152
R3759 VSS.n10663 VSS.n10662 152
R3760 VSS.n10264 VSS.n10262 152
R3761 VSS.n10646 VSS.n10645 152
R3762 VSS.n10643 VSS.n10642 152
R3763 VSS.n10624 VSS.n10623 152
R3764 VSS.n10622 VSS.n10621 152
R3765 VSS.n10274 VSS.n10271 152
R3766 VSS.n10282 VSS.n10280 152
R3767 VSS.n10598 VSS.n10597 152
R3768 VSS.n10595 VSS.n10594 152
R3769 VSS.n10589 VSS.n10588 152
R3770 VSS.n10587 VSS.n10586 152
R3771 VSS.n10579 VSS.n10288 152
R3772 VSS.n10302 VSS.n10296 152
R3773 VSS.n10303 VSS.n10297 152
R3774 VSS.n10562 VSS.n10561 152
R3775 VSS.n10314 VSS.n10312 152
R3776 VSS.n10545 VSS.n10544 152
R3777 VSS.n10542 VSS.n10541 152
R3778 VSS.n10523 VSS.n10522 152
R3779 VSS.n10521 VSS.n10520 152
R3780 VSS.n10324 VSS.n10321 152
R3781 VSS.n10332 VSS.n10330 152
R3782 VSS.n10497 VSS.n10496 152
R3783 VSS.n10494 VSS.n10493 152
R3784 VSS.n10488 VSS.n10487 152
R3785 VSS.n10486 VSS.n10485 152
R3786 VSS.n10478 VSS.n10338 152
R3787 VSS.n10352 VSS.n10346 152
R3788 VSS.n10353 VSS.n10347 152
R3789 VSS.n10461 VSS.n10460 152
R3790 VSS.n11837 VSS.n11836 152
R3791 VSS.n11835 VSS.n11834 152
R3792 VSS.n11827 VSS.n11822 152
R3793 VSS.n11837 VSS.n11818 152
R3794 VSS.n11834 VSS.n11821 152
R3795 VSS.n11826 VSS.n11822 152
R3796 VSS.n11860 VSS.n11859 152
R3797 VSS.n11858 VSS.n11857 152
R3798 VSS.n11850 VSS.n11809 152
R3799 VSS.n11860 VSS.n11805 152
R3800 VSS.n11857 VSS.n11808 152
R3801 VSS.n11813 VSS.n11809 152
R3802 VSS.n11161 VSS.n11160 152
R3803 VSS.n11163 VSS.n11162 152
R3804 VSS.n11171 VSS.n11170 152
R3805 VSS.n11150 VSS.n11149 152
R3806 VSS.n11148 VSS.n11132 152
R3807 VSS.n11157 VSS.n11156 152
R3808 VSS.n11181 VSS.n11180 152
R3809 VSS.n11183 VSS.n11182 152
R3810 VSS.n11186 VSS.n11185 152
R3811 VSS.n1909 VSS.n1908 152
R3812 VSS.n11201 VSS.n11200 152
R3813 VSS.n11204 VSS.n11203 152
R3814 VSS.n11221 VSS.n11220 152
R3815 VSS.n11224 VSS.n11223 152
R3816 VSS.n1896 VSS.n1895 152
R3817 VSS.n11234 VSS.n11233 152
R3818 VSS.n11235 VSS.n1893 152
R3819 VSS.n11238 VSS.n11237 152
R3820 VSS.n11258 VSS.n11257 152
R3821 VSS.n11260 VSS.n11259 152
R3822 VSS.n11268 VSS.n11267 152
R3823 VSS.n11282 VSS.n11281 152
R3824 VSS.n11284 VSS.n11283 152
R3825 VSS.n11291 VSS.n11290 152
R3826 VSS.n1867 VSS.n1866 152
R3827 VSS.n11307 VSS.n11306 152
R3828 VSS.n11310 VSS.n11309 152
R3829 VSS.n11327 VSS.n11326 152
R3830 VSS.n11330 VSS.n11329 152
R3831 VSS.n1854 VSS.n1853 152
R3832 VSS.n11340 VSS.n11339 152
R3833 VSS.n11341 VSS.n1851 152
R3834 VSS.n11344 VSS.n11343 152
R3835 VSS.n11364 VSS.n11363 152
R3836 VSS.n11366 VSS.n11365 152
R3837 VSS.n11374 VSS.n11373 152
R3838 VSS.n11388 VSS.n11387 152
R3839 VSS.n11390 VSS.n11389 152
R3840 VSS.n11397 VSS.n11396 152
R3841 VSS.n1825 VSS.n1824 152
R3842 VSS.n11413 VSS.n11412 152
R3843 VSS.n11416 VSS.n11415 152
R3844 VSS.n11433 VSS.n11432 152
R3845 VSS.n11436 VSS.n11435 152
R3846 VSS.n1812 VSS.n1811 152
R3847 VSS.n11446 VSS.n11445 152
R3848 VSS.n11447 VSS.n1809 152
R3849 VSS.n11450 VSS.n11449 152
R3850 VSS.n11470 VSS.n11469 152
R3851 VSS.n11472 VSS.n11471 152
R3852 VSS.n11480 VSS.n11479 152
R3853 VSS.n11494 VSS.n11493 152
R3854 VSS.n11496 VSS.n11495 152
R3855 VSS.n11503 VSS.n11502 152
R3856 VSS.n1783 VSS.n1782 152
R3857 VSS.n11519 VSS.n11518 152
R3858 VSS.n11522 VSS.n11521 152
R3859 VSS.n11539 VSS.n11538 152
R3860 VSS.n11542 VSS.n11541 152
R3861 VSS.n1770 VSS.n1769 152
R3862 VSS.n11552 VSS.n11551 152
R3863 VSS.n11553 VSS.n1767 152
R3864 VSS.n11556 VSS.n11555 152
R3865 VSS.n11576 VSS.n11575 152
R3866 VSS.n11578 VSS.n11577 152
R3867 VSS.n11586 VSS.n11585 152
R3868 VSS.n11600 VSS.n11599 152
R3869 VSS.n11602 VSS.n11601 152
R3870 VSS.n11609 VSS.n11608 152
R3871 VSS.n1741 VSS.n1740 152
R3872 VSS.n11625 VSS.n11624 152
R3873 VSS.n11628 VSS.n11627 152
R3874 VSS.n11645 VSS.n11644 152
R3875 VSS.n11648 VSS.n11647 152
R3876 VSS.n1728 VSS.n1727 152
R3877 VSS.n11658 VSS.n11657 152
R3878 VSS.n11659 VSS.n1725 152
R3879 VSS.n11662 VSS.n11661 152
R3880 VSS.n11682 VSS.n11681 152
R3881 VSS.n11684 VSS.n11683 152
R3882 VSS.n11692 VSS.n11691 152
R3883 VSS.n11706 VSS.n11705 152
R3884 VSS.n11708 VSS.n11707 152
R3885 VSS.n11715 VSS.n11714 152
R3886 VSS.n1699 VSS.n1698 152
R3887 VSS.n11731 VSS.n11730 152
R3888 VSS.n11734 VSS.n11733 152
R3889 VSS.n11751 VSS.n11750 152
R3890 VSS.n11754 VSS.n11753 152
R3891 VSS.n1686 VSS.n1685 152
R3892 VSS.n11764 VSS.n11763 152
R3893 VSS.n11765 VSS.n1683 152
R3894 VSS.n11768 VSS.n11767 152
R3895 VSS.n11789 VSS.n11788 152
R3896 VSS.n11790 VSS.n1655 152
R3897 VSS.n11792 VSS.n1656 152
R3898 VSS.n12875 VSS.n12874 152
R3899 VSS.n12873 VSS.n12872 152
R3900 VSS.n12865 VSS.n12860 152
R3901 VSS.n12875 VSS.n12856 152
R3902 VSS.n12872 VSS.n12859 152
R3903 VSS.n12864 VSS.n12860 152
R3904 VSS.n12898 VSS.n12897 152
R3905 VSS.n12896 VSS.n12895 152
R3906 VSS.n12888 VSS.n12847 152
R3907 VSS.n12898 VSS.n12843 152
R3908 VSS.n12895 VSS.n12846 152
R3909 VSS.n12851 VSS.n12847 152
R3910 VSS.n12204 VSS.n12203 152
R3911 VSS.n12206 VSS.n12205 152
R3912 VSS.n12214 VSS.n12213 152
R3913 VSS.n12193 VSS.n12192 152
R3914 VSS.n12191 VSS.n12175 152
R3915 VSS.n12200 VSS.n12199 152
R3916 VSS.n12225 VSS.n12224 152
R3917 VSS.n12223 VSS.n12153 152
R3918 VSS.n12229 VSS.n12228 152
R3919 VSS.n12143 VSS.n12142 152
R3920 VSS.n12239 VSS.n12238 152
R3921 VSS.n12242 VSS.n12241 152
R3922 VSS.n12259 VSS.n12258 152
R3923 VSS.n12262 VSS.n12261 152
R3924 VSS.n12130 VSS.n12129 152
R3925 VSS.n12272 VSS.n12271 152
R3926 VSS.n12273 VSS.n12127 152
R3927 VSS.n12276 VSS.n12275 152
R3928 VSS.n12296 VSS.n12295 152
R3929 VSS.n12298 VSS.n12297 152
R3930 VSS.n12306 VSS.n12305 152
R3931 VSS.n12320 VSS.n12319 152
R3932 VSS.n12322 VSS.n12321 152
R3933 VSS.n12329 VSS.n12328 152
R3934 VSS.n12101 VSS.n12100 152
R3935 VSS.n12345 VSS.n12344 152
R3936 VSS.n12348 VSS.n12347 152
R3937 VSS.n12365 VSS.n12364 152
R3938 VSS.n12368 VSS.n12367 152
R3939 VSS.n12088 VSS.n12087 152
R3940 VSS.n12378 VSS.n12377 152
R3941 VSS.n12379 VSS.n12085 152
R3942 VSS.n12382 VSS.n12381 152
R3943 VSS.n12402 VSS.n12401 152
R3944 VSS.n12404 VSS.n12403 152
R3945 VSS.n12412 VSS.n12411 152
R3946 VSS.n12426 VSS.n12425 152
R3947 VSS.n12428 VSS.n12427 152
R3948 VSS.n12435 VSS.n12434 152
R3949 VSS.n12059 VSS.n12058 152
R3950 VSS.n12451 VSS.n12450 152
R3951 VSS.n12454 VSS.n12453 152
R3952 VSS.n12471 VSS.n12470 152
R3953 VSS.n12474 VSS.n12473 152
R3954 VSS.n12046 VSS.n12045 152
R3955 VSS.n12484 VSS.n12483 152
R3956 VSS.n12485 VSS.n12043 152
R3957 VSS.n12488 VSS.n12487 152
R3958 VSS.n12508 VSS.n12507 152
R3959 VSS.n12510 VSS.n12509 152
R3960 VSS.n12518 VSS.n12517 152
R3961 VSS.n12532 VSS.n12531 152
R3962 VSS.n12534 VSS.n12533 152
R3963 VSS.n12541 VSS.n12540 152
R3964 VSS.n12017 VSS.n12016 152
R3965 VSS.n12557 VSS.n12556 152
R3966 VSS.n12560 VSS.n12559 152
R3967 VSS.n12577 VSS.n12576 152
R3968 VSS.n12580 VSS.n12579 152
R3969 VSS.n12004 VSS.n12003 152
R3970 VSS.n12590 VSS.n12589 152
R3971 VSS.n12591 VSS.n12001 152
R3972 VSS.n12594 VSS.n12593 152
R3973 VSS.n12614 VSS.n12613 152
R3974 VSS.n12616 VSS.n12615 152
R3975 VSS.n12624 VSS.n12623 152
R3976 VSS.n12638 VSS.n12637 152
R3977 VSS.n12640 VSS.n12639 152
R3978 VSS.n12647 VSS.n12646 152
R3979 VSS.n11975 VSS.n11974 152
R3980 VSS.n12663 VSS.n12662 152
R3981 VSS.n12666 VSS.n12665 152
R3982 VSS.n12683 VSS.n12682 152
R3983 VSS.n12686 VSS.n12685 152
R3984 VSS.n11962 VSS.n11961 152
R3985 VSS.n12696 VSS.n12695 152
R3986 VSS.n12697 VSS.n11959 152
R3987 VSS.n12700 VSS.n12699 152
R3988 VSS.n12720 VSS.n12719 152
R3989 VSS.n12722 VSS.n12721 152
R3990 VSS.n12730 VSS.n12729 152
R3991 VSS.n12744 VSS.n12743 152
R3992 VSS.n12746 VSS.n12745 152
R3993 VSS.n12753 VSS.n12752 152
R3994 VSS.n11933 VSS.n11932 152
R3995 VSS.n12769 VSS.n12768 152
R3996 VSS.n12772 VSS.n12771 152
R3997 VSS.n12789 VSS.n12788 152
R3998 VSS.n12792 VSS.n12791 152
R3999 VSS.n11920 VSS.n11919 152
R4000 VSS.n12802 VSS.n12801 152
R4001 VSS.n12803 VSS.n11917 152
R4002 VSS.n12806 VSS.n12805 152
R4003 VSS.n12827 VSS.n12826 152
R4004 VSS.n12828 VSS.n11889 152
R4005 VSS.n12830 VSS.n11890 152
R4006 VSS.n1592 VSS.n1589 152
R4007 VSS.n1605 VSS.n1604 152
R4008 VSS.n1602 VSS.n1601 152
R4009 VSS.n1594 VSS.n1589 152
R4010 VSS.n1605 VSS.n1590 152
R4011 VSS.n1601 VSS.n1596 152
R4012 VSS.n1578 VSS.n1575 152
R4013 VSS.n1627 VSS.n1626 152
R4014 VSS.n1624 VSS.n1623 152
R4015 VSS.n1580 VSS.n1575 152
R4016 VSS.n1627 VSS.n1576 152
R4017 VSS.n1623 VSS.n1582 152
R4018 VSS.n13553 VSS.n13552 152
R4019 VSS.n13555 VSS.n13554 152
R4020 VSS.n13563 VSS.n13562 152
R4021 VSS.n13542 VSS.n13541 152
R4022 VSS.n13540 VSS.n13524 152
R4023 VSS.n13549 VSS.n13548 152
R4024 VSS.n13573 VSS.n13572 152
R4025 VSS.n13575 VSS.n13574 152
R4026 VSS.n13578 VSS.n13577 152
R4027 VSS.n13499 VSS.n13498 152
R4028 VSS.n13509 VSS.n13508 152
R4029 VSS.n13512 VSS.n13511 152
R4030 VSS.n1287 VSS.n1285 152
R4031 VSS.n13480 VSS.n13479 152
R4032 VSS.n13477 VSS.n13476 152
R4033 VSS.n13471 VSS.n13470 152
R4034 VSS.n13469 VSS.n13468 152
R4035 VSS.n13461 VSS.n1293 152
R4036 VSS.n1307 VSS.n1301 152
R4037 VSS.n1308 VSS.n1302 152
R4038 VSS.n13444 VSS.n13443 152
R4039 VSS.n1319 VSS.n1317 152
R4040 VSS.n13427 VSS.n13426 152
R4041 VSS.n13424 VSS.n13423 152
R4042 VSS.n13405 VSS.n13404 152
R4043 VSS.n13403 VSS.n13402 152
R4044 VSS.n1329 VSS.n1326 152
R4045 VSS.n1337 VSS.n1335 152
R4046 VSS.n13379 VSS.n13378 152
R4047 VSS.n13376 VSS.n13375 152
R4048 VSS.n13370 VSS.n13369 152
R4049 VSS.n13368 VSS.n13367 152
R4050 VSS.n13360 VSS.n1343 152
R4051 VSS.n1357 VSS.n1351 152
R4052 VSS.n1358 VSS.n1352 152
R4053 VSS.n13343 VSS.n13342 152
R4054 VSS.n1369 VSS.n1367 152
R4055 VSS.n13326 VSS.n13325 152
R4056 VSS.n13323 VSS.n13322 152
R4057 VSS.n13304 VSS.n13303 152
R4058 VSS.n13302 VSS.n13301 152
R4059 VSS.n1379 VSS.n1376 152
R4060 VSS.n1387 VSS.n1385 152
R4061 VSS.n13278 VSS.n13277 152
R4062 VSS.n13275 VSS.n13274 152
R4063 VSS.n13269 VSS.n13268 152
R4064 VSS.n13267 VSS.n13266 152
R4065 VSS.n13259 VSS.n1393 152
R4066 VSS.n1407 VSS.n1401 152
R4067 VSS.n1408 VSS.n1402 152
R4068 VSS.n13242 VSS.n13241 152
R4069 VSS.n1419 VSS.n1417 152
R4070 VSS.n13225 VSS.n13224 152
R4071 VSS.n13222 VSS.n13221 152
R4072 VSS.n13203 VSS.n13202 152
R4073 VSS.n13201 VSS.n13200 152
R4074 VSS.n1429 VSS.n1426 152
R4075 VSS.n1437 VSS.n1435 152
R4076 VSS.n13177 VSS.n13176 152
R4077 VSS.n13174 VSS.n13173 152
R4078 VSS.n13168 VSS.n13167 152
R4079 VSS.n13166 VSS.n13165 152
R4080 VSS.n13158 VSS.n1443 152
R4081 VSS.n1457 VSS.n1451 152
R4082 VSS.n1458 VSS.n1452 152
R4083 VSS.n13141 VSS.n13140 152
R4084 VSS.n1469 VSS.n1467 152
R4085 VSS.n13124 VSS.n13123 152
R4086 VSS.n13121 VSS.n13120 152
R4087 VSS.n13102 VSS.n13101 152
R4088 VSS.n13100 VSS.n13099 152
R4089 VSS.n1479 VSS.n1476 152
R4090 VSS.n1487 VSS.n1485 152
R4091 VSS.n13076 VSS.n13075 152
R4092 VSS.n13073 VSS.n13072 152
R4093 VSS.n13067 VSS.n13066 152
R4094 VSS.n13065 VSS.n13064 152
R4095 VSS.n13057 VSS.n1493 152
R4096 VSS.n1507 VSS.n1501 152
R4097 VSS.n1508 VSS.n1502 152
R4098 VSS.n13040 VSS.n13039 152
R4099 VSS.n1519 VSS.n1517 152
R4100 VSS.n13023 VSS.n13022 152
R4101 VSS.n13020 VSS.n13019 152
R4102 VSS.n13001 VSS.n13000 152
R4103 VSS.n12999 VSS.n12998 152
R4104 VSS.n1529 VSS.n1526 152
R4105 VSS.n1537 VSS.n1535 152
R4106 VSS.n12975 VSS.n12974 152
R4107 VSS.n12972 VSS.n12971 152
R4108 VSS.n12966 VSS.n12965 152
R4109 VSS.n12964 VSS.n12963 152
R4110 VSS.n12956 VSS.n1543 152
R4111 VSS.n1557 VSS.n1551 152
R4112 VSS.n1558 VSS.n1552 152
R4113 VSS.n12939 VSS.n12938 152
R4114 VSS.n13874 VSS.n13871 152
R4115 VSS.n13887 VSS.n13886 152
R4116 VSS.n13884 VSS.n13883 152
R4117 VSS.n13876 VSS.n13871 152
R4118 VSS.n13887 VSS.n13872 152
R4119 VSS.n13883 VSS.n13878 152
R4120 VSS.n13860 VSS.n13857 152
R4121 VSS.n13909 VSS.n13908 152
R4122 VSS.n13906 VSS.n13905 152
R4123 VSS.n13862 VSS.n13857 152
R4124 VSS.n13909 VSS.n13858 152
R4125 VSS.n13905 VSS.n13864 152
R4126 VSS.n14518 VSS.n14517 152
R4127 VSS.n14520 VSS.n14519 152
R4128 VSS.n14528 VSS.n14527 152
R4129 VSS.n14507 VSS.n14506 152
R4130 VSS.n14505 VSS.n14489 152
R4131 VSS.n14514 VSS.n14513 152
R4132 VSS.n14538 VSS.n14537 152
R4133 VSS.n14540 VSS.n14539 152
R4134 VSS.n14543 VSS.n14542 152
R4135 VSS.n14464 VSS.n14463 152
R4136 VSS.n14474 VSS.n14473 152
R4137 VSS.n14477 VSS.n14476 152
R4138 VSS.n13602 VSS.n13600 152
R4139 VSS.n14445 VSS.n14444 152
R4140 VSS.n14442 VSS.n14441 152
R4141 VSS.n14436 VSS.n14435 152
R4142 VSS.n14434 VSS.n14433 152
R4143 VSS.n14426 VSS.n13608 152
R4144 VSS.n13622 VSS.n13616 152
R4145 VSS.n13623 VSS.n13617 152
R4146 VSS.n14409 VSS.n14408 152
R4147 VSS.n13634 VSS.n13632 152
R4148 VSS.n14392 VSS.n14391 152
R4149 VSS.n14389 VSS.n14388 152
R4150 VSS.n14370 VSS.n14369 152
R4151 VSS.n14368 VSS.n14367 152
R4152 VSS.n13644 VSS.n13641 152
R4153 VSS.n13652 VSS.n13650 152
R4154 VSS.n14349 VSS.n14348 152
R4155 VSS.n14341 VSS.n13655 152
R4156 VSS.n14328 VSS.n14327 152
R4157 VSS.n14326 VSS.n14325 152
R4158 VSS.n14318 VSS.n13663 152
R4159 VSS.n14306 VSS.n14305 152
R4160 VSS.n14304 VSS.n14303 152
R4161 VSS.n14296 VSS.n13704 152
R4162 VSS.t601 VSS.n14275 152
R4163 VSS.n14274 VSS.n14273 152
R4164 VSS.n14267 VSS.n13717 152
R4165 VSS.n14254 VSS.n14253 152
R4166 VSS.n13736 VSS.n13734 152
R4167 VSS.n14226 VSS.n14225 152
R4168 VSS.n14223 VSS.n14222 152
R4169 VSS.n14171 VSS.n14170 152
R4170 VSS.n14174 VSS.n14173 152
R4171 VSS.n14158 VSS.n14157 152
R4172 VSS.n14192 VSS.n14191 152
R4173 VSS.n14195 VSS.n14194 152
R4174 VSS.n14150 VSS.n14149 152
R4175 VSS.n14205 VSS.n14204 152
R4176 VSS.n14206 VSS.n13740 152
R4177 VSS.n14208 VSS.n13741 152
R4178 VSS.n13751 VSS.n13749 152
R4179 VSS.n14133 VSS.n14132 152
R4180 VSS.n14130 VSS.n14129 152
R4181 VSS.n14111 VSS.n14110 152
R4182 VSS.n14109 VSS.n14108 152
R4183 VSS.n13761 VSS.n13758 152
R4184 VSS.n13769 VSS.n13767 152
R4185 VSS.n14085 VSS.n14084 152
R4186 VSS.n14082 VSS.n14081 152
R4187 VSS.n14076 VSS.n14075 152
R4188 VSS.n14074 VSS.n14073 152
R4189 VSS.n14066 VSS.n13775 152
R4190 VSS.n13789 VSS.n13783 152
R4191 VSS.n13790 VSS.n13784 152
R4192 VSS.n14049 VSS.n14048 152
R4193 VSS.n13801 VSS.n13799 152
R4194 VSS.n14032 VSS.n14031 152
R4195 VSS.n14029 VSS.n14028 152
R4196 VSS.n14010 VSS.n14009 152
R4197 VSS.n14008 VSS.n14007 152
R4198 VSS.n13811 VSS.n13808 152
R4199 VSS.n13819 VSS.n13817 152
R4200 VSS.n13984 VSS.n13983 152
R4201 VSS.n13981 VSS.n13980 152
R4202 VSS.n13975 VSS.n13974 152
R4203 VSS.n13973 VSS.n13972 152
R4204 VSS.n13965 VSS.n13825 152
R4205 VSS.n13839 VSS.n13833 152
R4206 VSS.n13840 VSS.n13834 152
R4207 VSS.n13948 VSS.n13947 152
R4208 VSS.n15170 VSS.n15167 152
R4209 VSS.n15183 VSS.n15182 152
R4210 VSS.n15180 VSS.n15179 152
R4211 VSS.n15172 VSS.n15167 152
R4212 VSS.n15183 VSS.n15168 152
R4213 VSS.n15179 VSS.n15174 152
R4214 VSS.n15156 VSS.n15153 152
R4215 VSS.n15205 VSS.n15204 152
R4216 VSS.n15202 VSS.n15201 152
R4217 VSS.n15158 VSS.n15153 152
R4218 VSS.n15205 VSS.n15154 152
R4219 VSS.n15201 VSS.n15160 152
R4220 VSS.n15231 VSS.n15230 152
R4221 VSS.n15233 VSS.n15232 152
R4222 VSS.n15237 VSS.n15236 152
R4223 VSS.n14601 VSS.n14600 152
R4224 VSS.n14603 VSS.n14602 152
R4225 VSS.n14611 VSS.n14610 152
R4226 VSS.n14590 VSS.n14589 152
R4227 VSS.n14588 VSS.n14572 152
R4228 VSS.n14597 VSS.n14596 152
R4229 VSS.n14621 VSS.n14620 152
R4230 VSS.n14623 VSS.n14622 152
R4231 VSS.n14626 VSS.n14625 152
R4232 VSS.n457 VSS.n456 152
R4233 VSS.n14641 VSS.n14640 152
R4234 VSS.n14644 VSS.n14643 152
R4235 VSS.n14661 VSS.n14660 152
R4236 VSS.n14664 VSS.n14663 152
R4237 VSS.n444 VSS.n443 152
R4238 VSS.n14674 VSS.n14673 152
R4239 VSS.n14675 VSS.n441 152
R4240 VSS.n14678 VSS.n14677 152
R4241 VSS.n14698 VSS.n14697 152
R4242 VSS.n14700 VSS.n14699 152
R4243 VSS.n14708 VSS.n14707 152
R4244 VSS.n425 VSS.n424 152
R4245 VSS.n417 VSS.n416 152
R4246 VSS.n419 VSS.n418 152
R4247 VSS.n14727 VSS.n14726 152
R4248 VSS.n407 VSS.n406 152
R4249 VSS.n399 VSS.n398 152
R4250 VSS.n401 VSS.n400 152
R4251 VSS.n14745 VSS.n14744 152
R4252 VSS.n14872 VSS.n14871 152
R4253 VSS.n14902 VSS.n14901 152
R4254 VSS.n14935 VSS.n14934 152
R4255 VSS.n14937 VSS.n14936 152
R4256 VSS.n14944 VSS.n14943 152
R4257 VSS.n14962 VSS.n14958 152
R4258 VSS.n14964 VSS.n14963 152
R4259 VSS.n14972 VSS.n14971 152
R4260 VSS.n14959 VSS.n14958 152
R4261 VSS.n14964 VSS.n14961 152
R4262 VSS.n14971 VSS.n329 152
R4263 VSS.n14991 VSS.n14990 152
R4264 VSS.n14989 VSS.n323 152
R4265 VSS.n14997 VSS.n14996 152
R4266 VSS.n14991 VSS.n14988 152
R4267 VSS.n14987 VSS.n323 152
R4268 VSS.n14996 VSS.n321 152
R4269 VSS.n15058 VSS.n15057 152
R4270 VSS.t257 VSS.n15119 152
R4271 VSS.n15118 VSS.n15117 152
R4272 VSS.n15110 VSS.n15087 152
R4273 VSS.n269 VSS.n268 152
R4274 VSS.n267 VSS.n266 152
R4275 VSS.n259 VSS.n250 152
R4276 VSS.n15355 VSS.n15354 152
R4277 VSS.n15353 VSS.n15352 152
R4278 VSS.n15345 VSS.n237 152
R4279 VSS.n2896 VSS.n2895 152
R4280 VSS.n2894 VSS.n2893 152
R4281 VSS.n2891 VSS.n2890 152
R4282 VSS.n2570 VSS.n2569 152
R4283 VSS.n2568 VSS.n2545 152
R4284 VSS.n2576 VSS.n2575 152
R4285 VSS.n2592 VSS.n2591 152
R4286 VSS.n2590 VSS.n2589 152
R4287 VSS.n2586 VSS.n2585 152
R4288 VSS.n2535 VSS.n2533 152
R4289 VSS.n3439 VSS.n3438 152
R4290 VSS.n3436 VSS.n3435 152
R4291 VSS.n2640 VSS.n2639 152
R4292 VSS.n2642 VSS.n2641 152
R4293 VSS.n2650 VSS.n2649 152
R4294 VSS.n2666 VSS.n2665 152
R4295 VSS.n2664 VSS.n2612 152
R4296 VSS.n2672 VSS.n2671 152
R4297 VSS.n3409 VSS.n3408 152
R4298 VSS.n3407 VSS.n3406 152
R4299 VSS.n3399 VSS.n2683 152
R4300 VSS.n3386 VSS.n3385 152
R4301 VSS.n3384 VSS.n3383 152
R4302 VSS.n3376 VSS.n2692 152
R4303 VSS.n3357 VSS.n3356 152
R4304 VSS.n3355 VSS.n3354 152
R4305 VSS.n3347 VSS.n2703 152
R4306 VSS.n3334 VSS.n3333 152
R4307 VSS.n3332 VSS.n3331 152
R4308 VSS.n3324 VSS.n2712 152
R4309 VSS.n3305 VSS.n3304 152
R4310 VSS.n3303 VSS.n3302 152
R4311 VSS.n3295 VSS.n2723 152
R4312 VSS.n3282 VSS.n3281 152
R4313 VSS.n3280 VSS.n3279 152
R4314 VSS.n3272 VSS.n2732 152
R4315 VSS.n3253 VSS.n3252 152
R4316 VSS.n3251 VSS.n3250 152
R4317 VSS.n3243 VSS.n2743 152
R4318 VSS.n3230 VSS.n3229 152
R4319 VSS.n3228 VSS.n3227 152
R4320 VSS.n3220 VSS.n2752 152
R4321 VSS.n3201 VSS.n3200 152
R4322 VSS.n3199 VSS.n3198 152
R4323 VSS.n3191 VSS.n2763 152
R4324 VSS.n3178 VSS.n3177 152
R4325 VSS.n3176 VSS.n3175 152
R4326 VSS.n3168 VSS.n2772 152
R4327 VSS.n3149 VSS.n3148 152
R4328 VSS.n3147 VSS.n3146 152
R4329 VSS.n3139 VSS.n2783 152
R4330 VSS.n3126 VSS.n3125 152
R4331 VSS.n3124 VSS.n3123 152
R4332 VSS.n3116 VSS.n2792 152
R4333 VSS.n3097 VSS.n3096 152
R4334 VSS.n3095 VSS.n3094 152
R4335 VSS.n3087 VSS.n2803 152
R4336 VSS.n3074 VSS.n3073 152
R4337 VSS.n3072 VSS.n3071 152
R4338 VSS.n3064 VSS.n2812 152
R4339 VSS.n3045 VSS.n3044 152
R4340 VSS.n3043 VSS.n3042 152
R4341 VSS.n3035 VSS.n2823 152
R4342 VSS.n3022 VSS.n3021 152
R4343 VSS.n3020 VSS.n3019 152
R4344 VSS.n3012 VSS.n2832 152
R4345 VSS.n2993 VSS.n2992 152
R4346 VSS.n2991 VSS.n2990 152
R4347 VSS.n2983 VSS.n2843 152
R4348 VSS.n2970 VSS.n2969 152
R4349 VSS.n2968 VSS.n2967 152
R4350 VSS.n2960 VSS.n2852 152
R4351 VSS.n2941 VSS.n2940 152
R4352 VSS.n2939 VSS.n2938 152
R4353 VSS.n2931 VSS.n2863 152
R4354 VSS.n2918 VSS.n2917 152
R4355 VSS.n2916 VSS.n2915 152
R4356 VSS.n2908 VSS.n2872 152
R4357 VSS.t3293 VSS.t148 151.725
R4358 VSS.t242 VSS.t3271 146.512
R4359 VSS.t246 VSS.t203 146.512
R4360 VSS.t27 VSS.t3364 146.512
R4361 VSS.t93 VSS.t110 146.512
R4362 VSS.t4 VSS.t130 146.512
R4363 VSS.t3435 VSS.t3372 146.512
R4364 VSS.t95 VSS.t3292 146.512
R4365 VSS.t56 VSS.t3301 143.296
R4366 VSS.t137 VSS.t3310 143.296
R4367 VSS.t3368 VSS.t3371 135.718
R4368 VSS.t38 VSS.t50 134.867
R4369 VSS.t62 VSS.t247 132.632
R4370 VSS.t247 VSS.t3434 132.632
R4371 VSS.t240 VSS.t242 129.548
R4372 VSS.t64 VSS.t3367 129.548
R4373 VSS.t244 VSS.t246 129.548
R4374 VSS.t25 VSS.t27 129.548
R4375 VSS.t91 VSS.t93 129.548
R4376 VSS.t86 VSS.t3378 129.548
R4377 VSS.t130 VSS.t131 129.548
R4378 VSS.t40 VSS.t3322 129.548
R4379 VSS.t3372 VSS.t3374 129.548
R4380 VSS.t97 VSS.t95 129.548
R4381 VSS.n14347 VSS.t610 129.21
R4382 VSS.t6 VSS.t175 126.438
R4383 VSS.t3327 VSS.t15 126.438
R4384 VSS.n3892 VSS.n3887 125.475
R4385 VSS.n3993 VSS.n3988 125.475
R4386 VSS.n4094 VSS.n4089 125.475
R4387 VSS.n4195 VSS.n4190 125.475
R4388 VSS.n4296 VSS.n4291 125.475
R4389 VSS.n4461 VSS.n3441 125.475
R4390 VSS.n5717 VSS.n4897 125.475
R4391 VSS.n5611 VSS.n4939 125.475
R4392 VSS.n5505 VSS.n4981 125.475
R4393 VSS.n5399 VSS.n5023 125.475
R4394 VSS.n5293 VSS.n5065 125.475
R4395 VSS.n5109 VSS.n5108 125.475
R4396 VSS.n5973 VSS.n5968 125.475
R4397 VSS.n6074 VSS.n6069 125.475
R4398 VSS.n6175 VSS.n6170 125.475
R4399 VSS.n6276 VSS.n6271 125.475
R4400 VSS.n6377 VSS.n6372 125.475
R4401 VSS.n6542 VSS.n4464 125.475
R4402 VSS.n7015 VSS.n7010 125.475
R4403 VSS.n7116 VSS.n7111 125.475
R4404 VSS.n7217 VSS.n7212 125.475
R4405 VSS.n7318 VSS.n7313 125.475
R4406 VSS.n7419 VSS.n7414 125.475
R4407 VSS.n7584 VSS.n6545 125.475
R4408 VSS.n8199 VSS.n2325 125.475
R4409 VSS.n8093 VSS.n2367 125.475
R4410 VSS.n7987 VSS.n2409 125.475
R4411 VSS.n7881 VSS.n2451 125.475
R4412 VSS.n7775 VSS.n2493 125.475
R4413 VSS.n7670 VSS.n7587 125.475
R4414 VSS.n9237 VSS.n8417 125.475
R4415 VSS.n9131 VSS.n8459 125.475
R4416 VSS.n9025 VSS.n8501 125.475
R4417 VSS.n8919 VSS.n8543 125.475
R4418 VSS.n8813 VSS.n8585 125.475
R4419 VSS.n8629 VSS.n8628 125.475
R4420 VSS.n9493 VSS.n9488 125.475
R4421 VSS.n9594 VSS.n9589 125.475
R4422 VSS.n9695 VSS.n9690 125.475
R4423 VSS.n9796 VSS.n9791 125.475
R4424 VSS.n9897 VSS.n9892 125.475
R4425 VSS.n10062 VSS.n1911 125.475
R4426 VSS.n10535 VSS.n10530 125.475
R4427 VSS.n10636 VSS.n10631 125.475
R4428 VSS.n10737 VSS.n10732 125.475
R4429 VSS.n10838 VSS.n10833 125.475
R4430 VSS.n10939 VSS.n10934 125.475
R4431 VSS.n11104 VSS.n10065 125.475
R4432 VSS.n11719 VSS.n1703 125.475
R4433 VSS.n11613 VSS.n1745 125.475
R4434 VSS.n11507 VSS.n1787 125.475
R4435 VSS.n11401 VSS.n1829 125.475
R4436 VSS.n11295 VSS.n1871 125.475
R4437 VSS.n11190 VSS.n11107 125.475
R4438 VSS.n12757 VSS.n11937 125.475
R4439 VSS.n12651 VSS.n11979 125.475
R4440 VSS.n12545 VSS.n12021 125.475
R4441 VSS.n12439 VSS.n12063 125.475
R4442 VSS.n12333 VSS.n12105 125.475
R4443 VSS.n12149 VSS.n12148 125.475
R4444 VSS.n13013 VSS.n13008 125.475
R4445 VSS.n13114 VSS.n13109 125.475
R4446 VSS.n13215 VSS.n13210 125.475
R4447 VSS.n13316 VSS.n13311 125.475
R4448 VSS.n13417 VSS.n13412 125.475
R4449 VSS.n13582 VSS.n1270 125.475
R4450 VSS.n14022 VSS.n14017 125.475
R4451 VSS.n14123 VSS.n14118 125.475
R4452 VSS.n14382 VSS.n14377 125.475
R4453 VSS.n14547 VSS.n13585 125.475
R4454 VSS.n14630 VSS.n14550 125.475
R4455 VSS.n405 VSS.n404 122.383
R4456 VSS.n423 VSS.n422 122.383
R4457 VSS.t3332 VSS.t212 118.008
R4458 VSS.t4266 VSS.n13653 116.876
R4459 VSS.n14900 VSS.t4333 116.876
R4460 VSS.t61 VSS.t3285 109.579
R4461 VSS.t3416 VSS.t35 101.15
R4462 VSS.t29 VSS.t3383 101.15
R4463 VSS.t3324 VSS.t3439 101.15
R4464 VSS.t158 VSS.t3340 92.7208
R4465 VSS.t3404 VSS.t249 75.8626
R4466 VSS.t215 VSS.t3423 75.8626
R4467 VSS.n1266 VSS.t4369 68.6994
R4468 VSS.n504 VSS.t4368 68.6994
R4469 VSS.n565 VSS.t4380 68.6994
R4470 VSS.t4379 VSS.n1037 68.6994
R4471 VSS.t4378 VSS.n1044 68.6994
R4472 VSS.n542 VSS.t4374 68.6994
R4473 VSS.n533 VSS.t4373 68.6994
R4474 VSS.t4370 VSS.n1206 68.6994
R4475 VSS.t4383 VSS.n923 68.6994
R4476 VSS.t4382 VSS.n930 68.6994
R4477 VSS.t4399 VSS.n299 68.6994
R4478 VSS.n647 VSS.t4398 68.6994
R4479 VSS.n626 VSS.t4393 68.6994
R4480 VSS.n617 VSS.t4392 68.6994
R4481 VSS.n606 VSS.t4390 68.6994
R4482 VSS.t4387 VSS.n810 68.6994
R4483 VSS.t4386 VSS.n817 68.6994
R4484 VSS.t3487 VSS.n4402 68.6994
R4485 VSS.n4357 VSS.t3491 68.6994
R4486 VSS.n4256 VSS.t3496 68.6994
R4487 VSS.n4155 VSS.t3501 68.6994
R4488 VSS.n4054 VSS.t3506 68.6994
R4489 VSS.n3953 VSS.t3511 68.6994
R4490 VSS.n3852 VSS.t3516 68.6994
R4491 VSS.n3730 VSS.t3554 68.6994
R4492 VSS.n3712 VSS.t3553 68.6994
R4493 VSS.n3696 VSS.t3551 68.6994
R4494 VSS.t3514 VSS.n3887 68.6994
R4495 VSS.n3900 VSS.t3550 68.6994
R4496 VSS.n3680 VSS.t3549 68.6994
R4497 VSS.n3662 VSS.t3548 68.6994
R4498 VSS.n3646 VSS.t3546 68.6994
R4499 VSS.t3509 VSS.n3988 68.6994
R4500 VSS.n4001 VSS.t3545 68.6994
R4501 VSS.n3630 VSS.t3544 68.6994
R4502 VSS.n3612 VSS.t3543 68.6994
R4503 VSS.n3596 VSS.t3541 68.6994
R4504 VSS.t3504 VSS.n4089 68.6994
R4505 VSS.n4102 VSS.t3540 68.6994
R4506 VSS.n3580 VSS.t3539 68.6994
R4507 VSS.n3562 VSS.t3538 68.6994
R4508 VSS.n3546 VSS.t3536 68.6994
R4509 VSS.t3499 VSS.n4190 68.6994
R4510 VSS.n4203 VSS.t3535 68.6994
R4511 VSS.n3530 VSS.t3534 68.6994
R4512 VSS.n3512 VSS.t3533 68.6994
R4513 VSS.n3496 VSS.t3531 68.6994
R4514 VSS.t3494 VSS.n4291 68.6994
R4515 VSS.n4304 VSS.t3530 68.6994
R4516 VSS.n3480 VSS.t3529 68.6994
R4517 VSS.n3462 VSS.t3528 68.6994
R4518 VSS.n4389 VSS.t3526 68.6994
R4519 VSS.t3489 VSS.n3441 68.6994
R4520 VSS.t3525 VSS.n3445 68.6994
R4521 VSS.t3524 VSS.n3450 68.6994
R4522 VSS.n3771 VSS.t3556 68.6994
R4523 VSS.n3761 VSS.t3522 68.6994
R4524 VSS.t3557 VSS.n5134 68.6994
R4525 VSS.n5220 VSS.t3561 68.6994
R4526 VSS.n5326 VSS.t3566 68.6994
R4527 VSS.n5432 VSS.t3571 68.6994
R4528 VSS.n5538 VSS.t3576 68.6994
R4529 VSS.n5644 VSS.t3581 68.6994
R4530 VSS.n5750 VSS.t3586 68.6994
R4531 VSS.n5789 VSS.t3624 68.6994
R4532 VSS.n5764 VSS.t3623 68.6994
R4533 VSS.n5730 VSS.t3621 68.6994
R4534 VSS.t3584 VSS.n4897 68.6994
R4535 VSS.t3620 VSS.n4901 68.6994
R4536 VSS.t3619 VSS.n4909 68.6994
R4537 VSS.n5658 VSS.t3618 68.6994
R4538 VSS.n5624 VSS.t3616 68.6994
R4539 VSS.t3579 VSS.n4939 68.6994
R4540 VSS.t3615 VSS.n4943 68.6994
R4541 VSS.t3614 VSS.n4951 68.6994
R4542 VSS.n5552 VSS.t3613 68.6994
R4543 VSS.n5518 VSS.t3611 68.6994
R4544 VSS.t3574 VSS.n4981 68.6994
R4545 VSS.t3610 VSS.n4985 68.6994
R4546 VSS.t3609 VSS.n4993 68.6994
R4547 VSS.n5446 VSS.t3608 68.6994
R4548 VSS.n5412 VSS.t3606 68.6994
R4549 VSS.t3569 VSS.n5023 68.6994
R4550 VSS.t3605 VSS.n5027 68.6994
R4551 VSS.t3604 VSS.n5035 68.6994
R4552 VSS.n5340 VSS.t3603 68.6994
R4553 VSS.n5306 VSS.t3601 68.6994
R4554 VSS.t3564 VSS.n5065 68.6994
R4555 VSS.t3600 VSS.n5069 68.6994
R4556 VSS.t3599 VSS.n5077 68.6994
R4557 VSS.n5234 VSS.t3598 68.6994
R4558 VSS.n5200 VSS.t3596 68.6994
R4559 VSS.n5108 VSS.t3559 68.6994
R4560 VSS.t3595 VSS.n5112 68.6994
R4561 VSS.t3594 VSS.n5118 68.6994
R4562 VSS.n5810 VSS.t3591 68.6994
R4563 VSS.n5805 VSS.t3625 68.6994
R4564 VSS.n5823 VSS.t3592 68.6994
R4565 VSS.n5818 VSS.t3626 68.6994
R4566 VSS.t3627 VSS.n6483 68.6994
R4567 VSS.n6438 VSS.t3631 68.6994
R4568 VSS.n6337 VSS.t3636 68.6994
R4569 VSS.n6236 VSS.t3641 68.6994
R4570 VSS.n6135 VSS.t3646 68.6994
R4571 VSS.n6034 VSS.t3651 68.6994
R4572 VSS.n5933 VSS.t3656 68.6994
R4573 VSS.n4753 VSS.t3694 68.6994
R4574 VSS.n4735 VSS.t3693 68.6994
R4575 VSS.n4719 VSS.t3691 68.6994
R4576 VSS.t3654 VSS.n5968 68.6994
R4577 VSS.n5981 VSS.t3690 68.6994
R4578 VSS.n4703 VSS.t3689 68.6994
R4579 VSS.n4685 VSS.t3688 68.6994
R4580 VSS.n4669 VSS.t3686 68.6994
R4581 VSS.t3649 VSS.n6069 68.6994
R4582 VSS.n6082 VSS.t3685 68.6994
R4583 VSS.n4653 VSS.t3684 68.6994
R4584 VSS.n4635 VSS.t3683 68.6994
R4585 VSS.n4619 VSS.t3681 68.6994
R4586 VSS.t3644 VSS.n6170 68.6994
R4587 VSS.n6183 VSS.t3680 68.6994
R4588 VSS.n4603 VSS.t3679 68.6994
R4589 VSS.n4585 VSS.t3678 68.6994
R4590 VSS.n4569 VSS.t3676 68.6994
R4591 VSS.t3639 VSS.n6271 68.6994
R4592 VSS.n6284 VSS.t3675 68.6994
R4593 VSS.n4553 VSS.t3674 68.6994
R4594 VSS.n4535 VSS.t3673 68.6994
R4595 VSS.n4519 VSS.t3671 68.6994
R4596 VSS.t3634 VSS.n6372 68.6994
R4597 VSS.n6385 VSS.t3670 68.6994
R4598 VSS.n4503 VSS.t3669 68.6994
R4599 VSS.n4485 VSS.t3668 68.6994
R4600 VSS.n6470 VSS.t3666 68.6994
R4601 VSS.t3629 VSS.n4464 68.6994
R4602 VSS.t3665 VSS.n4468 68.6994
R4603 VSS.t3664 VSS.n4473 68.6994
R4604 VSS.n4775 VSS.t3661 68.6994
R4605 VSS.n4819 VSS.t3695 68.6994
R4606 VSS.n4789 VSS.t3662 68.6994
R4607 VSS.n4797 VSS.t3696 68.6994
R4608 VSS.t3697 VSS.n7525 68.6994
R4609 VSS.n7480 VSS.t3701 68.6994
R4610 VSS.n7379 VSS.t3706 68.6994
R4611 VSS.n7278 VSS.t3711 68.6994
R4612 VSS.n7177 VSS.t3716 68.6994
R4613 VSS.n7076 VSS.t3721 68.6994
R4614 VSS.n6975 VSS.t3726 68.6994
R4615 VSS.n6834 VSS.t3764 68.6994
R4616 VSS.n6816 VSS.t3763 68.6994
R4617 VSS.n6800 VSS.t3761 68.6994
R4618 VSS.t3724 VSS.n7010 68.6994
R4619 VSS.n7023 VSS.t3760 68.6994
R4620 VSS.n6784 VSS.t3759 68.6994
R4621 VSS.n6766 VSS.t3758 68.6994
R4622 VSS.n6750 VSS.t3756 68.6994
R4623 VSS.t3719 VSS.n7111 68.6994
R4624 VSS.n7124 VSS.t3755 68.6994
R4625 VSS.n6734 VSS.t3754 68.6994
R4626 VSS.n6716 VSS.t3753 68.6994
R4627 VSS.n6700 VSS.t3751 68.6994
R4628 VSS.t3714 VSS.n7212 68.6994
R4629 VSS.n7225 VSS.t3750 68.6994
R4630 VSS.n6684 VSS.t3749 68.6994
R4631 VSS.n6666 VSS.t3748 68.6994
R4632 VSS.n6650 VSS.t3746 68.6994
R4633 VSS.t3709 VSS.n7313 68.6994
R4634 VSS.n7326 VSS.t3745 68.6994
R4635 VSS.n6634 VSS.t3744 68.6994
R4636 VSS.n6616 VSS.t3743 68.6994
R4637 VSS.n6600 VSS.t3741 68.6994
R4638 VSS.t3704 VSS.n7414 68.6994
R4639 VSS.n7427 VSS.t3740 68.6994
R4640 VSS.n6584 VSS.t3739 68.6994
R4641 VSS.n6566 VSS.t3738 68.6994
R4642 VSS.n7512 VSS.t3736 68.6994
R4643 VSS.t3699 VSS.n6545 68.6994
R4644 VSS.t3735 VSS.n6549 68.6994
R4645 VSS.t3734 VSS.n6554 68.6994
R4646 VSS.n6856 VSS.t3731 68.6994
R4647 VSS.n6900 VSS.t3765 68.6994
R4648 VSS.n6870 VSS.t3732 68.6994
R4649 VSS.n6878 VSS.t3766 68.6994
R4650 VSS.t3767 VSS.n7611 68.6994
R4651 VSS.n7702 VSS.t3771 68.6994
R4652 VSS.n7808 VSS.t3776 68.6994
R4653 VSS.n7914 VSS.t3781 68.6994
R4654 VSS.n8020 VSS.t3786 68.6994
R4655 VSS.n8126 VSS.t3791 68.6994
R4656 VSS.n8232 VSS.t3796 68.6994
R4657 VSS.n8271 VSS.t3834 68.6994
R4658 VSS.n8246 VSS.t3833 68.6994
R4659 VSS.n8212 VSS.t3831 68.6994
R4660 VSS.t3794 VSS.n2325 68.6994
R4661 VSS.t3830 VSS.n2329 68.6994
R4662 VSS.t3829 VSS.n2337 68.6994
R4663 VSS.n8140 VSS.t3828 68.6994
R4664 VSS.n8106 VSS.t3826 68.6994
R4665 VSS.t3789 VSS.n2367 68.6994
R4666 VSS.t3825 VSS.n2371 68.6994
R4667 VSS.t3824 VSS.n2379 68.6994
R4668 VSS.n8034 VSS.t3823 68.6994
R4669 VSS.n8000 VSS.t3821 68.6994
R4670 VSS.t3784 VSS.n2409 68.6994
R4671 VSS.t3820 VSS.n2413 68.6994
R4672 VSS.t3819 VSS.n2421 68.6994
R4673 VSS.n7928 VSS.t3818 68.6994
R4674 VSS.n7894 VSS.t3816 68.6994
R4675 VSS.t3779 VSS.n2451 68.6994
R4676 VSS.t3815 VSS.n2455 68.6994
R4677 VSS.t3814 VSS.n2463 68.6994
R4678 VSS.n7822 VSS.t3813 68.6994
R4679 VSS.n7788 VSS.t3811 68.6994
R4680 VSS.t3774 VSS.n2493 68.6994
R4681 VSS.t3810 VSS.n2497 68.6994
R4682 VSS.t3809 VSS.n2505 68.6994
R4683 VSS.n7716 VSS.t3808 68.6994
R4684 VSS.n7682 VSS.t3806 68.6994
R4685 VSS.t3769 VSS.n7587 68.6994
R4686 VSS.t3805 VSS.n7590 68.6994
R4687 VSS.t3804 VSS.n7595 68.6994
R4688 VSS.n8292 VSS.t3801 68.6994
R4689 VSS.n8287 VSS.t3835 68.6994
R4690 VSS.n8305 VSS.t3802 68.6994
R4691 VSS.n8300 VSS.t3836 68.6994
R4692 VSS.t3837 VSS.n8654 68.6994
R4693 VSS.n8740 VSS.t3841 68.6994
R4694 VSS.n8846 VSS.t3846 68.6994
R4695 VSS.n8952 VSS.t3851 68.6994
R4696 VSS.n9058 VSS.t3856 68.6994
R4697 VSS.n9164 VSS.t3861 68.6994
R4698 VSS.n9270 VSS.t3866 68.6994
R4699 VSS.n9309 VSS.t3904 68.6994
R4700 VSS.n9284 VSS.t3903 68.6994
R4701 VSS.n9250 VSS.t3901 68.6994
R4702 VSS.t3864 VSS.n8417 68.6994
R4703 VSS.t3900 VSS.n8421 68.6994
R4704 VSS.t3899 VSS.n8429 68.6994
R4705 VSS.n9178 VSS.t3898 68.6994
R4706 VSS.n9144 VSS.t3896 68.6994
R4707 VSS.t3859 VSS.n8459 68.6994
R4708 VSS.t3895 VSS.n8463 68.6994
R4709 VSS.t3894 VSS.n8471 68.6994
R4710 VSS.n9072 VSS.t3893 68.6994
R4711 VSS.n9038 VSS.t3891 68.6994
R4712 VSS.t3854 VSS.n8501 68.6994
R4713 VSS.t3890 VSS.n8505 68.6994
R4714 VSS.t3889 VSS.n8513 68.6994
R4715 VSS.n8966 VSS.t3888 68.6994
R4716 VSS.n8932 VSS.t3886 68.6994
R4717 VSS.t3849 VSS.n8543 68.6994
R4718 VSS.t3885 VSS.n8547 68.6994
R4719 VSS.t3884 VSS.n8555 68.6994
R4720 VSS.n8860 VSS.t3883 68.6994
R4721 VSS.n8826 VSS.t3881 68.6994
R4722 VSS.t3844 VSS.n8585 68.6994
R4723 VSS.t3880 VSS.n8589 68.6994
R4724 VSS.t3879 VSS.n8597 68.6994
R4725 VSS.n8754 VSS.t3878 68.6994
R4726 VSS.n8720 VSS.t3876 68.6994
R4727 VSS.n8628 VSS.t3839 68.6994
R4728 VSS.t3875 VSS.n8632 68.6994
R4729 VSS.t3874 VSS.n8638 68.6994
R4730 VSS.n9330 VSS.t3871 68.6994
R4731 VSS.n9325 VSS.t3905 68.6994
R4732 VSS.n9343 VSS.t3872 68.6994
R4733 VSS.n9338 VSS.t3906 68.6994
R4734 VSS.t3907 VSS.n10003 68.6994
R4735 VSS.n9958 VSS.t3911 68.6994
R4736 VSS.n9857 VSS.t3916 68.6994
R4737 VSS.n9756 VSS.t3921 68.6994
R4738 VSS.n9655 VSS.t3926 68.6994
R4739 VSS.n9554 VSS.t3931 68.6994
R4740 VSS.n9453 VSS.t3936 68.6994
R4741 VSS.n2200 VSS.t3974 68.6994
R4742 VSS.n2182 VSS.t3973 68.6994
R4743 VSS.n2166 VSS.t3971 68.6994
R4744 VSS.t3934 VSS.n9488 68.6994
R4745 VSS.n9501 VSS.t3970 68.6994
R4746 VSS.n2150 VSS.t3969 68.6994
R4747 VSS.n2132 VSS.t3968 68.6994
R4748 VSS.n2116 VSS.t3966 68.6994
R4749 VSS.t3929 VSS.n9589 68.6994
R4750 VSS.n9602 VSS.t3965 68.6994
R4751 VSS.n2100 VSS.t3964 68.6994
R4752 VSS.n2082 VSS.t3963 68.6994
R4753 VSS.n2066 VSS.t3961 68.6994
R4754 VSS.t3924 VSS.n9690 68.6994
R4755 VSS.n9703 VSS.t3960 68.6994
R4756 VSS.n2050 VSS.t3959 68.6994
R4757 VSS.n2032 VSS.t3958 68.6994
R4758 VSS.n2016 VSS.t3956 68.6994
R4759 VSS.t3919 VSS.n9791 68.6994
R4760 VSS.n9804 VSS.t3955 68.6994
R4761 VSS.n2000 VSS.t3954 68.6994
R4762 VSS.n1982 VSS.t3953 68.6994
R4763 VSS.n1966 VSS.t3951 68.6994
R4764 VSS.t3914 VSS.n9892 68.6994
R4765 VSS.n9905 VSS.t3950 68.6994
R4766 VSS.n1950 VSS.t3949 68.6994
R4767 VSS.n1932 VSS.t3948 68.6994
R4768 VSS.n9990 VSS.t3946 68.6994
R4769 VSS.t3909 VSS.n1911 68.6994
R4770 VSS.t3945 VSS.n1915 68.6994
R4771 VSS.t3944 VSS.n1920 68.6994
R4772 VSS.n2241 VSS.t3976 68.6994
R4773 VSS.n2231 VSS.t3942 68.6994
R4774 VSS.t3977 VSS.n11045 68.6994
R4775 VSS.n11000 VSS.t3981 68.6994
R4776 VSS.n10899 VSS.t3986 68.6994
R4777 VSS.n10798 VSS.t3991 68.6994
R4778 VSS.n10697 VSS.t3996 68.6994
R4779 VSS.n10596 VSS.t4001 68.6994
R4780 VSS.n10495 VSS.t4006 68.6994
R4781 VSS.n10354 VSS.t4044 68.6994
R4782 VSS.n10336 VSS.t4043 68.6994
R4783 VSS.n10320 VSS.t4041 68.6994
R4784 VSS.t4004 VSS.n10530 68.6994
R4785 VSS.n10543 VSS.t4040 68.6994
R4786 VSS.n10304 VSS.t4039 68.6994
R4787 VSS.n10286 VSS.t4038 68.6994
R4788 VSS.n10270 VSS.t4036 68.6994
R4789 VSS.t3999 VSS.n10631 68.6994
R4790 VSS.n10644 VSS.t4035 68.6994
R4791 VSS.n10254 VSS.t4034 68.6994
R4792 VSS.n10236 VSS.t4033 68.6994
R4793 VSS.n10220 VSS.t4031 68.6994
R4794 VSS.t3994 VSS.n10732 68.6994
R4795 VSS.n10745 VSS.t4030 68.6994
R4796 VSS.n10204 VSS.t4029 68.6994
R4797 VSS.n10186 VSS.t4028 68.6994
R4798 VSS.n10170 VSS.t4026 68.6994
R4799 VSS.t3989 VSS.n10833 68.6994
R4800 VSS.n10846 VSS.t4025 68.6994
R4801 VSS.n10154 VSS.t4024 68.6994
R4802 VSS.n10136 VSS.t4023 68.6994
R4803 VSS.n10120 VSS.t4021 68.6994
R4804 VSS.t3984 VSS.n10934 68.6994
R4805 VSS.n10947 VSS.t4020 68.6994
R4806 VSS.n10104 VSS.t4019 68.6994
R4807 VSS.n10086 VSS.t4018 68.6994
R4808 VSS.n11032 VSS.t4016 68.6994
R4809 VSS.t3979 VSS.n10065 68.6994
R4810 VSS.t4015 VSS.n10069 68.6994
R4811 VSS.t4014 VSS.n10074 68.6994
R4812 VSS.n10376 VSS.t4011 68.6994
R4813 VSS.n10420 VSS.t4045 68.6994
R4814 VSS.n10390 VSS.t4012 68.6994
R4815 VSS.n10398 VSS.t4046 68.6994
R4816 VSS.t4047 VSS.n11131 68.6994
R4817 VSS.n11222 VSS.t4051 68.6994
R4818 VSS.n11328 VSS.t4056 68.6994
R4819 VSS.n11434 VSS.t4061 68.6994
R4820 VSS.n11540 VSS.t4066 68.6994
R4821 VSS.n11646 VSS.t4071 68.6994
R4822 VSS.n11752 VSS.t4076 68.6994
R4823 VSS.n11791 VSS.t4114 68.6994
R4824 VSS.n11766 VSS.t4113 68.6994
R4825 VSS.n11732 VSS.t4111 68.6994
R4826 VSS.t4074 VSS.n1703 68.6994
R4827 VSS.t4110 VSS.n1707 68.6994
R4828 VSS.t4109 VSS.n1715 68.6994
R4829 VSS.n11660 VSS.t4108 68.6994
R4830 VSS.n11626 VSS.t4106 68.6994
R4831 VSS.t4069 VSS.n1745 68.6994
R4832 VSS.t4105 VSS.n1749 68.6994
R4833 VSS.t4104 VSS.n1757 68.6994
R4834 VSS.n11554 VSS.t4103 68.6994
R4835 VSS.n11520 VSS.t4101 68.6994
R4836 VSS.t4064 VSS.n1787 68.6994
R4837 VSS.t4100 VSS.n1791 68.6994
R4838 VSS.t4099 VSS.n1799 68.6994
R4839 VSS.n11448 VSS.t4098 68.6994
R4840 VSS.n11414 VSS.t4096 68.6994
R4841 VSS.t4059 VSS.n1829 68.6994
R4842 VSS.t4095 VSS.n1833 68.6994
R4843 VSS.t4094 VSS.n1841 68.6994
R4844 VSS.n11342 VSS.t4093 68.6994
R4845 VSS.n11308 VSS.t4091 68.6994
R4846 VSS.t4054 VSS.n1871 68.6994
R4847 VSS.t4090 VSS.n1875 68.6994
R4848 VSS.t4089 VSS.n1883 68.6994
R4849 VSS.n11236 VSS.t4088 68.6994
R4850 VSS.n11202 VSS.t4086 68.6994
R4851 VSS.t4049 VSS.n11107 68.6994
R4852 VSS.t4085 VSS.n11110 68.6994
R4853 VSS.t4084 VSS.n11115 68.6994
R4854 VSS.n11812 VSS.t4081 68.6994
R4855 VSS.n11807 VSS.t4115 68.6994
R4856 VSS.n11825 VSS.t4082 68.6994
R4857 VSS.n11820 VSS.t4116 68.6994
R4858 VSS.t4117 VSS.n12174 68.6994
R4859 VSS.n12260 VSS.t4121 68.6994
R4860 VSS.n12366 VSS.t4126 68.6994
R4861 VSS.n12472 VSS.t4131 68.6994
R4862 VSS.n12578 VSS.t4136 68.6994
R4863 VSS.n12684 VSS.t4141 68.6994
R4864 VSS.n12790 VSS.t4146 68.6994
R4865 VSS.n12829 VSS.t4184 68.6994
R4866 VSS.n12804 VSS.t4183 68.6994
R4867 VSS.n12770 VSS.t4181 68.6994
R4868 VSS.t4144 VSS.n11937 68.6994
R4869 VSS.t4180 VSS.n11941 68.6994
R4870 VSS.t4179 VSS.n11949 68.6994
R4871 VSS.n12698 VSS.t4178 68.6994
R4872 VSS.n12664 VSS.t4176 68.6994
R4873 VSS.t4139 VSS.n11979 68.6994
R4874 VSS.t4175 VSS.n11983 68.6994
R4875 VSS.t4174 VSS.n11991 68.6994
R4876 VSS.n12592 VSS.t4173 68.6994
R4877 VSS.n12558 VSS.t4171 68.6994
R4878 VSS.t4134 VSS.n12021 68.6994
R4879 VSS.t4170 VSS.n12025 68.6994
R4880 VSS.t4169 VSS.n12033 68.6994
R4881 VSS.n12486 VSS.t4168 68.6994
R4882 VSS.n12452 VSS.t4166 68.6994
R4883 VSS.t4129 VSS.n12063 68.6994
R4884 VSS.t4165 VSS.n12067 68.6994
R4885 VSS.t4164 VSS.n12075 68.6994
R4886 VSS.n12380 VSS.t4163 68.6994
R4887 VSS.n12346 VSS.t4161 68.6994
R4888 VSS.t4124 VSS.n12105 68.6994
R4889 VSS.t4160 VSS.n12109 68.6994
R4890 VSS.t4159 VSS.n12117 68.6994
R4891 VSS.n12274 VSS.t4158 68.6994
R4892 VSS.n12240 VSS.t4156 68.6994
R4893 VSS.n12148 VSS.t4119 68.6994
R4894 VSS.t4155 VSS.n12152 68.6994
R4895 VSS.t4154 VSS.n12158 68.6994
R4896 VSS.n12850 VSS.t4151 68.6994
R4897 VSS.n12845 VSS.t4185 68.6994
R4898 VSS.n12863 VSS.t4152 68.6994
R4899 VSS.n12858 VSS.t4186 68.6994
R4900 VSS.t4187 VSS.n13523 68.6994
R4901 VSS.n13478 VSS.t4191 68.6994
R4902 VSS.n13377 VSS.t4196 68.6994
R4903 VSS.n13276 VSS.t4201 68.6994
R4904 VSS.n13175 VSS.t4206 68.6994
R4905 VSS.n13074 VSS.t4211 68.6994
R4906 VSS.n12973 VSS.t4216 68.6994
R4907 VSS.n1559 VSS.t4254 68.6994
R4908 VSS.n1541 VSS.t4253 68.6994
R4909 VSS.n1525 VSS.t4251 68.6994
R4910 VSS.t4214 VSS.n13008 68.6994
R4911 VSS.n13021 VSS.t4250 68.6994
R4912 VSS.n1509 VSS.t4249 68.6994
R4913 VSS.n1491 VSS.t4248 68.6994
R4914 VSS.n1475 VSS.t4246 68.6994
R4915 VSS.t4209 VSS.n13109 68.6994
R4916 VSS.n13122 VSS.t4245 68.6994
R4917 VSS.n1459 VSS.t4244 68.6994
R4918 VSS.n1441 VSS.t4243 68.6994
R4919 VSS.n1425 VSS.t4241 68.6994
R4920 VSS.t4204 VSS.n13210 68.6994
R4921 VSS.n13223 VSS.t4240 68.6994
R4922 VSS.n1409 VSS.t4239 68.6994
R4923 VSS.n1391 VSS.t4238 68.6994
R4924 VSS.n1375 VSS.t4236 68.6994
R4925 VSS.t4199 VSS.n13311 68.6994
R4926 VSS.n13324 VSS.t4235 68.6994
R4927 VSS.n1359 VSS.t4234 68.6994
R4928 VSS.n1341 VSS.t4233 68.6994
R4929 VSS.n1325 VSS.t4231 68.6994
R4930 VSS.t4194 VSS.n13412 68.6994
R4931 VSS.n13425 VSS.t4230 68.6994
R4932 VSS.n1309 VSS.t4229 68.6994
R4933 VSS.n1291 VSS.t4228 68.6994
R4934 VSS.n13510 VSS.t4226 68.6994
R4935 VSS.t4189 VSS.n1270 68.6994
R4936 VSS.t4225 VSS.n1274 68.6994
R4937 VSS.t4224 VSS.n1279 68.6994
R4938 VSS.n1581 VSS.t4221 68.6994
R4939 VSS.n1625 VSS.t4255 68.6994
R4940 VSS.n1595 VSS.t4222 68.6994
R4941 VSS.n1603 VSS.t4256 68.6994
R4942 VSS.t4257 VSS.n14488 68.6994
R4943 VSS.n14443 VSS.t4261 68.6994
R4944 VSS.n14193 VSS.t4276 68.6994
R4945 VSS.n14083 VSS.t4280 68.6994
R4946 VSS.n13982 VSS.t4285 68.6994
R4947 VSS.n13841 VSS.t4318 68.6994
R4948 VSS.n13823 VSS.t4317 68.6994
R4949 VSS.n13807 VSS.t4315 68.6994
R4950 VSS.t4283 VSS.n14017 68.6994
R4951 VSS.n14030 VSS.t4314 68.6994
R4952 VSS.n13791 VSS.t4313 68.6994
R4953 VSS.n13773 VSS.t4312 68.6994
R4954 VSS.n13757 VSS.t4310 68.6994
R4955 VSS.t4278 VSS.n14118 68.6994
R4956 VSS.n14131 VSS.t4309 68.6994
R4957 VSS.n14207 VSS.t4308 68.6994
R4958 VSS.n14172 VSS.t4275 68.6994
R4959 VSS.n14224 VSS.t4305 68.6994
R4960 VSS.n13716 VSS.t4271 68.6994
R4961 VSS.n13703 VSS.t4270 68.6994
R4962 VSS.n13662 VSS.t4267 68.6994
R4963 VSS.n14347 VSS.t4301 68.6994
R4964 VSS.n13640 VSS.t4300 68.6994
R4965 VSS.t4264 VSS.n14377 68.6994
R4966 VSS.n14390 VSS.t4299 68.6994
R4967 VSS.n13624 VSS.t4298 68.6994
R4968 VSS.n13606 VSS.t4297 68.6994
R4969 VSS.n14475 VSS.t4295 68.6994
R4970 VSS.t4259 VSS.n13585 68.6994
R4971 VSS.t4294 VSS.n13589 68.6994
R4972 VSS.t4293 VSS.n13594 68.6994
R4973 VSS.n13863 VSS.t4290 68.6994
R4974 VSS.n13907 VSS.t4319 68.6994
R4975 VSS.n13877 VSS.t4291 68.6994
R4976 VSS.n13885 VSS.t4320 68.6994
R4977 VSS.t4321 VSS.n14571 68.6994
R4978 VSS.n14662 VSS.t4325 68.6994
R4979 VSS.t4353 VSS.n395 68.6994
R4980 VSS.n405 VSS.t4328 68.6994
R4981 VSS.t4352 VSS.n413 68.6994
R4982 VSS.n423 VSS.t4327 68.6994
R4983 VSS.t4351 VSS.n431 68.6994
R4984 VSS.n14676 VSS.t4350 68.6994
R4985 VSS.n14642 VSS.t4348 68.6994
R4986 VSS.t4323 VSS.n14550 68.6994
R4987 VSS.t4347 VSS.n14553 68.6994
R4988 VSS.t4346 VSS.n14558 68.6994
R4989 VSS.n14986 VSS.t4335 68.6994
R4990 VSS.t4362 VSS.n322 68.6994
R4991 VSS.n14960 VSS.t4334 68.6994
R4992 VSS.t4361 VSS.n330 68.6994
R4993 VSS.t4360 VSS.n336 68.6994
R4994 VSS.n15085 VSS.t4339 68.6994
R4995 VSS.t4341 VSS.n301 68.6994
R4996 VSS.n15159 VSS.t4343 68.6994
R4997 VSS.n15203 VSS.t4363 68.6994
R4998 VSS.n15173 VSS.t4344 68.6994
R4999 VSS.n15181 VSS.t4364 68.6994
R5000 VSS.n249 VSS.t4400 68.6994
R5001 VSS.n2888 VSS.t3482 68.6994
R5002 VSS.n236 VSS.t3483 68.6994
R5003 VSS.n15325 VSS.t3484 68.6994
R5004 VSS.n15303 VSS.t3485 68.6994
R5005 VSS.t3444 VSS.n2544 68.6994
R5006 VSS.n3437 VSS.t3447 68.6994
R5007 VSS.n2584 VSS.t3446 68.6994
R5008 VSS.t3450 VSS.n2611 68.6994
R5009 VSS.t3449 VSS.n2618 68.6994
R5010 VSS.n2691 VSS.t3453 68.6994
R5011 VSS.n2682 VSS.t3452 68.6994
R5012 VSS.n2711 VSS.t3456 68.6994
R5013 VSS.n2702 VSS.t3455 68.6994
R5014 VSS.n2731 VSS.t3459 68.6994
R5015 VSS.n2722 VSS.t3458 68.6994
R5016 VSS.n2751 VSS.t3462 68.6994
R5017 VSS.n2742 VSS.t3461 68.6994
R5018 VSS.n2771 VSS.t3465 68.6994
R5019 VSS.n2762 VSS.t3464 68.6994
R5020 VSS.n2791 VSS.t3468 68.6994
R5021 VSS.n2782 VSS.t3467 68.6994
R5022 VSS.n2811 VSS.t3471 68.6994
R5023 VSS.n2802 VSS.t3470 68.6994
R5024 VSS.n2831 VSS.t3474 68.6994
R5025 VSS.n2822 VSS.t3473 68.6994
R5026 VSS.n2851 VSS.t3477 68.6994
R5027 VSS.n2842 VSS.t3476 68.6994
R5028 VSS.n2871 VSS.t3480 68.6994
R5029 VSS.n2862 VSS.t3479 68.6994
R5030 VSS.t126 VSS.t3428 67.4335
R5031 VSS.t3348 VSS.t120 67.4335
R5032 VSS.t200 VSS.t700 67.4335
R5033 VSS.t192 VSS.t3249 67.4335
R5034 VSS.t3417 VSS.t47 67.4335
R5035 VSS.t3365 VSS.t128 67.4335
R5036 VSS.t3389 VSS.t152 67.4335
R5037 VSS.t221 VSS.t3402 67.4335
R5038 VSS.t142 VSS.t3441 67.4335
R5039 VSS.n1267 VSS.n461 62.9556
R5040 VSS.n511 VSS.n510 62.9556
R5041 VSS.n1022 VSS.n1021 62.9556
R5042 VSS.n1091 VSS.n1090 62.9556
R5043 VSS.n1067 VSS.n1066 62.9556
R5044 VSS.n1159 VSS.n1158 62.9556
R5045 VSS.n1182 VSS.n1181 62.9556
R5046 VSS.n1232 VSS.n1231 62.9556
R5047 VSS.n976 VSS.n975 62.9556
R5048 VSS.n952 VSS.n951 62.9556
R5049 VSS.n15242 VSS.n15241 62.9556
R5050 VSS.n654 VSS.n653 62.9556
R5051 VSS.n720 VSS.n719 62.9556
R5052 VSS.n743 VSS.n742 62.9556
R5053 VSS.n772 VSS.n771 62.9556
R5054 VSS.n864 VSS.n863 62.9556
R5055 VSS.n840 VSS.n839 62.9556
R5056 VSS.n4420 VSS.n4419 62.9556
R5057 VSS.n4358 VSS.n3458 62.9556
R5058 VSS.n4257 VSS.n3508 62.9556
R5059 VSS.n4156 VSS.n3558 62.9556
R5060 VSS.n4055 VSS.n3608 62.9556
R5061 VSS.n3954 VSS.n3658 62.9556
R5062 VSS.n3853 VSS.n3708 62.9556
R5063 VSS.n3729 VSS.n3728 62.9556
R5064 VSS.n3844 VSS.n3843 62.9556
R5065 VSS.n3879 VSS.n3878 62.9556
R5066 VSS.n3889 VSS.n3888 62.9556
R5067 VSS.n3901 VSS.n3690 62.9556
R5068 VSS.n3679 VSS.n3678 62.9556
R5069 VSS.n3945 VSS.n3944 62.9556
R5070 VSS.n3980 VSS.n3979 62.9556
R5071 VSS.n3990 VSS.n3989 62.9556
R5072 VSS.n4002 VSS.n3640 62.9556
R5073 VSS.n3629 VSS.n3628 62.9556
R5074 VSS.n4046 VSS.n4045 62.9556
R5075 VSS.n4081 VSS.n4080 62.9556
R5076 VSS.n4091 VSS.n4090 62.9556
R5077 VSS.n4103 VSS.n3590 62.9556
R5078 VSS.n3579 VSS.n3578 62.9556
R5079 VSS.n4147 VSS.n4146 62.9556
R5080 VSS.n4182 VSS.n4181 62.9556
R5081 VSS.n4192 VSS.n4191 62.9556
R5082 VSS.n4204 VSS.n3540 62.9556
R5083 VSS.n3529 VSS.n3528 62.9556
R5084 VSS.n4248 VSS.n4247 62.9556
R5085 VSS.n4283 VSS.n4282 62.9556
R5086 VSS.n4293 VSS.n4292 62.9556
R5087 VSS.n4305 VSS.n3490 62.9556
R5088 VSS.n3479 VSS.n3478 62.9556
R5089 VSS.n4349 VSS.n4348 62.9556
R5090 VSS.n4388 VSS.n4377 62.9556
R5091 VSS.n3444 VSS.n3443 62.9556
R5092 VSS.n4453 VSS.n4452 62.9556
R5093 VSS.n4433 VSS.n4432 62.9556
R5094 VSS.n3772 VSS.n3751 62.9556
R5095 VSS.n3762 VSS.n3753 62.9556
R5096 VSS.n5152 VSS.n5151 62.9556
R5097 VSS.n5221 VSS.n5219 62.9556
R5098 VSS.n5327 VSS.n5325 62.9556
R5099 VSS.n5433 VSS.n5431 62.9556
R5100 VSS.n5539 VSS.n5537 62.9556
R5101 VSS.n5645 VSS.n5643 62.9556
R5102 VSS.n5751 VSS.n5749 62.9556
R5103 VSS.n5788 VSS.n5787 62.9556
R5104 VSS.n5763 VSS.n5762 62.9556
R5105 VSS.n5729 VSS.n4892 62.9556
R5106 VSS.n4899 VSS.n4898 62.9556
R5107 VSS.n5705 VSS.n5704 62.9556
R5108 VSS.n5681 VSS.n5680 62.9556
R5109 VSS.n5657 VSS.n5656 62.9556
R5110 VSS.n5623 VSS.n4934 62.9556
R5111 VSS.n4941 VSS.n4940 62.9556
R5112 VSS.n5599 VSS.n5598 62.9556
R5113 VSS.n5575 VSS.n5574 62.9556
R5114 VSS.n5551 VSS.n5550 62.9556
R5115 VSS.n5517 VSS.n4976 62.9556
R5116 VSS.n4983 VSS.n4982 62.9556
R5117 VSS.n5493 VSS.n5492 62.9556
R5118 VSS.n5469 VSS.n5468 62.9556
R5119 VSS.n5445 VSS.n5444 62.9556
R5120 VSS.n5411 VSS.n5018 62.9556
R5121 VSS.n5025 VSS.n5024 62.9556
R5122 VSS.n5387 VSS.n5386 62.9556
R5123 VSS.n5363 VSS.n5362 62.9556
R5124 VSS.n5339 VSS.n5338 62.9556
R5125 VSS.n5305 VSS.n5060 62.9556
R5126 VSS.n5067 VSS.n5066 62.9556
R5127 VSS.n5281 VSS.n5280 62.9556
R5128 VSS.n5257 VSS.n5256 62.9556
R5129 VSS.n5233 VSS.n5232 62.9556
R5130 VSS.n5199 VSS.n5102 62.9556
R5131 VSS.n5107 VSS.n5105 62.9556
R5132 VSS.n5184 VSS.n5183 62.9556
R5133 VSS.n5165 VSS.n5164 62.9556
R5134 VSS.n5806 VSS.n5803 62.9556
R5135 VSS.n5857 VSS.n5856 62.9556
R5136 VSS.n5819 VSS.n5816 62.9556
R5137 VSS.n5834 VSS.n5833 62.9556
R5138 VSS.n6501 VSS.n6500 62.9556
R5139 VSS.n6439 VSS.n4481 62.9556
R5140 VSS.n6338 VSS.n4531 62.9556
R5141 VSS.n6237 VSS.n4581 62.9556
R5142 VSS.n6136 VSS.n4631 62.9556
R5143 VSS.n6035 VSS.n4681 62.9556
R5144 VSS.n5934 VSS.n4731 62.9556
R5145 VSS.n4752 VSS.n4751 62.9556
R5146 VSS.n5925 VSS.n5924 62.9556
R5147 VSS.n5960 VSS.n5959 62.9556
R5148 VSS.n5970 VSS.n5969 62.9556
R5149 VSS.n5982 VSS.n4713 62.9556
R5150 VSS.n4702 VSS.n4701 62.9556
R5151 VSS.n6026 VSS.n6025 62.9556
R5152 VSS.n6061 VSS.n6060 62.9556
R5153 VSS.n6071 VSS.n6070 62.9556
R5154 VSS.n6083 VSS.n4663 62.9556
R5155 VSS.n4652 VSS.n4651 62.9556
R5156 VSS.n6127 VSS.n6126 62.9556
R5157 VSS.n6162 VSS.n6161 62.9556
R5158 VSS.n6172 VSS.n6171 62.9556
R5159 VSS.n6184 VSS.n4613 62.9556
R5160 VSS.n4602 VSS.n4601 62.9556
R5161 VSS.n6228 VSS.n6227 62.9556
R5162 VSS.n6263 VSS.n6262 62.9556
R5163 VSS.n6273 VSS.n6272 62.9556
R5164 VSS.n6285 VSS.n4563 62.9556
R5165 VSS.n4552 VSS.n4551 62.9556
R5166 VSS.n6329 VSS.n6328 62.9556
R5167 VSS.n6364 VSS.n6363 62.9556
R5168 VSS.n6374 VSS.n6373 62.9556
R5169 VSS.n6386 VSS.n4513 62.9556
R5170 VSS.n4502 VSS.n4501 62.9556
R5171 VSS.n6430 VSS.n6429 62.9556
R5172 VSS.n6469 VSS.n6458 62.9556
R5173 VSS.n4467 VSS.n4466 62.9556
R5174 VSS.n6534 VSS.n6533 62.9556
R5175 VSS.n6514 VSS.n6513 62.9556
R5176 VSS.n4774 VSS.n4770 62.9556
R5177 VSS.n4820 VSS.n4772 62.9556
R5178 VSS.n4788 VSS.n4784 62.9556
R5179 VSS.n4798 VSS.n4786 62.9556
R5180 VSS.n7543 VSS.n7542 62.9556
R5181 VSS.n7481 VSS.n6562 62.9556
R5182 VSS.n7380 VSS.n6612 62.9556
R5183 VSS.n7279 VSS.n6662 62.9556
R5184 VSS.n7178 VSS.n6712 62.9556
R5185 VSS.n7077 VSS.n6762 62.9556
R5186 VSS.n6976 VSS.n6812 62.9556
R5187 VSS.n6833 VSS.n6832 62.9556
R5188 VSS.n6967 VSS.n6966 62.9556
R5189 VSS.n7002 VSS.n7001 62.9556
R5190 VSS.n7012 VSS.n7011 62.9556
R5191 VSS.n7024 VSS.n6794 62.9556
R5192 VSS.n6783 VSS.n6782 62.9556
R5193 VSS.n7068 VSS.n7067 62.9556
R5194 VSS.n7103 VSS.n7102 62.9556
R5195 VSS.n7113 VSS.n7112 62.9556
R5196 VSS.n7125 VSS.n6744 62.9556
R5197 VSS.n6733 VSS.n6732 62.9556
R5198 VSS.n7169 VSS.n7168 62.9556
R5199 VSS.n7204 VSS.n7203 62.9556
R5200 VSS.n7214 VSS.n7213 62.9556
R5201 VSS.n7226 VSS.n6694 62.9556
R5202 VSS.n6683 VSS.n6682 62.9556
R5203 VSS.n7270 VSS.n7269 62.9556
R5204 VSS.n7305 VSS.n7304 62.9556
R5205 VSS.n7315 VSS.n7314 62.9556
R5206 VSS.n7327 VSS.n6644 62.9556
R5207 VSS.n6633 VSS.n6632 62.9556
R5208 VSS.n7371 VSS.n7370 62.9556
R5209 VSS.n7406 VSS.n7405 62.9556
R5210 VSS.n7416 VSS.n7415 62.9556
R5211 VSS.n7428 VSS.n6594 62.9556
R5212 VSS.n6583 VSS.n6582 62.9556
R5213 VSS.n7472 VSS.n7471 62.9556
R5214 VSS.n7511 VSS.n7500 62.9556
R5215 VSS.n6548 VSS.n6547 62.9556
R5216 VSS.n7576 VSS.n7575 62.9556
R5217 VSS.n7556 VSS.n7555 62.9556
R5218 VSS.n6855 VSS.n6851 62.9556
R5219 VSS.n6901 VSS.n6853 62.9556
R5220 VSS.n6869 VSS.n6865 62.9556
R5221 VSS.n6879 VSS.n6867 62.9556
R5222 VSS.n7629 VSS.n7628 62.9556
R5223 VSS.n7703 VSS.n7701 62.9556
R5224 VSS.n7809 VSS.n7807 62.9556
R5225 VSS.n7915 VSS.n7913 62.9556
R5226 VSS.n8021 VSS.n8019 62.9556
R5227 VSS.n8127 VSS.n8125 62.9556
R5228 VSS.n8233 VSS.n8231 62.9556
R5229 VSS.n8270 VSS.n8269 62.9556
R5230 VSS.n8245 VSS.n8244 62.9556
R5231 VSS.n8211 VSS.n2320 62.9556
R5232 VSS.n2327 VSS.n2326 62.9556
R5233 VSS.n8187 VSS.n8186 62.9556
R5234 VSS.n8163 VSS.n8162 62.9556
R5235 VSS.n8139 VSS.n8138 62.9556
R5236 VSS.n8105 VSS.n2362 62.9556
R5237 VSS.n2369 VSS.n2368 62.9556
R5238 VSS.n8081 VSS.n8080 62.9556
R5239 VSS.n8057 VSS.n8056 62.9556
R5240 VSS.n8033 VSS.n8032 62.9556
R5241 VSS.n7999 VSS.n2404 62.9556
R5242 VSS.n2411 VSS.n2410 62.9556
R5243 VSS.n7975 VSS.n7974 62.9556
R5244 VSS.n7951 VSS.n7950 62.9556
R5245 VSS.n7927 VSS.n7926 62.9556
R5246 VSS.n7893 VSS.n2446 62.9556
R5247 VSS.n2453 VSS.n2452 62.9556
R5248 VSS.n7869 VSS.n7868 62.9556
R5249 VSS.n7845 VSS.n7844 62.9556
R5250 VSS.n7821 VSS.n7820 62.9556
R5251 VSS.n7787 VSS.n2488 62.9556
R5252 VSS.n2495 VSS.n2494 62.9556
R5253 VSS.n7763 VSS.n7762 62.9556
R5254 VSS.n7739 VSS.n7738 62.9556
R5255 VSS.n7715 VSS.n7714 62.9556
R5256 VSS.n7681 VSS.n2530 62.9556
R5257 VSS.n7589 VSS.n7588 62.9556
R5258 VSS.n7662 VSS.n7661 62.9556
R5259 VSS.n7642 VSS.n7641 62.9556
R5260 VSS.n8288 VSS.n8285 62.9556
R5261 VSS.n8339 VSS.n8338 62.9556
R5262 VSS.n8301 VSS.n8298 62.9556
R5263 VSS.n8316 VSS.n8315 62.9556
R5264 VSS.n8672 VSS.n8671 62.9556
R5265 VSS.n8741 VSS.n8739 62.9556
R5266 VSS.n8847 VSS.n8845 62.9556
R5267 VSS.n8953 VSS.n8951 62.9556
R5268 VSS.n9059 VSS.n9057 62.9556
R5269 VSS.n9165 VSS.n9163 62.9556
R5270 VSS.n9271 VSS.n9269 62.9556
R5271 VSS.n9308 VSS.n9307 62.9556
R5272 VSS.n9283 VSS.n9282 62.9556
R5273 VSS.n9249 VSS.n8412 62.9556
R5274 VSS.n8419 VSS.n8418 62.9556
R5275 VSS.n9225 VSS.n9224 62.9556
R5276 VSS.n9201 VSS.n9200 62.9556
R5277 VSS.n9177 VSS.n9176 62.9556
R5278 VSS.n9143 VSS.n8454 62.9556
R5279 VSS.n8461 VSS.n8460 62.9556
R5280 VSS.n9119 VSS.n9118 62.9556
R5281 VSS.n9095 VSS.n9094 62.9556
R5282 VSS.n9071 VSS.n9070 62.9556
R5283 VSS.n9037 VSS.n8496 62.9556
R5284 VSS.n8503 VSS.n8502 62.9556
R5285 VSS.n9013 VSS.n9012 62.9556
R5286 VSS.n8989 VSS.n8988 62.9556
R5287 VSS.n8965 VSS.n8964 62.9556
R5288 VSS.n8931 VSS.n8538 62.9556
R5289 VSS.n8545 VSS.n8544 62.9556
R5290 VSS.n8907 VSS.n8906 62.9556
R5291 VSS.n8883 VSS.n8882 62.9556
R5292 VSS.n8859 VSS.n8858 62.9556
R5293 VSS.n8825 VSS.n8580 62.9556
R5294 VSS.n8587 VSS.n8586 62.9556
R5295 VSS.n8801 VSS.n8800 62.9556
R5296 VSS.n8777 VSS.n8776 62.9556
R5297 VSS.n8753 VSS.n8752 62.9556
R5298 VSS.n8719 VSS.n8622 62.9556
R5299 VSS.n8627 VSS.n8625 62.9556
R5300 VSS.n8704 VSS.n8703 62.9556
R5301 VSS.n8685 VSS.n8684 62.9556
R5302 VSS.n9326 VSS.n9323 62.9556
R5303 VSS.n9377 VSS.n9376 62.9556
R5304 VSS.n9339 VSS.n9336 62.9556
R5305 VSS.n9354 VSS.n9353 62.9556
R5306 VSS.n10021 VSS.n10020 62.9556
R5307 VSS.n9959 VSS.n1928 62.9556
R5308 VSS.n9858 VSS.n1978 62.9556
R5309 VSS.n9757 VSS.n2028 62.9556
R5310 VSS.n9656 VSS.n2078 62.9556
R5311 VSS.n9555 VSS.n2128 62.9556
R5312 VSS.n9454 VSS.n2178 62.9556
R5313 VSS.n2199 VSS.n2198 62.9556
R5314 VSS.n9445 VSS.n9444 62.9556
R5315 VSS.n9480 VSS.n9479 62.9556
R5316 VSS.n9490 VSS.n9489 62.9556
R5317 VSS.n9502 VSS.n2160 62.9556
R5318 VSS.n2149 VSS.n2148 62.9556
R5319 VSS.n9546 VSS.n9545 62.9556
R5320 VSS.n9581 VSS.n9580 62.9556
R5321 VSS.n9591 VSS.n9590 62.9556
R5322 VSS.n9603 VSS.n2110 62.9556
R5323 VSS.n2099 VSS.n2098 62.9556
R5324 VSS.n9647 VSS.n9646 62.9556
R5325 VSS.n9682 VSS.n9681 62.9556
R5326 VSS.n9692 VSS.n9691 62.9556
R5327 VSS.n9704 VSS.n2060 62.9556
R5328 VSS.n2049 VSS.n2048 62.9556
R5329 VSS.n9748 VSS.n9747 62.9556
R5330 VSS.n9783 VSS.n9782 62.9556
R5331 VSS.n9793 VSS.n9792 62.9556
R5332 VSS.n9805 VSS.n2010 62.9556
R5333 VSS.n1999 VSS.n1998 62.9556
R5334 VSS.n9849 VSS.n9848 62.9556
R5335 VSS.n9884 VSS.n9883 62.9556
R5336 VSS.n9894 VSS.n9893 62.9556
R5337 VSS.n9906 VSS.n1960 62.9556
R5338 VSS.n1949 VSS.n1948 62.9556
R5339 VSS.n9950 VSS.n9949 62.9556
R5340 VSS.n9989 VSS.n9978 62.9556
R5341 VSS.n1914 VSS.n1913 62.9556
R5342 VSS.n10054 VSS.n10053 62.9556
R5343 VSS.n10034 VSS.n10033 62.9556
R5344 VSS.n2242 VSS.n2221 62.9556
R5345 VSS.n2232 VSS.n2223 62.9556
R5346 VSS.n11063 VSS.n11062 62.9556
R5347 VSS.n11001 VSS.n10082 62.9556
R5348 VSS.n10900 VSS.n10132 62.9556
R5349 VSS.n10799 VSS.n10182 62.9556
R5350 VSS.n10698 VSS.n10232 62.9556
R5351 VSS.n10597 VSS.n10282 62.9556
R5352 VSS.n10496 VSS.n10332 62.9556
R5353 VSS.n10353 VSS.n10352 62.9556
R5354 VSS.n10487 VSS.n10486 62.9556
R5355 VSS.n10522 VSS.n10521 62.9556
R5356 VSS.n10532 VSS.n10531 62.9556
R5357 VSS.n10544 VSS.n10314 62.9556
R5358 VSS.n10303 VSS.n10302 62.9556
R5359 VSS.n10588 VSS.n10587 62.9556
R5360 VSS.n10623 VSS.n10622 62.9556
R5361 VSS.n10633 VSS.n10632 62.9556
R5362 VSS.n10645 VSS.n10264 62.9556
R5363 VSS.n10253 VSS.n10252 62.9556
R5364 VSS.n10689 VSS.n10688 62.9556
R5365 VSS.n10724 VSS.n10723 62.9556
R5366 VSS.n10734 VSS.n10733 62.9556
R5367 VSS.n10746 VSS.n10214 62.9556
R5368 VSS.n10203 VSS.n10202 62.9556
R5369 VSS.n10790 VSS.n10789 62.9556
R5370 VSS.n10825 VSS.n10824 62.9556
R5371 VSS.n10835 VSS.n10834 62.9556
R5372 VSS.n10847 VSS.n10164 62.9556
R5373 VSS.n10153 VSS.n10152 62.9556
R5374 VSS.n10891 VSS.n10890 62.9556
R5375 VSS.n10926 VSS.n10925 62.9556
R5376 VSS.n10936 VSS.n10935 62.9556
R5377 VSS.n10948 VSS.n10114 62.9556
R5378 VSS.n10103 VSS.n10102 62.9556
R5379 VSS.n10992 VSS.n10991 62.9556
R5380 VSS.n11031 VSS.n11020 62.9556
R5381 VSS.n10068 VSS.n10067 62.9556
R5382 VSS.n11096 VSS.n11095 62.9556
R5383 VSS.n11076 VSS.n11075 62.9556
R5384 VSS.n10375 VSS.n10371 62.9556
R5385 VSS.n10421 VSS.n10373 62.9556
R5386 VSS.n10389 VSS.n10385 62.9556
R5387 VSS.n10399 VSS.n10387 62.9556
R5388 VSS.n11149 VSS.n11148 62.9556
R5389 VSS.n11223 VSS.n11221 62.9556
R5390 VSS.n11329 VSS.n11327 62.9556
R5391 VSS.n11435 VSS.n11433 62.9556
R5392 VSS.n11541 VSS.n11539 62.9556
R5393 VSS.n11647 VSS.n11645 62.9556
R5394 VSS.n11753 VSS.n11751 62.9556
R5395 VSS.n11790 VSS.n11789 62.9556
R5396 VSS.n11765 VSS.n11764 62.9556
R5397 VSS.n11731 VSS.n1698 62.9556
R5398 VSS.n1705 VSS.n1704 62.9556
R5399 VSS.n11707 VSS.n11706 62.9556
R5400 VSS.n11683 VSS.n11682 62.9556
R5401 VSS.n11659 VSS.n11658 62.9556
R5402 VSS.n11625 VSS.n1740 62.9556
R5403 VSS.n1747 VSS.n1746 62.9556
R5404 VSS.n11601 VSS.n11600 62.9556
R5405 VSS.n11577 VSS.n11576 62.9556
R5406 VSS.n11553 VSS.n11552 62.9556
R5407 VSS.n11519 VSS.n1782 62.9556
R5408 VSS.n1789 VSS.n1788 62.9556
R5409 VSS.n11495 VSS.n11494 62.9556
R5410 VSS.n11471 VSS.n11470 62.9556
R5411 VSS.n11447 VSS.n11446 62.9556
R5412 VSS.n11413 VSS.n1824 62.9556
R5413 VSS.n1831 VSS.n1830 62.9556
R5414 VSS.n11389 VSS.n11388 62.9556
R5415 VSS.n11365 VSS.n11364 62.9556
R5416 VSS.n11341 VSS.n11340 62.9556
R5417 VSS.n11307 VSS.n1866 62.9556
R5418 VSS.n1873 VSS.n1872 62.9556
R5419 VSS.n11283 VSS.n11282 62.9556
R5420 VSS.n11259 VSS.n11258 62.9556
R5421 VSS.n11235 VSS.n11234 62.9556
R5422 VSS.n11201 VSS.n1908 62.9556
R5423 VSS.n11109 VSS.n11108 62.9556
R5424 VSS.n11182 VSS.n11181 62.9556
R5425 VSS.n11162 VSS.n11161 62.9556
R5426 VSS.n11808 VSS.n11805 62.9556
R5427 VSS.n11859 VSS.n11858 62.9556
R5428 VSS.n11821 VSS.n11818 62.9556
R5429 VSS.n11836 VSS.n11835 62.9556
R5430 VSS.n12192 VSS.n12191 62.9556
R5431 VSS.n12261 VSS.n12259 62.9556
R5432 VSS.n12367 VSS.n12365 62.9556
R5433 VSS.n12473 VSS.n12471 62.9556
R5434 VSS.n12579 VSS.n12577 62.9556
R5435 VSS.n12685 VSS.n12683 62.9556
R5436 VSS.n12791 VSS.n12789 62.9556
R5437 VSS.n12828 VSS.n12827 62.9556
R5438 VSS.n12803 VSS.n12802 62.9556
R5439 VSS.n12769 VSS.n11932 62.9556
R5440 VSS.n11939 VSS.n11938 62.9556
R5441 VSS.n12745 VSS.n12744 62.9556
R5442 VSS.n12721 VSS.n12720 62.9556
R5443 VSS.n12697 VSS.n12696 62.9556
R5444 VSS.n12663 VSS.n11974 62.9556
R5445 VSS.n11981 VSS.n11980 62.9556
R5446 VSS.n12639 VSS.n12638 62.9556
R5447 VSS.n12615 VSS.n12614 62.9556
R5448 VSS.n12591 VSS.n12590 62.9556
R5449 VSS.n12557 VSS.n12016 62.9556
R5450 VSS.n12023 VSS.n12022 62.9556
R5451 VSS.n12533 VSS.n12532 62.9556
R5452 VSS.n12509 VSS.n12508 62.9556
R5453 VSS.n12485 VSS.n12484 62.9556
R5454 VSS.n12451 VSS.n12058 62.9556
R5455 VSS.n12065 VSS.n12064 62.9556
R5456 VSS.n12427 VSS.n12426 62.9556
R5457 VSS.n12403 VSS.n12402 62.9556
R5458 VSS.n12379 VSS.n12378 62.9556
R5459 VSS.n12345 VSS.n12100 62.9556
R5460 VSS.n12107 VSS.n12106 62.9556
R5461 VSS.n12321 VSS.n12320 62.9556
R5462 VSS.n12297 VSS.n12296 62.9556
R5463 VSS.n12273 VSS.n12272 62.9556
R5464 VSS.n12239 VSS.n12142 62.9556
R5465 VSS.n12147 VSS.n12145 62.9556
R5466 VSS.n12224 VSS.n12223 62.9556
R5467 VSS.n12205 VSS.n12204 62.9556
R5468 VSS.n12846 VSS.n12843 62.9556
R5469 VSS.n12897 VSS.n12896 62.9556
R5470 VSS.n12859 VSS.n12856 62.9556
R5471 VSS.n12874 VSS.n12873 62.9556
R5472 VSS.n13541 VSS.n13540 62.9556
R5473 VSS.n13479 VSS.n1287 62.9556
R5474 VSS.n13378 VSS.n1337 62.9556
R5475 VSS.n13277 VSS.n1387 62.9556
R5476 VSS.n13176 VSS.n1437 62.9556
R5477 VSS.n13075 VSS.n1487 62.9556
R5478 VSS.n12974 VSS.n1537 62.9556
R5479 VSS.n1558 VSS.n1557 62.9556
R5480 VSS.n12965 VSS.n12964 62.9556
R5481 VSS.n13000 VSS.n12999 62.9556
R5482 VSS.n13010 VSS.n13009 62.9556
R5483 VSS.n13022 VSS.n1519 62.9556
R5484 VSS.n1508 VSS.n1507 62.9556
R5485 VSS.n13066 VSS.n13065 62.9556
R5486 VSS.n13101 VSS.n13100 62.9556
R5487 VSS.n13111 VSS.n13110 62.9556
R5488 VSS.n13123 VSS.n1469 62.9556
R5489 VSS.n1458 VSS.n1457 62.9556
R5490 VSS.n13167 VSS.n13166 62.9556
R5491 VSS.n13202 VSS.n13201 62.9556
R5492 VSS.n13212 VSS.n13211 62.9556
R5493 VSS.n13224 VSS.n1419 62.9556
R5494 VSS.n1408 VSS.n1407 62.9556
R5495 VSS.n13268 VSS.n13267 62.9556
R5496 VSS.n13303 VSS.n13302 62.9556
R5497 VSS.n13313 VSS.n13312 62.9556
R5498 VSS.n13325 VSS.n1369 62.9556
R5499 VSS.n1358 VSS.n1357 62.9556
R5500 VSS.n13369 VSS.n13368 62.9556
R5501 VSS.n13404 VSS.n13403 62.9556
R5502 VSS.n13414 VSS.n13413 62.9556
R5503 VSS.n13426 VSS.n1319 62.9556
R5504 VSS.n1308 VSS.n1307 62.9556
R5505 VSS.n13470 VSS.n13469 62.9556
R5506 VSS.n13509 VSS.n13498 62.9556
R5507 VSS.n1273 VSS.n1272 62.9556
R5508 VSS.n13574 VSS.n13573 62.9556
R5509 VSS.n13554 VSS.n13553 62.9556
R5510 VSS.n1580 VSS.n1576 62.9556
R5511 VSS.n1626 VSS.n1578 62.9556
R5512 VSS.n1594 VSS.n1590 62.9556
R5513 VSS.n1604 VSS.n1592 62.9556
R5514 VSS.n14506 VSS.n14505 62.9556
R5515 VSS.n14444 VSS.n13602 62.9556
R5516 VSS.n14194 VSS.n14192 62.9556
R5517 VSS.n14084 VSS.n13769 62.9556
R5518 VSS.n13983 VSS.n13819 62.9556
R5519 VSS.n13840 VSS.n13839 62.9556
R5520 VSS.n13974 VSS.n13973 62.9556
R5521 VSS.n14009 VSS.n14008 62.9556
R5522 VSS.n14019 VSS.n14018 62.9556
R5523 VSS.n14031 VSS.n13801 62.9556
R5524 VSS.n13790 VSS.n13789 62.9556
R5525 VSS.n14075 VSS.n14074 62.9556
R5526 VSS.n14110 VSS.n14109 62.9556
R5527 VSS.n14120 VSS.n14119 62.9556
R5528 VSS.n14132 VSS.n13751 62.9556
R5529 VSS.n14206 VSS.n14205 62.9556
R5530 VSS.n14173 VSS.n14171 62.9556
R5531 VSS.n14225 VSS.n13736 62.9556
R5532 VSS.n14275 VSS.n14274 62.9556
R5533 VSS.n14305 VSS.n14304 62.9556
R5534 VSS.n14327 VSS.n14326 62.9556
R5535 VSS.n14348 VSS.n13652 62.9556
R5536 VSS.n14369 VSS.n14368 62.9556
R5537 VSS.n14379 VSS.n14378 62.9556
R5538 VSS.n14391 VSS.n13634 62.9556
R5539 VSS.n13623 VSS.n13622 62.9556
R5540 VSS.n14435 VSS.n14434 62.9556
R5541 VSS.n14474 VSS.n14463 62.9556
R5542 VSS.n13588 VSS.n13587 62.9556
R5543 VSS.n14539 VSS.n14538 62.9556
R5544 VSS.n14519 VSS.n14518 62.9556
R5545 VSS.n13862 VSS.n13858 62.9556
R5546 VSS.n13908 VSS.n13860 62.9556
R5547 VSS.n13876 VSS.n13872 62.9556
R5548 VSS.n13886 VSS.n13874 62.9556
R5549 VSS.n14589 VSS.n14588 62.9556
R5550 VSS.n14663 VSS.n14661 62.9556
R5551 VSS.n400 VSS.n399 62.9556
R5552 VSS.n406 VSS.n403 62.9556
R5553 VSS.n418 VSS.n417 62.9556
R5554 VSS.n424 VSS.n421 62.9556
R5555 VSS.n14699 VSS.n14698 62.9556
R5556 VSS.n14675 VSS.n14674 62.9556
R5557 VSS.n14641 VSS.n456 62.9556
R5558 VSS.n14552 VSS.n14551 62.9556
R5559 VSS.n14622 VSS.n14621 62.9556
R5560 VSS.n14602 VSS.n14601 62.9556
R5561 VSS.n14988 VSS.n14987 62.9556
R5562 VSS.n14990 VSS.n14989 62.9556
R5563 VSS.n14961 VSS.n14959 62.9556
R5564 VSS.n14963 VSS.n14962 62.9556
R5565 VSS.n14936 VSS.n14935 62.9556
R5566 VSS.n15119 VSS.n15118 62.9556
R5567 VSS.n15232 VSS.n15231 62.9556
R5568 VSS.n15158 VSS.n15154 62.9556
R5569 VSS.n15204 VSS.n15156 62.9556
R5570 VSS.n15172 VSS.n15168 62.9556
R5571 VSS.n15182 VSS.n15170 62.9556
R5572 VSS.n268 VSS.n267 62.9556
R5573 VSS.n2895 VSS.n2894 62.9556
R5574 VSS.n15354 VSS.n15353 62.9556
R5575 VSS.n15326 VSS.n15279 62.9556
R5576 VSS.n15304 VSS.n15289 62.9556
R5577 VSS.n2569 VSS.n2568 62.9556
R5578 VSS.n3438 VSS.n2535 62.9556
R5579 VSS.n2591 VSS.n2590 62.9556
R5580 VSS.n2665 VSS.n2664 62.9556
R5581 VSS.n2641 VSS.n2640 62.9556
R5582 VSS.n3385 VSS.n3384 62.9556
R5583 VSS.n3408 VSS.n3407 62.9556
R5584 VSS.n3333 VSS.n3332 62.9556
R5585 VSS.n3356 VSS.n3355 62.9556
R5586 VSS.n3281 VSS.n3280 62.9556
R5587 VSS.n3304 VSS.n3303 62.9556
R5588 VSS.n3229 VSS.n3228 62.9556
R5589 VSS.n3252 VSS.n3251 62.9556
R5590 VSS.n3177 VSS.n3176 62.9556
R5591 VSS.n3200 VSS.n3199 62.9556
R5592 VSS.n3125 VSS.n3124 62.9556
R5593 VSS.n3148 VSS.n3147 62.9556
R5594 VSS.n3073 VSS.n3072 62.9556
R5595 VSS.n3096 VSS.n3095 62.9556
R5596 VSS.n3021 VSS.n3020 62.9556
R5597 VSS.n3044 VSS.n3043 62.9556
R5598 VSS.n2969 VSS.n2968 62.9556
R5599 VSS.n2992 VSS.n2991 62.9556
R5600 VSS.n2917 VSS.n2916 62.9556
R5601 VSS.n2940 VSS.n2939 62.9556
R5602 VSS.t190 VSS.t153 50.5752
R5603 VSS.t73 VSS.t53 50.5752
R5604 VSS.t519 VSS.t518 44.3849
R5605 VSS.t420 VSS.t160 42.1461
R5606 VSS.n14341 VSS.t4266 37.2036
R5607 VSS.n14902 VSS.t4333 37.2036
R5608 VSS.t608 VSS.t4302 35.2296
R5609 VSS.t605 VSS.t4303 35.2296
R5610 VSS.n14287 VSS.n13708 34.6358
R5611 VSS.n498 VSS.n467 34.6358
R5612 VSS.n498 VSS.n497 34.6358
R5613 VSS.n1134 VSS.n1133 34.6358
R5614 VSS.n1135 VSS.n1134 34.6358
R5615 VSS.n1135 VSS.n549 34.6358
R5616 VSS.n1129 VSS.n1128 34.6358
R5617 VSS.n1113 VSS.n1112 34.6358
R5618 VSS.n1113 VSS.n554 34.6358
R5619 VSS.n1117 VSS.n554 34.6358
R5620 VSS.n1108 VSS.n556 34.6358
R5621 VSS.n1003 VSS.n570 34.6358
R5622 VSS.n1007 VSS.n570 34.6358
R5623 VSS.n1002 VSS.n572 34.6358
R5624 VSS.n911 VSS.n579 34.6358
R5625 VSS.n904 VSS.n903 34.6358
R5626 VSS.n905 VSS.n904 34.6358
R5627 VSS.n905 VSS.n581 34.6358
R5628 VSS.n909 VSS.n581 34.6358
R5629 VSS.n910 VSS.n909 34.6358
R5630 VSS.n898 VSS.n584 34.6358
R5631 VSS.n676 VSS.n643 34.6358
R5632 VSS.n677 VSS.n676 34.6358
R5633 VSS.n15144 VSS.n15139 34.6358
R5634 VSS.n15141 VSS.n15139 34.6358
R5635 VSS.n14762 VSS.n391 34.6358
R5636 VSS.n14758 VSS.n391 34.6358
R5637 VSS.n14758 VSS.n14757 34.6358
R5638 VSS.n14752 VSS.n14751 34.6358
R5639 VSS.n14751 VSS.n394 34.6358
R5640 VSS.n14768 VSS.n389 34.6358
R5641 VSS.n14764 VSS.n14763 34.6358
R5642 VSS.t514 VSS.n14788 34.6358
R5643 VSS.n14785 VSS.n14784 34.6358
R5644 VSS.n14784 VSS.n14783 34.6358
R5645 VSS.n14780 VSS.n14779 34.6358
R5646 VSS.n14779 VSS.n14778 34.6358
R5647 VSS.n14778 VSS.t516 34.6358
R5648 VSS.n14774 VSS.t516 34.6358
R5649 VSS.n14774 VSS.n14773 34.6358
R5650 VSS.n14846 VSS.n369 34.6358
R5651 VSS.n14878 VSS.n359 34.6358
R5652 VSS.n14880 VSS.n14879 34.6358
R5653 VSS.n14911 VSS.n348 34.6358
R5654 VSS.n14912 VSS.n14911 34.6358
R5655 VSS.n15071 VSS.n307 34.6358
R5656 VSS.n15071 VSS.n15070 34.6358
R5657 VSS.n15070 VSS.n15069 34.6358
R5658 VSS.n15066 VSS.n15065 34.6358
R5659 VSS.n15061 VSS.n310 34.6358
R5660 VSS.n15106 VSS.n15090 34.6358
R5661 VSS.n15101 VSS.n15100 34.6358
R5662 VSS.n15021 VSS.n15020 34.6358
R5663 VSS.n15019 VSS.n15006 34.6358
R5664 VSS.n15015 VSS.t217 34.6358
R5665 VSS.n282 VSS.n281 34.6358
R5666 VSS.n2556 VSS.n2555 34.6358
R5667 VSS.n4461 VSS.n4460 34.3776
R5668 VSS.n4296 VSS.n4295 34.3776
R5669 VSS.n4195 VSS.n4194 34.3776
R5670 VSS.n4094 VSS.n4093 34.3776
R5671 VSS.n3993 VSS.n3992 34.3776
R5672 VSS.n3892 VSS.n3891 34.3776
R5673 VSS.n5109 VSS.n5106 34.3776
R5674 VSS.n5293 VSS.n5292 34.3776
R5675 VSS.n5399 VSS.n5398 34.3776
R5676 VSS.n5505 VSS.n5504 34.3776
R5677 VSS.n5611 VSS.n5610 34.3776
R5678 VSS.n5717 VSS.n5716 34.3776
R5679 VSS.n6542 VSS.n6541 34.3776
R5680 VSS.n6377 VSS.n6376 34.3776
R5681 VSS.n6276 VSS.n6275 34.3776
R5682 VSS.n6175 VSS.n6174 34.3776
R5683 VSS.n6074 VSS.n6073 34.3776
R5684 VSS.n5973 VSS.n5972 34.3776
R5685 VSS.n7584 VSS.n7583 34.3776
R5686 VSS.n7419 VSS.n7418 34.3776
R5687 VSS.n7318 VSS.n7317 34.3776
R5688 VSS.n7217 VSS.n7216 34.3776
R5689 VSS.n7116 VSS.n7115 34.3776
R5690 VSS.n7015 VSS.n7014 34.3776
R5691 VSS.n7670 VSS.n7669 34.3776
R5692 VSS.n7775 VSS.n7774 34.3776
R5693 VSS.n7881 VSS.n7880 34.3776
R5694 VSS.n7987 VSS.n7986 34.3776
R5695 VSS.n8093 VSS.n8092 34.3776
R5696 VSS.n8199 VSS.n8198 34.3776
R5697 VSS.n8629 VSS.n8626 34.3776
R5698 VSS.n8813 VSS.n8812 34.3776
R5699 VSS.n8919 VSS.n8918 34.3776
R5700 VSS.n9025 VSS.n9024 34.3776
R5701 VSS.n9131 VSS.n9130 34.3776
R5702 VSS.n9237 VSS.n9236 34.3776
R5703 VSS.n10062 VSS.n10061 34.3776
R5704 VSS.n9897 VSS.n9896 34.3776
R5705 VSS.n9796 VSS.n9795 34.3776
R5706 VSS.n9695 VSS.n9694 34.3776
R5707 VSS.n9594 VSS.n9593 34.3776
R5708 VSS.n9493 VSS.n9492 34.3776
R5709 VSS.n11104 VSS.n11103 34.3776
R5710 VSS.n10939 VSS.n10938 34.3776
R5711 VSS.n10838 VSS.n10837 34.3776
R5712 VSS.n10737 VSS.n10736 34.3776
R5713 VSS.n10636 VSS.n10635 34.3776
R5714 VSS.n10535 VSS.n10534 34.3776
R5715 VSS.n11190 VSS.n11189 34.3776
R5716 VSS.n11295 VSS.n11294 34.3776
R5717 VSS.n11401 VSS.n11400 34.3776
R5718 VSS.n11507 VSS.n11506 34.3776
R5719 VSS.n11613 VSS.n11612 34.3776
R5720 VSS.n11719 VSS.n11718 34.3776
R5721 VSS.n12149 VSS.n12146 34.3776
R5722 VSS.n12333 VSS.n12332 34.3776
R5723 VSS.n12439 VSS.n12438 34.3776
R5724 VSS.n12545 VSS.n12544 34.3776
R5725 VSS.n12651 VSS.n12650 34.3776
R5726 VSS.n12757 VSS.n12756 34.3776
R5727 VSS.n13582 VSS.n13581 34.3776
R5728 VSS.n13417 VSS.n13416 34.3776
R5729 VSS.n13316 VSS.n13315 34.3776
R5730 VSS.n13215 VSS.n13214 34.3776
R5731 VSS.n13114 VSS.n13113 34.3776
R5732 VSS.n13013 VSS.n13012 34.3776
R5733 VSS.n14547 VSS.n14546 34.3776
R5734 VSS.n14382 VSS.n14381 34.3776
R5735 VSS.n14123 VSS.n14122 34.3776
R5736 VSS.n14022 VSS.n14021 34.3776
R5737 VSS.n14630 VSS.n14629 34.3776
R5738 VSS.n14880 VSS.t44 34.2593
R5739 VSS.n14773 VSS.t14 33.8829
R5740 VSS.n14817 VSS.t3280 33.8829
R5741 VSS.n15069 VSS.t3269 33.8829
R5742 VSS.n15106 VSS.t129 33.8829
R5743 VSS.t225 VSS.t182 33.717
R5744 VSS.n14243 VSS.t121 32.377
R5745 VSS.n14753 VSS.t113 32.377
R5746 VSS.n1139 VSS.t3277 32.0005
R5747 VSS.n14813 VSS.t159 31.624
R5748 VSS.t176 VSS.n14853 31.624
R5749 VSS.n14879 VSS.t261 31.624
R5750 VSS.n1266 VSS.n1265 31.4781
R5751 VSS.n1267 VSS.n1266 31.4781
R5752 VSS.n506 VSS.n504 31.4781
R5753 VSS.n510 VSS.n504 31.4781
R5754 VSS.n1013 VSS.n565 31.4781
R5755 VSS.n1021 VSS.n565 31.4781
R5756 VSS.n1098 VSS.n1037 31.4781
R5757 VSS.n1090 VSS.n1037 31.4781
R5758 VSS.n1076 VSS.n1044 31.4781
R5759 VSS.n1067 VSS.n1044 31.4781
R5760 VSS.n1150 VSS.n542 31.4781
R5761 VSS.n1158 VSS.n542 31.4781
R5762 VSS.n1173 VSS.n533 31.4781
R5763 VSS.n1181 VSS.n533 31.4781
R5764 VSS.n1239 VSS.n1206 31.4781
R5765 VSS.n1231 VSS.n1206 31.4781
R5766 VSS.n983 VSS.n923 31.4781
R5767 VSS.n975 VSS.n923 31.4781
R5768 VSS.n961 VSS.n930 31.4781
R5769 VSS.n952 VSS.n930 31.4781
R5770 VSS.n15249 VSS.n299 31.4781
R5771 VSS.n15241 VSS.n299 31.4781
R5772 VSS.n649 VSS.n647 31.4781
R5773 VSS.n653 VSS.n647 31.4781
R5774 VSS.n711 VSS.n626 31.4781
R5775 VSS.n719 VSS.n626 31.4781
R5776 VSS.n734 VSS.n617 31.4781
R5777 VSS.n742 VSS.n617 31.4781
R5778 VSS.n763 VSS.n606 31.4781
R5779 VSS.n771 VSS.n606 31.4781
R5780 VSS.n871 VSS.n810 31.4781
R5781 VSS.n863 VSS.n810 31.4781
R5782 VSS.n849 VSS.n817 31.4781
R5783 VSS.n840 VSS.n817 31.4781
R5784 VSS.n4428 VSS.n4402 31.4781
R5785 VSS.n4419 VSS.n4402 31.4781
R5786 VSS.n4357 VSS.n4356 31.4781
R5787 VSS.n4358 VSS.n4357 31.4781
R5788 VSS.n4256 VSS.n4255 31.4781
R5789 VSS.n4257 VSS.n4256 31.4781
R5790 VSS.n4155 VSS.n4154 31.4781
R5791 VSS.n4156 VSS.n4155 31.4781
R5792 VSS.n4054 VSS.n4053 31.4781
R5793 VSS.n4055 VSS.n4054 31.4781
R5794 VSS.n3953 VSS.n3952 31.4781
R5795 VSS.n3954 VSS.n3953 31.4781
R5796 VSS.n3852 VSS.n3851 31.4781
R5797 VSS.n3853 VSS.n3852 31.4781
R5798 VSS.n3817 VSS.n3730 31.4781
R5799 VSS.n3730 VSS.n3729 31.4781
R5800 VSS.n3835 VSS.n3712 31.4781
R5801 VSS.n3843 VSS.n3712 31.4781
R5802 VSS.n3700 VSS.n3696 31.4781
R5803 VSS.n3878 VSS.n3696 31.4781
R5804 VSS.n3888 VSS.n3887 31.4781
R5805 VSS.n3900 VSS.n3899 31.4781
R5806 VSS.n3901 VSS.n3900 31.4781
R5807 VSS.n3918 VSS.n3680 31.4781
R5808 VSS.n3680 VSS.n3679 31.4781
R5809 VSS.n3936 VSS.n3662 31.4781
R5810 VSS.n3944 VSS.n3662 31.4781
R5811 VSS.n3650 VSS.n3646 31.4781
R5812 VSS.n3979 VSS.n3646 31.4781
R5813 VSS.n3989 VSS.n3988 31.4781
R5814 VSS.n4001 VSS.n4000 31.4781
R5815 VSS.n4002 VSS.n4001 31.4781
R5816 VSS.n4019 VSS.n3630 31.4781
R5817 VSS.n3630 VSS.n3629 31.4781
R5818 VSS.n4037 VSS.n3612 31.4781
R5819 VSS.n4045 VSS.n3612 31.4781
R5820 VSS.n3600 VSS.n3596 31.4781
R5821 VSS.n4080 VSS.n3596 31.4781
R5822 VSS.n4090 VSS.n4089 31.4781
R5823 VSS.n4102 VSS.n4101 31.4781
R5824 VSS.n4103 VSS.n4102 31.4781
R5825 VSS.n4120 VSS.n3580 31.4781
R5826 VSS.n3580 VSS.n3579 31.4781
R5827 VSS.n4138 VSS.n3562 31.4781
R5828 VSS.n4146 VSS.n3562 31.4781
R5829 VSS.n3550 VSS.n3546 31.4781
R5830 VSS.n4181 VSS.n3546 31.4781
R5831 VSS.n4191 VSS.n4190 31.4781
R5832 VSS.n4203 VSS.n4202 31.4781
R5833 VSS.n4204 VSS.n4203 31.4781
R5834 VSS.n4221 VSS.n3530 31.4781
R5835 VSS.n3530 VSS.n3529 31.4781
R5836 VSS.n4239 VSS.n3512 31.4781
R5837 VSS.n4247 VSS.n3512 31.4781
R5838 VSS.n3500 VSS.n3496 31.4781
R5839 VSS.n4282 VSS.n3496 31.4781
R5840 VSS.n4292 VSS.n4291 31.4781
R5841 VSS.n4304 VSS.n4303 31.4781
R5842 VSS.n4305 VSS.n4304 31.4781
R5843 VSS.n4322 VSS.n3480 31.4781
R5844 VSS.n3480 VSS.n3479 31.4781
R5845 VSS.n4340 VSS.n3462 31.4781
R5846 VSS.n4348 VSS.n3462 31.4781
R5847 VSS.n4390 VSS.n4389 31.4781
R5848 VSS.n4389 VSS.n4388 31.4781
R5849 VSS.n3443 VSS.n3441 31.4781
R5850 VSS.n4457 VSS.n3445 31.4781
R5851 VSS.n4453 VSS.n3445 31.4781
R5852 VSS.n4442 VSS.n3450 31.4781
R5853 VSS.n4433 VSS.n3450 31.4781
R5854 VSS.n3771 VSS.n3770 31.4781
R5855 VSS.n3772 VSS.n3771 31.4781
R5856 VSS.n3761 VSS.n3760 31.4781
R5857 VSS.n3762 VSS.n3761 31.4781
R5858 VSS.n5160 VSS.n5134 31.4781
R5859 VSS.n5151 VSS.n5134 31.4781
R5860 VSS.n5220 VSS.n5089 31.4781
R5861 VSS.n5221 VSS.n5220 31.4781
R5862 VSS.n5326 VSS.n5047 31.4781
R5863 VSS.n5327 VSS.n5326 31.4781
R5864 VSS.n5432 VSS.n5005 31.4781
R5865 VSS.n5433 VSS.n5432 31.4781
R5866 VSS.n5538 VSS.n4963 31.4781
R5867 VSS.n5539 VSS.n5538 31.4781
R5868 VSS.n5644 VSS.n4921 31.4781
R5869 VSS.n5645 VSS.n5644 31.4781
R5870 VSS.n5750 VSS.n4879 31.4781
R5871 VSS.n5751 VSS.n5750 31.4781
R5872 VSS.n5790 VSS.n5789 31.4781
R5873 VSS.n5789 VSS.n5788 31.4781
R5874 VSS.n5765 VSS.n5764 31.4781
R5875 VSS.n5764 VSS.n5763 31.4781
R5876 VSS.n5731 VSS.n5730 31.4781
R5877 VSS.n5730 VSS.n5729 31.4781
R5878 VSS.n4898 VSS.n4897 31.4781
R5879 VSS.n5713 VSS.n4901 31.4781
R5880 VSS.n5705 VSS.n4901 31.4781
R5881 VSS.n5690 VSS.n4909 31.4781
R5882 VSS.n5681 VSS.n4909 31.4781
R5883 VSS.n5659 VSS.n5658 31.4781
R5884 VSS.n5658 VSS.n5657 31.4781
R5885 VSS.n5625 VSS.n5624 31.4781
R5886 VSS.n5624 VSS.n5623 31.4781
R5887 VSS.n4940 VSS.n4939 31.4781
R5888 VSS.n5607 VSS.n4943 31.4781
R5889 VSS.n5599 VSS.n4943 31.4781
R5890 VSS.n5584 VSS.n4951 31.4781
R5891 VSS.n5575 VSS.n4951 31.4781
R5892 VSS.n5553 VSS.n5552 31.4781
R5893 VSS.n5552 VSS.n5551 31.4781
R5894 VSS.n5519 VSS.n5518 31.4781
R5895 VSS.n5518 VSS.n5517 31.4781
R5896 VSS.n4982 VSS.n4981 31.4781
R5897 VSS.n5501 VSS.n4985 31.4781
R5898 VSS.n5493 VSS.n4985 31.4781
R5899 VSS.n5478 VSS.n4993 31.4781
R5900 VSS.n5469 VSS.n4993 31.4781
R5901 VSS.n5447 VSS.n5446 31.4781
R5902 VSS.n5446 VSS.n5445 31.4781
R5903 VSS.n5413 VSS.n5412 31.4781
R5904 VSS.n5412 VSS.n5411 31.4781
R5905 VSS.n5024 VSS.n5023 31.4781
R5906 VSS.n5395 VSS.n5027 31.4781
R5907 VSS.n5387 VSS.n5027 31.4781
R5908 VSS.n5372 VSS.n5035 31.4781
R5909 VSS.n5363 VSS.n5035 31.4781
R5910 VSS.n5341 VSS.n5340 31.4781
R5911 VSS.n5340 VSS.n5339 31.4781
R5912 VSS.n5307 VSS.n5306 31.4781
R5913 VSS.n5306 VSS.n5305 31.4781
R5914 VSS.n5066 VSS.n5065 31.4781
R5915 VSS.n5289 VSS.n5069 31.4781
R5916 VSS.n5281 VSS.n5069 31.4781
R5917 VSS.n5266 VSS.n5077 31.4781
R5918 VSS.n5257 VSS.n5077 31.4781
R5919 VSS.n5235 VSS.n5234 31.4781
R5920 VSS.n5234 VSS.n5233 31.4781
R5921 VSS.n5201 VSS.n5200 31.4781
R5922 VSS.n5200 VSS.n5199 31.4781
R5923 VSS.n5108 VSS.n5107 31.4781
R5924 VSS.n5189 VSS.n5112 31.4781
R5925 VSS.n5183 VSS.n5112 31.4781
R5926 VSS.n5174 VSS.n5118 31.4781
R5927 VSS.n5165 VSS.n5118 31.4781
R5928 VSS.n5811 VSS.n5810 31.4781
R5929 VSS.n5810 VSS.n5806 31.4781
R5930 VSS.n5848 VSS.n5805 31.4781
R5931 VSS.n5856 VSS.n5805 31.4781
R5932 VSS.n5824 VSS.n5823 31.4781
R5933 VSS.n5823 VSS.n5819 31.4781
R5934 VSS.n5825 VSS.n5818 31.4781
R5935 VSS.n5833 VSS.n5818 31.4781
R5936 VSS.n6509 VSS.n6483 31.4781
R5937 VSS.n6500 VSS.n6483 31.4781
R5938 VSS.n6438 VSS.n6437 31.4781
R5939 VSS.n6439 VSS.n6438 31.4781
R5940 VSS.n6337 VSS.n6336 31.4781
R5941 VSS.n6338 VSS.n6337 31.4781
R5942 VSS.n6236 VSS.n6235 31.4781
R5943 VSS.n6237 VSS.n6236 31.4781
R5944 VSS.n6135 VSS.n6134 31.4781
R5945 VSS.n6136 VSS.n6135 31.4781
R5946 VSS.n6034 VSS.n6033 31.4781
R5947 VSS.n6035 VSS.n6034 31.4781
R5948 VSS.n5933 VSS.n5932 31.4781
R5949 VSS.n5934 VSS.n5933 31.4781
R5950 VSS.n5898 VSS.n4753 31.4781
R5951 VSS.n4753 VSS.n4752 31.4781
R5952 VSS.n5916 VSS.n4735 31.4781
R5953 VSS.n5924 VSS.n4735 31.4781
R5954 VSS.n4723 VSS.n4719 31.4781
R5955 VSS.n5959 VSS.n4719 31.4781
R5956 VSS.n5969 VSS.n5968 31.4781
R5957 VSS.n5981 VSS.n5980 31.4781
R5958 VSS.n5982 VSS.n5981 31.4781
R5959 VSS.n5999 VSS.n4703 31.4781
R5960 VSS.n4703 VSS.n4702 31.4781
R5961 VSS.n6017 VSS.n4685 31.4781
R5962 VSS.n6025 VSS.n4685 31.4781
R5963 VSS.n4673 VSS.n4669 31.4781
R5964 VSS.n6060 VSS.n4669 31.4781
R5965 VSS.n6070 VSS.n6069 31.4781
R5966 VSS.n6082 VSS.n6081 31.4781
R5967 VSS.n6083 VSS.n6082 31.4781
R5968 VSS.n6100 VSS.n4653 31.4781
R5969 VSS.n4653 VSS.n4652 31.4781
R5970 VSS.n6118 VSS.n4635 31.4781
R5971 VSS.n6126 VSS.n4635 31.4781
R5972 VSS.n4623 VSS.n4619 31.4781
R5973 VSS.n6161 VSS.n4619 31.4781
R5974 VSS.n6171 VSS.n6170 31.4781
R5975 VSS.n6183 VSS.n6182 31.4781
R5976 VSS.n6184 VSS.n6183 31.4781
R5977 VSS.n6201 VSS.n4603 31.4781
R5978 VSS.n4603 VSS.n4602 31.4781
R5979 VSS.n6219 VSS.n4585 31.4781
R5980 VSS.n6227 VSS.n4585 31.4781
R5981 VSS.n4573 VSS.n4569 31.4781
R5982 VSS.n6262 VSS.n4569 31.4781
R5983 VSS.n6272 VSS.n6271 31.4781
R5984 VSS.n6284 VSS.n6283 31.4781
R5985 VSS.n6285 VSS.n6284 31.4781
R5986 VSS.n6302 VSS.n4553 31.4781
R5987 VSS.n4553 VSS.n4552 31.4781
R5988 VSS.n6320 VSS.n4535 31.4781
R5989 VSS.n6328 VSS.n4535 31.4781
R5990 VSS.n4523 VSS.n4519 31.4781
R5991 VSS.n6363 VSS.n4519 31.4781
R5992 VSS.n6373 VSS.n6372 31.4781
R5993 VSS.n6385 VSS.n6384 31.4781
R5994 VSS.n6386 VSS.n6385 31.4781
R5995 VSS.n6403 VSS.n4503 31.4781
R5996 VSS.n4503 VSS.n4502 31.4781
R5997 VSS.n6421 VSS.n4485 31.4781
R5998 VSS.n6429 VSS.n4485 31.4781
R5999 VSS.n6471 VSS.n6470 31.4781
R6000 VSS.n6470 VSS.n6469 31.4781
R6001 VSS.n4466 VSS.n4464 31.4781
R6002 VSS.n6538 VSS.n4468 31.4781
R6003 VSS.n6534 VSS.n4468 31.4781
R6004 VSS.n6523 VSS.n4473 31.4781
R6005 VSS.n6514 VSS.n4473 31.4781
R6006 VSS.n4776 VSS.n4775 31.4781
R6007 VSS.n4775 VSS.n4770 31.4781
R6008 VSS.n4819 VSS.n4818 31.4781
R6009 VSS.n4820 VSS.n4819 31.4781
R6010 VSS.n4790 VSS.n4789 31.4781
R6011 VSS.n4789 VSS.n4784 31.4781
R6012 VSS.n4797 VSS.n4796 31.4781
R6013 VSS.n4798 VSS.n4797 31.4781
R6014 VSS.n7551 VSS.n7525 31.4781
R6015 VSS.n7542 VSS.n7525 31.4781
R6016 VSS.n7480 VSS.n7479 31.4781
R6017 VSS.n7481 VSS.n7480 31.4781
R6018 VSS.n7379 VSS.n7378 31.4781
R6019 VSS.n7380 VSS.n7379 31.4781
R6020 VSS.n7278 VSS.n7277 31.4781
R6021 VSS.n7279 VSS.n7278 31.4781
R6022 VSS.n7177 VSS.n7176 31.4781
R6023 VSS.n7178 VSS.n7177 31.4781
R6024 VSS.n7076 VSS.n7075 31.4781
R6025 VSS.n7077 VSS.n7076 31.4781
R6026 VSS.n6975 VSS.n6974 31.4781
R6027 VSS.n6976 VSS.n6975 31.4781
R6028 VSS.n6940 VSS.n6834 31.4781
R6029 VSS.n6834 VSS.n6833 31.4781
R6030 VSS.n6958 VSS.n6816 31.4781
R6031 VSS.n6966 VSS.n6816 31.4781
R6032 VSS.n6804 VSS.n6800 31.4781
R6033 VSS.n7001 VSS.n6800 31.4781
R6034 VSS.n7011 VSS.n7010 31.4781
R6035 VSS.n7023 VSS.n7022 31.4781
R6036 VSS.n7024 VSS.n7023 31.4781
R6037 VSS.n7041 VSS.n6784 31.4781
R6038 VSS.n6784 VSS.n6783 31.4781
R6039 VSS.n7059 VSS.n6766 31.4781
R6040 VSS.n7067 VSS.n6766 31.4781
R6041 VSS.n6754 VSS.n6750 31.4781
R6042 VSS.n7102 VSS.n6750 31.4781
R6043 VSS.n7112 VSS.n7111 31.4781
R6044 VSS.n7124 VSS.n7123 31.4781
R6045 VSS.n7125 VSS.n7124 31.4781
R6046 VSS.n7142 VSS.n6734 31.4781
R6047 VSS.n6734 VSS.n6733 31.4781
R6048 VSS.n7160 VSS.n6716 31.4781
R6049 VSS.n7168 VSS.n6716 31.4781
R6050 VSS.n6704 VSS.n6700 31.4781
R6051 VSS.n7203 VSS.n6700 31.4781
R6052 VSS.n7213 VSS.n7212 31.4781
R6053 VSS.n7225 VSS.n7224 31.4781
R6054 VSS.n7226 VSS.n7225 31.4781
R6055 VSS.n7243 VSS.n6684 31.4781
R6056 VSS.n6684 VSS.n6683 31.4781
R6057 VSS.n7261 VSS.n6666 31.4781
R6058 VSS.n7269 VSS.n6666 31.4781
R6059 VSS.n6654 VSS.n6650 31.4781
R6060 VSS.n7304 VSS.n6650 31.4781
R6061 VSS.n7314 VSS.n7313 31.4781
R6062 VSS.n7326 VSS.n7325 31.4781
R6063 VSS.n7327 VSS.n7326 31.4781
R6064 VSS.n7344 VSS.n6634 31.4781
R6065 VSS.n6634 VSS.n6633 31.4781
R6066 VSS.n7362 VSS.n6616 31.4781
R6067 VSS.n7370 VSS.n6616 31.4781
R6068 VSS.n6604 VSS.n6600 31.4781
R6069 VSS.n7405 VSS.n6600 31.4781
R6070 VSS.n7415 VSS.n7414 31.4781
R6071 VSS.n7427 VSS.n7426 31.4781
R6072 VSS.n7428 VSS.n7427 31.4781
R6073 VSS.n7445 VSS.n6584 31.4781
R6074 VSS.n6584 VSS.n6583 31.4781
R6075 VSS.n7463 VSS.n6566 31.4781
R6076 VSS.n7471 VSS.n6566 31.4781
R6077 VSS.n7513 VSS.n7512 31.4781
R6078 VSS.n7512 VSS.n7511 31.4781
R6079 VSS.n6547 VSS.n6545 31.4781
R6080 VSS.n7580 VSS.n6549 31.4781
R6081 VSS.n7576 VSS.n6549 31.4781
R6082 VSS.n7565 VSS.n6554 31.4781
R6083 VSS.n7556 VSS.n6554 31.4781
R6084 VSS.n6857 VSS.n6856 31.4781
R6085 VSS.n6856 VSS.n6851 31.4781
R6086 VSS.n6900 VSS.n6899 31.4781
R6087 VSS.n6901 VSS.n6900 31.4781
R6088 VSS.n6871 VSS.n6870 31.4781
R6089 VSS.n6870 VSS.n6865 31.4781
R6090 VSS.n6878 VSS.n6877 31.4781
R6091 VSS.n6879 VSS.n6878 31.4781
R6092 VSS.n7637 VSS.n7611 31.4781
R6093 VSS.n7628 VSS.n7611 31.4781
R6094 VSS.n7702 VSS.n2517 31.4781
R6095 VSS.n7703 VSS.n7702 31.4781
R6096 VSS.n7808 VSS.n2475 31.4781
R6097 VSS.n7809 VSS.n7808 31.4781
R6098 VSS.n7914 VSS.n2433 31.4781
R6099 VSS.n7915 VSS.n7914 31.4781
R6100 VSS.n8020 VSS.n2391 31.4781
R6101 VSS.n8021 VSS.n8020 31.4781
R6102 VSS.n8126 VSS.n2349 31.4781
R6103 VSS.n8127 VSS.n8126 31.4781
R6104 VSS.n8232 VSS.n2307 31.4781
R6105 VSS.n8233 VSS.n8232 31.4781
R6106 VSS.n8272 VSS.n8271 31.4781
R6107 VSS.n8271 VSS.n8270 31.4781
R6108 VSS.n8247 VSS.n8246 31.4781
R6109 VSS.n8246 VSS.n8245 31.4781
R6110 VSS.n8213 VSS.n8212 31.4781
R6111 VSS.n8212 VSS.n8211 31.4781
R6112 VSS.n2326 VSS.n2325 31.4781
R6113 VSS.n8195 VSS.n2329 31.4781
R6114 VSS.n8187 VSS.n2329 31.4781
R6115 VSS.n8172 VSS.n2337 31.4781
R6116 VSS.n8163 VSS.n2337 31.4781
R6117 VSS.n8141 VSS.n8140 31.4781
R6118 VSS.n8140 VSS.n8139 31.4781
R6119 VSS.n8107 VSS.n8106 31.4781
R6120 VSS.n8106 VSS.n8105 31.4781
R6121 VSS.n2368 VSS.n2367 31.4781
R6122 VSS.n8089 VSS.n2371 31.4781
R6123 VSS.n8081 VSS.n2371 31.4781
R6124 VSS.n8066 VSS.n2379 31.4781
R6125 VSS.n8057 VSS.n2379 31.4781
R6126 VSS.n8035 VSS.n8034 31.4781
R6127 VSS.n8034 VSS.n8033 31.4781
R6128 VSS.n8001 VSS.n8000 31.4781
R6129 VSS.n8000 VSS.n7999 31.4781
R6130 VSS.n2410 VSS.n2409 31.4781
R6131 VSS.n7983 VSS.n2413 31.4781
R6132 VSS.n7975 VSS.n2413 31.4781
R6133 VSS.n7960 VSS.n2421 31.4781
R6134 VSS.n7951 VSS.n2421 31.4781
R6135 VSS.n7929 VSS.n7928 31.4781
R6136 VSS.n7928 VSS.n7927 31.4781
R6137 VSS.n7895 VSS.n7894 31.4781
R6138 VSS.n7894 VSS.n7893 31.4781
R6139 VSS.n2452 VSS.n2451 31.4781
R6140 VSS.n7877 VSS.n2455 31.4781
R6141 VSS.n7869 VSS.n2455 31.4781
R6142 VSS.n7854 VSS.n2463 31.4781
R6143 VSS.n7845 VSS.n2463 31.4781
R6144 VSS.n7823 VSS.n7822 31.4781
R6145 VSS.n7822 VSS.n7821 31.4781
R6146 VSS.n7789 VSS.n7788 31.4781
R6147 VSS.n7788 VSS.n7787 31.4781
R6148 VSS.n2494 VSS.n2493 31.4781
R6149 VSS.n7771 VSS.n2497 31.4781
R6150 VSS.n7763 VSS.n2497 31.4781
R6151 VSS.n7748 VSS.n2505 31.4781
R6152 VSS.n7739 VSS.n2505 31.4781
R6153 VSS.n7717 VSS.n7716 31.4781
R6154 VSS.n7716 VSS.n7715 31.4781
R6155 VSS.n7683 VSS.n7682 31.4781
R6156 VSS.n7682 VSS.n7681 31.4781
R6157 VSS.n7588 VSS.n7587 31.4781
R6158 VSS.n7666 VSS.n7590 31.4781
R6159 VSS.n7662 VSS.n7590 31.4781
R6160 VSS.n7651 VSS.n7595 31.4781
R6161 VSS.n7642 VSS.n7595 31.4781
R6162 VSS.n8293 VSS.n8292 31.4781
R6163 VSS.n8292 VSS.n8288 31.4781
R6164 VSS.n8330 VSS.n8287 31.4781
R6165 VSS.n8338 VSS.n8287 31.4781
R6166 VSS.n8306 VSS.n8305 31.4781
R6167 VSS.n8305 VSS.n8301 31.4781
R6168 VSS.n8307 VSS.n8300 31.4781
R6169 VSS.n8315 VSS.n8300 31.4781
R6170 VSS.n8680 VSS.n8654 31.4781
R6171 VSS.n8671 VSS.n8654 31.4781
R6172 VSS.n8740 VSS.n8609 31.4781
R6173 VSS.n8741 VSS.n8740 31.4781
R6174 VSS.n8846 VSS.n8567 31.4781
R6175 VSS.n8847 VSS.n8846 31.4781
R6176 VSS.n8952 VSS.n8525 31.4781
R6177 VSS.n8953 VSS.n8952 31.4781
R6178 VSS.n9058 VSS.n8483 31.4781
R6179 VSS.n9059 VSS.n9058 31.4781
R6180 VSS.n9164 VSS.n8441 31.4781
R6181 VSS.n9165 VSS.n9164 31.4781
R6182 VSS.n9270 VSS.n8399 31.4781
R6183 VSS.n9271 VSS.n9270 31.4781
R6184 VSS.n9310 VSS.n9309 31.4781
R6185 VSS.n9309 VSS.n9308 31.4781
R6186 VSS.n9285 VSS.n9284 31.4781
R6187 VSS.n9284 VSS.n9283 31.4781
R6188 VSS.n9251 VSS.n9250 31.4781
R6189 VSS.n9250 VSS.n9249 31.4781
R6190 VSS.n8418 VSS.n8417 31.4781
R6191 VSS.n9233 VSS.n8421 31.4781
R6192 VSS.n9225 VSS.n8421 31.4781
R6193 VSS.n9210 VSS.n8429 31.4781
R6194 VSS.n9201 VSS.n8429 31.4781
R6195 VSS.n9179 VSS.n9178 31.4781
R6196 VSS.n9178 VSS.n9177 31.4781
R6197 VSS.n9145 VSS.n9144 31.4781
R6198 VSS.n9144 VSS.n9143 31.4781
R6199 VSS.n8460 VSS.n8459 31.4781
R6200 VSS.n9127 VSS.n8463 31.4781
R6201 VSS.n9119 VSS.n8463 31.4781
R6202 VSS.n9104 VSS.n8471 31.4781
R6203 VSS.n9095 VSS.n8471 31.4781
R6204 VSS.n9073 VSS.n9072 31.4781
R6205 VSS.n9072 VSS.n9071 31.4781
R6206 VSS.n9039 VSS.n9038 31.4781
R6207 VSS.n9038 VSS.n9037 31.4781
R6208 VSS.n8502 VSS.n8501 31.4781
R6209 VSS.n9021 VSS.n8505 31.4781
R6210 VSS.n9013 VSS.n8505 31.4781
R6211 VSS.n8998 VSS.n8513 31.4781
R6212 VSS.n8989 VSS.n8513 31.4781
R6213 VSS.n8967 VSS.n8966 31.4781
R6214 VSS.n8966 VSS.n8965 31.4781
R6215 VSS.n8933 VSS.n8932 31.4781
R6216 VSS.n8932 VSS.n8931 31.4781
R6217 VSS.n8544 VSS.n8543 31.4781
R6218 VSS.n8915 VSS.n8547 31.4781
R6219 VSS.n8907 VSS.n8547 31.4781
R6220 VSS.n8892 VSS.n8555 31.4781
R6221 VSS.n8883 VSS.n8555 31.4781
R6222 VSS.n8861 VSS.n8860 31.4781
R6223 VSS.n8860 VSS.n8859 31.4781
R6224 VSS.n8827 VSS.n8826 31.4781
R6225 VSS.n8826 VSS.n8825 31.4781
R6226 VSS.n8586 VSS.n8585 31.4781
R6227 VSS.n8809 VSS.n8589 31.4781
R6228 VSS.n8801 VSS.n8589 31.4781
R6229 VSS.n8786 VSS.n8597 31.4781
R6230 VSS.n8777 VSS.n8597 31.4781
R6231 VSS.n8755 VSS.n8754 31.4781
R6232 VSS.n8754 VSS.n8753 31.4781
R6233 VSS.n8721 VSS.n8720 31.4781
R6234 VSS.n8720 VSS.n8719 31.4781
R6235 VSS.n8628 VSS.n8627 31.4781
R6236 VSS.n8709 VSS.n8632 31.4781
R6237 VSS.n8703 VSS.n8632 31.4781
R6238 VSS.n8694 VSS.n8638 31.4781
R6239 VSS.n8685 VSS.n8638 31.4781
R6240 VSS.n9331 VSS.n9330 31.4781
R6241 VSS.n9330 VSS.n9326 31.4781
R6242 VSS.n9368 VSS.n9325 31.4781
R6243 VSS.n9376 VSS.n9325 31.4781
R6244 VSS.n9344 VSS.n9343 31.4781
R6245 VSS.n9343 VSS.n9339 31.4781
R6246 VSS.n9345 VSS.n9338 31.4781
R6247 VSS.n9353 VSS.n9338 31.4781
R6248 VSS.n10029 VSS.n10003 31.4781
R6249 VSS.n10020 VSS.n10003 31.4781
R6250 VSS.n9958 VSS.n9957 31.4781
R6251 VSS.n9959 VSS.n9958 31.4781
R6252 VSS.n9857 VSS.n9856 31.4781
R6253 VSS.n9858 VSS.n9857 31.4781
R6254 VSS.n9756 VSS.n9755 31.4781
R6255 VSS.n9757 VSS.n9756 31.4781
R6256 VSS.n9655 VSS.n9654 31.4781
R6257 VSS.n9656 VSS.n9655 31.4781
R6258 VSS.n9554 VSS.n9553 31.4781
R6259 VSS.n9555 VSS.n9554 31.4781
R6260 VSS.n9453 VSS.n9452 31.4781
R6261 VSS.n9454 VSS.n9453 31.4781
R6262 VSS.n9418 VSS.n2200 31.4781
R6263 VSS.n2200 VSS.n2199 31.4781
R6264 VSS.n9436 VSS.n2182 31.4781
R6265 VSS.n9444 VSS.n2182 31.4781
R6266 VSS.n2170 VSS.n2166 31.4781
R6267 VSS.n9479 VSS.n2166 31.4781
R6268 VSS.n9489 VSS.n9488 31.4781
R6269 VSS.n9501 VSS.n9500 31.4781
R6270 VSS.n9502 VSS.n9501 31.4781
R6271 VSS.n9519 VSS.n2150 31.4781
R6272 VSS.n2150 VSS.n2149 31.4781
R6273 VSS.n9537 VSS.n2132 31.4781
R6274 VSS.n9545 VSS.n2132 31.4781
R6275 VSS.n2120 VSS.n2116 31.4781
R6276 VSS.n9580 VSS.n2116 31.4781
R6277 VSS.n9590 VSS.n9589 31.4781
R6278 VSS.n9602 VSS.n9601 31.4781
R6279 VSS.n9603 VSS.n9602 31.4781
R6280 VSS.n9620 VSS.n2100 31.4781
R6281 VSS.n2100 VSS.n2099 31.4781
R6282 VSS.n9638 VSS.n2082 31.4781
R6283 VSS.n9646 VSS.n2082 31.4781
R6284 VSS.n2070 VSS.n2066 31.4781
R6285 VSS.n9681 VSS.n2066 31.4781
R6286 VSS.n9691 VSS.n9690 31.4781
R6287 VSS.n9703 VSS.n9702 31.4781
R6288 VSS.n9704 VSS.n9703 31.4781
R6289 VSS.n9721 VSS.n2050 31.4781
R6290 VSS.n2050 VSS.n2049 31.4781
R6291 VSS.n9739 VSS.n2032 31.4781
R6292 VSS.n9747 VSS.n2032 31.4781
R6293 VSS.n2020 VSS.n2016 31.4781
R6294 VSS.n9782 VSS.n2016 31.4781
R6295 VSS.n9792 VSS.n9791 31.4781
R6296 VSS.n9804 VSS.n9803 31.4781
R6297 VSS.n9805 VSS.n9804 31.4781
R6298 VSS.n9822 VSS.n2000 31.4781
R6299 VSS.n2000 VSS.n1999 31.4781
R6300 VSS.n9840 VSS.n1982 31.4781
R6301 VSS.n9848 VSS.n1982 31.4781
R6302 VSS.n1970 VSS.n1966 31.4781
R6303 VSS.n9883 VSS.n1966 31.4781
R6304 VSS.n9893 VSS.n9892 31.4781
R6305 VSS.n9905 VSS.n9904 31.4781
R6306 VSS.n9906 VSS.n9905 31.4781
R6307 VSS.n9923 VSS.n1950 31.4781
R6308 VSS.n1950 VSS.n1949 31.4781
R6309 VSS.n9941 VSS.n1932 31.4781
R6310 VSS.n9949 VSS.n1932 31.4781
R6311 VSS.n9991 VSS.n9990 31.4781
R6312 VSS.n9990 VSS.n9989 31.4781
R6313 VSS.n1913 VSS.n1911 31.4781
R6314 VSS.n10058 VSS.n1915 31.4781
R6315 VSS.n10054 VSS.n1915 31.4781
R6316 VSS.n10043 VSS.n1920 31.4781
R6317 VSS.n10034 VSS.n1920 31.4781
R6318 VSS.n2241 VSS.n2240 31.4781
R6319 VSS.n2242 VSS.n2241 31.4781
R6320 VSS.n2231 VSS.n2230 31.4781
R6321 VSS.n2232 VSS.n2231 31.4781
R6322 VSS.n11071 VSS.n11045 31.4781
R6323 VSS.n11062 VSS.n11045 31.4781
R6324 VSS.n11000 VSS.n10999 31.4781
R6325 VSS.n11001 VSS.n11000 31.4781
R6326 VSS.n10899 VSS.n10898 31.4781
R6327 VSS.n10900 VSS.n10899 31.4781
R6328 VSS.n10798 VSS.n10797 31.4781
R6329 VSS.n10799 VSS.n10798 31.4781
R6330 VSS.n10697 VSS.n10696 31.4781
R6331 VSS.n10698 VSS.n10697 31.4781
R6332 VSS.n10596 VSS.n10595 31.4781
R6333 VSS.n10597 VSS.n10596 31.4781
R6334 VSS.n10495 VSS.n10494 31.4781
R6335 VSS.n10496 VSS.n10495 31.4781
R6336 VSS.n10460 VSS.n10354 31.4781
R6337 VSS.n10354 VSS.n10353 31.4781
R6338 VSS.n10478 VSS.n10336 31.4781
R6339 VSS.n10486 VSS.n10336 31.4781
R6340 VSS.n10324 VSS.n10320 31.4781
R6341 VSS.n10521 VSS.n10320 31.4781
R6342 VSS.n10531 VSS.n10530 31.4781
R6343 VSS.n10543 VSS.n10542 31.4781
R6344 VSS.n10544 VSS.n10543 31.4781
R6345 VSS.n10561 VSS.n10304 31.4781
R6346 VSS.n10304 VSS.n10303 31.4781
R6347 VSS.n10579 VSS.n10286 31.4781
R6348 VSS.n10587 VSS.n10286 31.4781
R6349 VSS.n10274 VSS.n10270 31.4781
R6350 VSS.n10622 VSS.n10270 31.4781
R6351 VSS.n10632 VSS.n10631 31.4781
R6352 VSS.n10644 VSS.n10643 31.4781
R6353 VSS.n10645 VSS.n10644 31.4781
R6354 VSS.n10662 VSS.n10254 31.4781
R6355 VSS.n10254 VSS.n10253 31.4781
R6356 VSS.n10680 VSS.n10236 31.4781
R6357 VSS.n10688 VSS.n10236 31.4781
R6358 VSS.n10224 VSS.n10220 31.4781
R6359 VSS.n10723 VSS.n10220 31.4781
R6360 VSS.n10733 VSS.n10732 31.4781
R6361 VSS.n10745 VSS.n10744 31.4781
R6362 VSS.n10746 VSS.n10745 31.4781
R6363 VSS.n10763 VSS.n10204 31.4781
R6364 VSS.n10204 VSS.n10203 31.4781
R6365 VSS.n10781 VSS.n10186 31.4781
R6366 VSS.n10789 VSS.n10186 31.4781
R6367 VSS.n10174 VSS.n10170 31.4781
R6368 VSS.n10824 VSS.n10170 31.4781
R6369 VSS.n10834 VSS.n10833 31.4781
R6370 VSS.n10846 VSS.n10845 31.4781
R6371 VSS.n10847 VSS.n10846 31.4781
R6372 VSS.n10864 VSS.n10154 31.4781
R6373 VSS.n10154 VSS.n10153 31.4781
R6374 VSS.n10882 VSS.n10136 31.4781
R6375 VSS.n10890 VSS.n10136 31.4781
R6376 VSS.n10124 VSS.n10120 31.4781
R6377 VSS.n10925 VSS.n10120 31.4781
R6378 VSS.n10935 VSS.n10934 31.4781
R6379 VSS.n10947 VSS.n10946 31.4781
R6380 VSS.n10948 VSS.n10947 31.4781
R6381 VSS.n10965 VSS.n10104 31.4781
R6382 VSS.n10104 VSS.n10103 31.4781
R6383 VSS.n10983 VSS.n10086 31.4781
R6384 VSS.n10991 VSS.n10086 31.4781
R6385 VSS.n11033 VSS.n11032 31.4781
R6386 VSS.n11032 VSS.n11031 31.4781
R6387 VSS.n10067 VSS.n10065 31.4781
R6388 VSS.n11100 VSS.n10069 31.4781
R6389 VSS.n11096 VSS.n10069 31.4781
R6390 VSS.n11085 VSS.n10074 31.4781
R6391 VSS.n11076 VSS.n10074 31.4781
R6392 VSS.n10377 VSS.n10376 31.4781
R6393 VSS.n10376 VSS.n10371 31.4781
R6394 VSS.n10420 VSS.n10419 31.4781
R6395 VSS.n10421 VSS.n10420 31.4781
R6396 VSS.n10391 VSS.n10390 31.4781
R6397 VSS.n10390 VSS.n10385 31.4781
R6398 VSS.n10398 VSS.n10397 31.4781
R6399 VSS.n10399 VSS.n10398 31.4781
R6400 VSS.n11157 VSS.n11131 31.4781
R6401 VSS.n11148 VSS.n11131 31.4781
R6402 VSS.n11222 VSS.n1895 31.4781
R6403 VSS.n11223 VSS.n11222 31.4781
R6404 VSS.n11328 VSS.n1853 31.4781
R6405 VSS.n11329 VSS.n11328 31.4781
R6406 VSS.n11434 VSS.n1811 31.4781
R6407 VSS.n11435 VSS.n11434 31.4781
R6408 VSS.n11540 VSS.n1769 31.4781
R6409 VSS.n11541 VSS.n11540 31.4781
R6410 VSS.n11646 VSS.n1727 31.4781
R6411 VSS.n11647 VSS.n11646 31.4781
R6412 VSS.n11752 VSS.n1685 31.4781
R6413 VSS.n11753 VSS.n11752 31.4781
R6414 VSS.n11792 VSS.n11791 31.4781
R6415 VSS.n11791 VSS.n11790 31.4781
R6416 VSS.n11767 VSS.n11766 31.4781
R6417 VSS.n11766 VSS.n11765 31.4781
R6418 VSS.n11733 VSS.n11732 31.4781
R6419 VSS.n11732 VSS.n11731 31.4781
R6420 VSS.n1704 VSS.n1703 31.4781
R6421 VSS.n11715 VSS.n1707 31.4781
R6422 VSS.n11707 VSS.n1707 31.4781
R6423 VSS.n11692 VSS.n1715 31.4781
R6424 VSS.n11683 VSS.n1715 31.4781
R6425 VSS.n11661 VSS.n11660 31.4781
R6426 VSS.n11660 VSS.n11659 31.4781
R6427 VSS.n11627 VSS.n11626 31.4781
R6428 VSS.n11626 VSS.n11625 31.4781
R6429 VSS.n1746 VSS.n1745 31.4781
R6430 VSS.n11609 VSS.n1749 31.4781
R6431 VSS.n11601 VSS.n1749 31.4781
R6432 VSS.n11586 VSS.n1757 31.4781
R6433 VSS.n11577 VSS.n1757 31.4781
R6434 VSS.n11555 VSS.n11554 31.4781
R6435 VSS.n11554 VSS.n11553 31.4781
R6436 VSS.n11521 VSS.n11520 31.4781
R6437 VSS.n11520 VSS.n11519 31.4781
R6438 VSS.n1788 VSS.n1787 31.4781
R6439 VSS.n11503 VSS.n1791 31.4781
R6440 VSS.n11495 VSS.n1791 31.4781
R6441 VSS.n11480 VSS.n1799 31.4781
R6442 VSS.n11471 VSS.n1799 31.4781
R6443 VSS.n11449 VSS.n11448 31.4781
R6444 VSS.n11448 VSS.n11447 31.4781
R6445 VSS.n11415 VSS.n11414 31.4781
R6446 VSS.n11414 VSS.n11413 31.4781
R6447 VSS.n1830 VSS.n1829 31.4781
R6448 VSS.n11397 VSS.n1833 31.4781
R6449 VSS.n11389 VSS.n1833 31.4781
R6450 VSS.n11374 VSS.n1841 31.4781
R6451 VSS.n11365 VSS.n1841 31.4781
R6452 VSS.n11343 VSS.n11342 31.4781
R6453 VSS.n11342 VSS.n11341 31.4781
R6454 VSS.n11309 VSS.n11308 31.4781
R6455 VSS.n11308 VSS.n11307 31.4781
R6456 VSS.n1872 VSS.n1871 31.4781
R6457 VSS.n11291 VSS.n1875 31.4781
R6458 VSS.n11283 VSS.n1875 31.4781
R6459 VSS.n11268 VSS.n1883 31.4781
R6460 VSS.n11259 VSS.n1883 31.4781
R6461 VSS.n11237 VSS.n11236 31.4781
R6462 VSS.n11236 VSS.n11235 31.4781
R6463 VSS.n11203 VSS.n11202 31.4781
R6464 VSS.n11202 VSS.n11201 31.4781
R6465 VSS.n11108 VSS.n11107 31.4781
R6466 VSS.n11186 VSS.n11110 31.4781
R6467 VSS.n11182 VSS.n11110 31.4781
R6468 VSS.n11171 VSS.n11115 31.4781
R6469 VSS.n11162 VSS.n11115 31.4781
R6470 VSS.n11813 VSS.n11812 31.4781
R6471 VSS.n11812 VSS.n11808 31.4781
R6472 VSS.n11850 VSS.n11807 31.4781
R6473 VSS.n11858 VSS.n11807 31.4781
R6474 VSS.n11826 VSS.n11825 31.4781
R6475 VSS.n11825 VSS.n11821 31.4781
R6476 VSS.n11827 VSS.n11820 31.4781
R6477 VSS.n11835 VSS.n11820 31.4781
R6478 VSS.n12200 VSS.n12174 31.4781
R6479 VSS.n12191 VSS.n12174 31.4781
R6480 VSS.n12260 VSS.n12129 31.4781
R6481 VSS.n12261 VSS.n12260 31.4781
R6482 VSS.n12366 VSS.n12087 31.4781
R6483 VSS.n12367 VSS.n12366 31.4781
R6484 VSS.n12472 VSS.n12045 31.4781
R6485 VSS.n12473 VSS.n12472 31.4781
R6486 VSS.n12578 VSS.n12003 31.4781
R6487 VSS.n12579 VSS.n12578 31.4781
R6488 VSS.n12684 VSS.n11961 31.4781
R6489 VSS.n12685 VSS.n12684 31.4781
R6490 VSS.n12790 VSS.n11919 31.4781
R6491 VSS.n12791 VSS.n12790 31.4781
R6492 VSS.n12830 VSS.n12829 31.4781
R6493 VSS.n12829 VSS.n12828 31.4781
R6494 VSS.n12805 VSS.n12804 31.4781
R6495 VSS.n12804 VSS.n12803 31.4781
R6496 VSS.n12771 VSS.n12770 31.4781
R6497 VSS.n12770 VSS.n12769 31.4781
R6498 VSS.n11938 VSS.n11937 31.4781
R6499 VSS.n12753 VSS.n11941 31.4781
R6500 VSS.n12745 VSS.n11941 31.4781
R6501 VSS.n12730 VSS.n11949 31.4781
R6502 VSS.n12721 VSS.n11949 31.4781
R6503 VSS.n12699 VSS.n12698 31.4781
R6504 VSS.n12698 VSS.n12697 31.4781
R6505 VSS.n12665 VSS.n12664 31.4781
R6506 VSS.n12664 VSS.n12663 31.4781
R6507 VSS.n11980 VSS.n11979 31.4781
R6508 VSS.n12647 VSS.n11983 31.4781
R6509 VSS.n12639 VSS.n11983 31.4781
R6510 VSS.n12624 VSS.n11991 31.4781
R6511 VSS.n12615 VSS.n11991 31.4781
R6512 VSS.n12593 VSS.n12592 31.4781
R6513 VSS.n12592 VSS.n12591 31.4781
R6514 VSS.n12559 VSS.n12558 31.4781
R6515 VSS.n12558 VSS.n12557 31.4781
R6516 VSS.n12022 VSS.n12021 31.4781
R6517 VSS.n12541 VSS.n12025 31.4781
R6518 VSS.n12533 VSS.n12025 31.4781
R6519 VSS.n12518 VSS.n12033 31.4781
R6520 VSS.n12509 VSS.n12033 31.4781
R6521 VSS.n12487 VSS.n12486 31.4781
R6522 VSS.n12486 VSS.n12485 31.4781
R6523 VSS.n12453 VSS.n12452 31.4781
R6524 VSS.n12452 VSS.n12451 31.4781
R6525 VSS.n12064 VSS.n12063 31.4781
R6526 VSS.n12435 VSS.n12067 31.4781
R6527 VSS.n12427 VSS.n12067 31.4781
R6528 VSS.n12412 VSS.n12075 31.4781
R6529 VSS.n12403 VSS.n12075 31.4781
R6530 VSS.n12381 VSS.n12380 31.4781
R6531 VSS.n12380 VSS.n12379 31.4781
R6532 VSS.n12347 VSS.n12346 31.4781
R6533 VSS.n12346 VSS.n12345 31.4781
R6534 VSS.n12106 VSS.n12105 31.4781
R6535 VSS.n12329 VSS.n12109 31.4781
R6536 VSS.n12321 VSS.n12109 31.4781
R6537 VSS.n12306 VSS.n12117 31.4781
R6538 VSS.n12297 VSS.n12117 31.4781
R6539 VSS.n12275 VSS.n12274 31.4781
R6540 VSS.n12274 VSS.n12273 31.4781
R6541 VSS.n12241 VSS.n12240 31.4781
R6542 VSS.n12240 VSS.n12239 31.4781
R6543 VSS.n12148 VSS.n12147 31.4781
R6544 VSS.n12229 VSS.n12152 31.4781
R6545 VSS.n12223 VSS.n12152 31.4781
R6546 VSS.n12214 VSS.n12158 31.4781
R6547 VSS.n12205 VSS.n12158 31.4781
R6548 VSS.n12851 VSS.n12850 31.4781
R6549 VSS.n12850 VSS.n12846 31.4781
R6550 VSS.n12888 VSS.n12845 31.4781
R6551 VSS.n12896 VSS.n12845 31.4781
R6552 VSS.n12864 VSS.n12863 31.4781
R6553 VSS.n12863 VSS.n12859 31.4781
R6554 VSS.n12865 VSS.n12858 31.4781
R6555 VSS.n12873 VSS.n12858 31.4781
R6556 VSS.n13549 VSS.n13523 31.4781
R6557 VSS.n13540 VSS.n13523 31.4781
R6558 VSS.n13478 VSS.n13477 31.4781
R6559 VSS.n13479 VSS.n13478 31.4781
R6560 VSS.n13377 VSS.n13376 31.4781
R6561 VSS.n13378 VSS.n13377 31.4781
R6562 VSS.n13276 VSS.n13275 31.4781
R6563 VSS.n13277 VSS.n13276 31.4781
R6564 VSS.n13175 VSS.n13174 31.4781
R6565 VSS.n13176 VSS.n13175 31.4781
R6566 VSS.n13074 VSS.n13073 31.4781
R6567 VSS.n13075 VSS.n13074 31.4781
R6568 VSS.n12973 VSS.n12972 31.4781
R6569 VSS.n12974 VSS.n12973 31.4781
R6570 VSS.n12938 VSS.n1559 31.4781
R6571 VSS.n1559 VSS.n1558 31.4781
R6572 VSS.n12956 VSS.n1541 31.4781
R6573 VSS.n12964 VSS.n1541 31.4781
R6574 VSS.n1529 VSS.n1525 31.4781
R6575 VSS.n12999 VSS.n1525 31.4781
R6576 VSS.n13009 VSS.n13008 31.4781
R6577 VSS.n13021 VSS.n13020 31.4781
R6578 VSS.n13022 VSS.n13021 31.4781
R6579 VSS.n13039 VSS.n1509 31.4781
R6580 VSS.n1509 VSS.n1508 31.4781
R6581 VSS.n13057 VSS.n1491 31.4781
R6582 VSS.n13065 VSS.n1491 31.4781
R6583 VSS.n1479 VSS.n1475 31.4781
R6584 VSS.n13100 VSS.n1475 31.4781
R6585 VSS.n13110 VSS.n13109 31.4781
R6586 VSS.n13122 VSS.n13121 31.4781
R6587 VSS.n13123 VSS.n13122 31.4781
R6588 VSS.n13140 VSS.n1459 31.4781
R6589 VSS.n1459 VSS.n1458 31.4781
R6590 VSS.n13158 VSS.n1441 31.4781
R6591 VSS.n13166 VSS.n1441 31.4781
R6592 VSS.n1429 VSS.n1425 31.4781
R6593 VSS.n13201 VSS.n1425 31.4781
R6594 VSS.n13211 VSS.n13210 31.4781
R6595 VSS.n13223 VSS.n13222 31.4781
R6596 VSS.n13224 VSS.n13223 31.4781
R6597 VSS.n13241 VSS.n1409 31.4781
R6598 VSS.n1409 VSS.n1408 31.4781
R6599 VSS.n13259 VSS.n1391 31.4781
R6600 VSS.n13267 VSS.n1391 31.4781
R6601 VSS.n1379 VSS.n1375 31.4781
R6602 VSS.n13302 VSS.n1375 31.4781
R6603 VSS.n13312 VSS.n13311 31.4781
R6604 VSS.n13324 VSS.n13323 31.4781
R6605 VSS.n13325 VSS.n13324 31.4781
R6606 VSS.n13342 VSS.n1359 31.4781
R6607 VSS.n1359 VSS.n1358 31.4781
R6608 VSS.n13360 VSS.n1341 31.4781
R6609 VSS.n13368 VSS.n1341 31.4781
R6610 VSS.n1329 VSS.n1325 31.4781
R6611 VSS.n13403 VSS.n1325 31.4781
R6612 VSS.n13413 VSS.n13412 31.4781
R6613 VSS.n13425 VSS.n13424 31.4781
R6614 VSS.n13426 VSS.n13425 31.4781
R6615 VSS.n13443 VSS.n1309 31.4781
R6616 VSS.n1309 VSS.n1308 31.4781
R6617 VSS.n13461 VSS.n1291 31.4781
R6618 VSS.n13469 VSS.n1291 31.4781
R6619 VSS.n13511 VSS.n13510 31.4781
R6620 VSS.n13510 VSS.n13509 31.4781
R6621 VSS.n1272 VSS.n1270 31.4781
R6622 VSS.n13578 VSS.n1274 31.4781
R6623 VSS.n13574 VSS.n1274 31.4781
R6624 VSS.n13563 VSS.n1279 31.4781
R6625 VSS.n13554 VSS.n1279 31.4781
R6626 VSS.n1582 VSS.n1581 31.4781
R6627 VSS.n1581 VSS.n1576 31.4781
R6628 VSS.n1625 VSS.n1624 31.4781
R6629 VSS.n1626 VSS.n1625 31.4781
R6630 VSS.n1596 VSS.n1595 31.4781
R6631 VSS.n1595 VSS.n1590 31.4781
R6632 VSS.n1603 VSS.n1602 31.4781
R6633 VSS.n1604 VSS.n1603 31.4781
R6634 VSS.n14514 VSS.n14488 31.4781
R6635 VSS.n14505 VSS.n14488 31.4781
R6636 VSS.n14443 VSS.n14442 31.4781
R6637 VSS.n14444 VSS.n14443 31.4781
R6638 VSS.n14193 VSS.n14149 31.4781
R6639 VSS.n14194 VSS.n14193 31.4781
R6640 VSS.n14083 VSS.n14082 31.4781
R6641 VSS.n14084 VSS.n14083 31.4781
R6642 VSS.n13982 VSS.n13981 31.4781
R6643 VSS.n13983 VSS.n13982 31.4781
R6644 VSS.n13947 VSS.n13841 31.4781
R6645 VSS.n13841 VSS.n13840 31.4781
R6646 VSS.n13965 VSS.n13823 31.4781
R6647 VSS.n13973 VSS.n13823 31.4781
R6648 VSS.n13811 VSS.n13807 31.4781
R6649 VSS.n14008 VSS.n13807 31.4781
R6650 VSS.n14018 VSS.n14017 31.4781
R6651 VSS.n14030 VSS.n14029 31.4781
R6652 VSS.n14031 VSS.n14030 31.4781
R6653 VSS.n14048 VSS.n13791 31.4781
R6654 VSS.n13791 VSS.n13790 31.4781
R6655 VSS.n14066 VSS.n13773 31.4781
R6656 VSS.n14074 VSS.n13773 31.4781
R6657 VSS.n13761 VSS.n13757 31.4781
R6658 VSS.n14109 VSS.n13757 31.4781
R6659 VSS.n14119 VSS.n14118 31.4781
R6660 VSS.n14131 VSS.n14130 31.4781
R6661 VSS.n14132 VSS.n14131 31.4781
R6662 VSS.n14208 VSS.n14207 31.4781
R6663 VSS.n14207 VSS.n14206 31.4781
R6664 VSS.n14172 VSS.n14157 31.4781
R6665 VSS.n14173 VSS.n14172 31.4781
R6666 VSS.n14224 VSS.n14223 31.4781
R6667 VSS.n14225 VSS.n14224 31.4781
R6668 VSS.n14267 VSS.n13716 31.4781
R6669 VSS.n14274 VSS.n13716 31.4781
R6670 VSS.n14296 VSS.n13703 31.4781
R6671 VSS.n14304 VSS.n13703 31.4781
R6672 VSS.n14318 VSS.n13662 31.4781
R6673 VSS.n14326 VSS.n13662 31.4781
R6674 VSS.n14348 VSS.n14347 31.4781
R6675 VSS.n13644 VSS.n13640 31.4781
R6676 VSS.n14368 VSS.n13640 31.4781
R6677 VSS.n14378 VSS.n14377 31.4781
R6678 VSS.n14390 VSS.n14389 31.4781
R6679 VSS.n14391 VSS.n14390 31.4781
R6680 VSS.n14408 VSS.n13624 31.4781
R6681 VSS.n13624 VSS.n13623 31.4781
R6682 VSS.n14426 VSS.n13606 31.4781
R6683 VSS.n14434 VSS.n13606 31.4781
R6684 VSS.n14476 VSS.n14475 31.4781
R6685 VSS.n14475 VSS.n14474 31.4781
R6686 VSS.n13587 VSS.n13585 31.4781
R6687 VSS.n14543 VSS.n13589 31.4781
R6688 VSS.n14539 VSS.n13589 31.4781
R6689 VSS.n14528 VSS.n13594 31.4781
R6690 VSS.n14519 VSS.n13594 31.4781
R6691 VSS.n13864 VSS.n13863 31.4781
R6692 VSS.n13863 VSS.n13858 31.4781
R6693 VSS.n13907 VSS.n13906 31.4781
R6694 VSS.n13908 VSS.n13907 31.4781
R6695 VSS.n13878 VSS.n13877 31.4781
R6696 VSS.n13877 VSS.n13872 31.4781
R6697 VSS.n13885 VSS.n13884 31.4781
R6698 VSS.n13886 VSS.n13885 31.4781
R6699 VSS.n14597 VSS.n14571 31.4781
R6700 VSS.n14588 VSS.n14571 31.4781
R6701 VSS.n14662 VSS.n443 31.4781
R6702 VSS.n14663 VSS.n14662 31.4781
R6703 VSS.n14745 VSS.n395 31.4781
R6704 VSS.n400 VSS.n395 31.4781
R6705 VSS.n406 VSS.n405 31.4781
R6706 VSS.n14727 VSS.n413 31.4781
R6707 VSS.n418 VSS.n413 31.4781
R6708 VSS.n424 VSS.n423 31.4781
R6709 VSS.n14708 VSS.n431 31.4781
R6710 VSS.n14699 VSS.n431 31.4781
R6711 VSS.n14677 VSS.n14676 31.4781
R6712 VSS.n14676 VSS.n14675 31.4781
R6713 VSS.n14643 VSS.n14642 31.4781
R6714 VSS.n14642 VSS.n14641 31.4781
R6715 VSS.n14551 VSS.n14550 31.4781
R6716 VSS.n14626 VSS.n14553 31.4781
R6717 VSS.n14622 VSS.n14553 31.4781
R6718 VSS.n14611 VSS.n14558 31.4781
R6719 VSS.n14602 VSS.n14558 31.4781
R6720 VSS.n14986 VSS.n321 31.4781
R6721 VSS.n14987 VSS.n14986 31.4781
R6722 VSS.n14997 VSS.n322 31.4781
R6723 VSS.n14989 VSS.n322 31.4781
R6724 VSS.n14960 VSS.n329 31.4781
R6725 VSS.n14961 VSS.n14960 31.4781
R6726 VSS.n14972 VSS.n330 31.4781
R6727 VSS.n14963 VSS.n330 31.4781
R6728 VSS.n14944 VSS.n336 31.4781
R6729 VSS.n14936 VSS.n336 31.4781
R6730 VSS.n15110 VSS.n15085 31.4781
R6731 VSS.n15118 VSS.n15085 31.4781
R6732 VSS.n15237 VSS.n301 31.4781
R6733 VSS.n15232 VSS.n301 31.4781
R6734 VSS.n15160 VSS.n15159 31.4781
R6735 VSS.n15159 VSS.n15154 31.4781
R6736 VSS.n15203 VSS.n15202 31.4781
R6737 VSS.n15204 VSS.n15203 31.4781
R6738 VSS.n15174 VSS.n15173 31.4781
R6739 VSS.n15173 VSS.n15168 31.4781
R6740 VSS.n15181 VSS.n15180 31.4781
R6741 VSS.n15182 VSS.n15181 31.4781
R6742 VSS.n259 VSS.n249 31.4781
R6743 VSS.n267 VSS.n249 31.4781
R6744 VSS.n2890 VSS.n2888 31.4781
R6745 VSS.n2894 VSS.n2888 31.4781
R6746 VSS.n15345 VSS.n236 31.4781
R6747 VSS.n15353 VSS.n236 31.4781
R6748 VSS.n15325 VSS.n15324 31.4781
R6749 VSS.n15326 VSS.n15325 31.4781
R6750 VSS.n15303 VSS.n15302 31.4781
R6751 VSS.n15304 VSS.n15303 31.4781
R6752 VSS.n2576 VSS.n2544 31.4781
R6753 VSS.n2568 VSS.n2544 31.4781
R6754 VSS.n3437 VSS.n3436 31.4781
R6755 VSS.n3438 VSS.n3437 31.4781
R6756 VSS.n2586 VSS.n2584 31.4781
R6757 VSS.n2590 VSS.n2584 31.4781
R6758 VSS.n2672 VSS.n2611 31.4781
R6759 VSS.n2664 VSS.n2611 31.4781
R6760 VSS.n2650 VSS.n2618 31.4781
R6761 VSS.n2641 VSS.n2618 31.4781
R6762 VSS.n3376 VSS.n2691 31.4781
R6763 VSS.n3384 VSS.n2691 31.4781
R6764 VSS.n3399 VSS.n2682 31.4781
R6765 VSS.n3407 VSS.n2682 31.4781
R6766 VSS.n3324 VSS.n2711 31.4781
R6767 VSS.n3332 VSS.n2711 31.4781
R6768 VSS.n3347 VSS.n2702 31.4781
R6769 VSS.n3355 VSS.n2702 31.4781
R6770 VSS.n3272 VSS.n2731 31.4781
R6771 VSS.n3280 VSS.n2731 31.4781
R6772 VSS.n3295 VSS.n2722 31.4781
R6773 VSS.n3303 VSS.n2722 31.4781
R6774 VSS.n3220 VSS.n2751 31.4781
R6775 VSS.n3228 VSS.n2751 31.4781
R6776 VSS.n3243 VSS.n2742 31.4781
R6777 VSS.n3251 VSS.n2742 31.4781
R6778 VSS.n3168 VSS.n2771 31.4781
R6779 VSS.n3176 VSS.n2771 31.4781
R6780 VSS.n3191 VSS.n2762 31.4781
R6781 VSS.n3199 VSS.n2762 31.4781
R6782 VSS.n3116 VSS.n2791 31.4781
R6783 VSS.n3124 VSS.n2791 31.4781
R6784 VSS.n3139 VSS.n2782 31.4781
R6785 VSS.n3147 VSS.n2782 31.4781
R6786 VSS.n3064 VSS.n2811 31.4781
R6787 VSS.n3072 VSS.n2811 31.4781
R6788 VSS.n3087 VSS.n2802 31.4781
R6789 VSS.n3095 VSS.n2802 31.4781
R6790 VSS.n3012 VSS.n2831 31.4781
R6791 VSS.n3020 VSS.n2831 31.4781
R6792 VSS.n3035 VSS.n2822 31.4781
R6793 VSS.n3043 VSS.n2822 31.4781
R6794 VSS.n2960 VSS.n2851 31.4781
R6795 VSS.n2968 VSS.n2851 31.4781
R6796 VSS.n2983 VSS.n2842 31.4781
R6797 VSS.n2991 VSS.n2842 31.4781
R6798 VSS.n2908 VSS.n2871 31.4781
R6799 VSS.n2916 VSS.n2871 31.4781
R6800 VSS.n2931 VSS.n2862 31.4781
R6801 VSS.n2939 VSS.n2862 31.4781
R6802 VSS.t178 VSS.n14286 31.2476
R6803 VSS.n14239 VSS.t127 31.2476
R6804 VSS.n1129 VSS.t3242 30.8711
R6805 VSS.n14789 VSS.t107 30.8711
R6806 VSS.n14783 VSS.t89 30.4946
R6807 VSS.n14837 VSS.t211 30.4946
R6808 VSS.t3333 VSS.n14835 30.4946
R6809 VSS.n14247 VSS.t3430 30.1181
R6810 VSS.n14757 VSS.t3426 30.1181
R6811 VSS.n14842 VSS.t3405 29.7417
R6812 VSS.n15014 VSS.t220 29.7417
R6813 VSS.n4444 VSS.n3448 29.4317
R6814 VSS.n4339 VSS.n3466 29.4317
R6815 VSS.n4320 VSS.n3482 29.4317
R6816 VSS.n4238 VSS.n3516 29.4317
R6817 VSS.n4219 VSS.n3532 29.4317
R6818 VSS.n4137 VSS.n3566 29.4317
R6819 VSS.n4118 VSS.n3582 29.4317
R6820 VSS.n4036 VSS.n3616 29.4317
R6821 VSS.n4017 VSS.n3632 29.4317
R6822 VSS.n3935 VSS.n3666 29.4317
R6823 VSS.n3916 VSS.n3682 29.4317
R6824 VSS.n3834 VSS.n3716 29.4317
R6825 VSS.n3815 VSS.n3733 29.4317
R6826 VSS.n5176 VSS.n5116 29.4317
R6827 VSS.n5242 VSS.n5083 29.4317
R6828 VSS.n5268 VSS.n5075 29.4317
R6829 VSS.n5348 VSS.n5041 29.4317
R6830 VSS.n5374 VSS.n5033 29.4317
R6831 VSS.n5454 VSS.n4999 29.4317
R6832 VSS.n5480 VSS.n4991 29.4317
R6833 VSS.n5560 VSS.n4957 29.4317
R6834 VSS.n5586 VSS.n4949 29.4317
R6835 VSS.n5666 VSS.n4915 29.4317
R6836 VSS.n5692 VSS.n4907 29.4317
R6837 VSS.n5772 VSS.n4873 29.4317
R6838 VSS.n4868 VSS.n4854 29.4317
R6839 VSS.n6525 VSS.n4471 29.4317
R6840 VSS.n6420 VSS.n4489 29.4317
R6841 VSS.n6401 VSS.n4505 29.4317
R6842 VSS.n6319 VSS.n4539 29.4317
R6843 VSS.n6300 VSS.n4555 29.4317
R6844 VSS.n6218 VSS.n4589 29.4317
R6845 VSS.n6199 VSS.n4605 29.4317
R6846 VSS.n6117 VSS.n4639 29.4317
R6847 VSS.n6098 VSS.n4655 29.4317
R6848 VSS.n6016 VSS.n4689 29.4317
R6849 VSS.n5997 VSS.n4705 29.4317
R6850 VSS.n5915 VSS.n4739 29.4317
R6851 VSS.n5896 VSS.n4756 29.4317
R6852 VSS.n7567 VSS.n6552 29.4317
R6853 VSS.n7462 VSS.n6570 29.4317
R6854 VSS.n7443 VSS.n6586 29.4317
R6855 VSS.n7361 VSS.n6620 29.4317
R6856 VSS.n7342 VSS.n6636 29.4317
R6857 VSS.n7260 VSS.n6670 29.4317
R6858 VSS.n7241 VSS.n6686 29.4317
R6859 VSS.n7159 VSS.n6720 29.4317
R6860 VSS.n7140 VSS.n6736 29.4317
R6861 VSS.n7058 VSS.n6770 29.4317
R6862 VSS.n7039 VSS.n6786 29.4317
R6863 VSS.n6957 VSS.n6820 29.4317
R6864 VSS.n6938 VSS.n6837 29.4317
R6865 VSS.n7653 VSS.n7593 29.4317
R6866 VSS.n7724 VSS.n2511 29.4317
R6867 VSS.n7750 VSS.n2503 29.4317
R6868 VSS.n7830 VSS.n2469 29.4317
R6869 VSS.n7856 VSS.n2461 29.4317
R6870 VSS.n7936 VSS.n2427 29.4317
R6871 VSS.n7962 VSS.n2419 29.4317
R6872 VSS.n8042 VSS.n2385 29.4317
R6873 VSS.n8068 VSS.n2377 29.4317
R6874 VSS.n8148 VSS.n2343 29.4317
R6875 VSS.n8174 VSS.n2335 29.4317
R6876 VSS.n8254 VSS.n2301 29.4317
R6877 VSS.n2296 VSS.n2282 29.4317
R6878 VSS.n8696 VSS.n8636 29.4317
R6879 VSS.n8762 VSS.n8603 29.4317
R6880 VSS.n8788 VSS.n8595 29.4317
R6881 VSS.n8868 VSS.n8561 29.4317
R6882 VSS.n8894 VSS.n8553 29.4317
R6883 VSS.n8974 VSS.n8519 29.4317
R6884 VSS.n9000 VSS.n8511 29.4317
R6885 VSS.n9080 VSS.n8477 29.4317
R6886 VSS.n9106 VSS.n8469 29.4317
R6887 VSS.n9186 VSS.n8435 29.4317
R6888 VSS.n9212 VSS.n8427 29.4317
R6889 VSS.n9292 VSS.n8393 29.4317
R6890 VSS.n8388 VSS.n8374 29.4317
R6891 VSS.n10045 VSS.n1918 29.4317
R6892 VSS.n9940 VSS.n1936 29.4317
R6893 VSS.n9921 VSS.n1952 29.4317
R6894 VSS.n9839 VSS.n1986 29.4317
R6895 VSS.n9820 VSS.n2002 29.4317
R6896 VSS.n9738 VSS.n2036 29.4317
R6897 VSS.n9719 VSS.n2052 29.4317
R6898 VSS.n9637 VSS.n2086 29.4317
R6899 VSS.n9618 VSS.n2102 29.4317
R6900 VSS.n9536 VSS.n2136 29.4317
R6901 VSS.n9517 VSS.n2152 29.4317
R6902 VSS.n9435 VSS.n2186 29.4317
R6903 VSS.n9416 VSS.n2203 29.4317
R6904 VSS.n11087 VSS.n10072 29.4317
R6905 VSS.n10982 VSS.n10090 29.4317
R6906 VSS.n10963 VSS.n10106 29.4317
R6907 VSS.n10881 VSS.n10140 29.4317
R6908 VSS.n10862 VSS.n10156 29.4317
R6909 VSS.n10780 VSS.n10190 29.4317
R6910 VSS.n10761 VSS.n10206 29.4317
R6911 VSS.n10679 VSS.n10240 29.4317
R6912 VSS.n10660 VSS.n10256 29.4317
R6913 VSS.n10578 VSS.n10290 29.4317
R6914 VSS.n10559 VSS.n10306 29.4317
R6915 VSS.n10477 VSS.n10340 29.4317
R6916 VSS.n10458 VSS.n10357 29.4317
R6917 VSS.n11173 VSS.n11113 29.4317
R6918 VSS.n11244 VSS.n1889 29.4317
R6919 VSS.n11270 VSS.n1881 29.4317
R6920 VSS.n11350 VSS.n1847 29.4317
R6921 VSS.n11376 VSS.n1839 29.4317
R6922 VSS.n11456 VSS.n1805 29.4317
R6923 VSS.n11482 VSS.n1797 29.4317
R6924 VSS.n11562 VSS.n1763 29.4317
R6925 VSS.n11588 VSS.n1755 29.4317
R6926 VSS.n11668 VSS.n1721 29.4317
R6927 VSS.n11694 VSS.n1713 29.4317
R6928 VSS.n11774 VSS.n1679 29.4317
R6929 VSS.n1674 VSS.n1660 29.4317
R6930 VSS.n12216 VSS.n12156 29.4317
R6931 VSS.n12282 VSS.n12123 29.4317
R6932 VSS.n12308 VSS.n12115 29.4317
R6933 VSS.n12388 VSS.n12081 29.4317
R6934 VSS.n12414 VSS.n12073 29.4317
R6935 VSS.n12494 VSS.n12039 29.4317
R6936 VSS.n12520 VSS.n12031 29.4317
R6937 VSS.n12600 VSS.n11997 29.4317
R6938 VSS.n12626 VSS.n11989 29.4317
R6939 VSS.n12706 VSS.n11955 29.4317
R6940 VSS.n12732 VSS.n11947 29.4317
R6941 VSS.n12812 VSS.n11913 29.4317
R6942 VSS.n11908 VSS.n11894 29.4317
R6943 VSS.n13565 VSS.n1277 29.4317
R6944 VSS.n13460 VSS.n1295 29.4317
R6945 VSS.n13441 VSS.n1311 29.4317
R6946 VSS.n13359 VSS.n1345 29.4317
R6947 VSS.n13340 VSS.n1361 29.4317
R6948 VSS.n13258 VSS.n1395 29.4317
R6949 VSS.n13239 VSS.n1411 29.4317
R6950 VSS.n13157 VSS.n1445 29.4317
R6951 VSS.n13138 VSS.n1461 29.4317
R6952 VSS.n13056 VSS.n1495 29.4317
R6953 VSS.n13037 VSS.n1511 29.4317
R6954 VSS.n12955 VSS.n1545 29.4317
R6955 VSS.n12936 VSS.n1562 29.4317
R6956 VSS.n14530 VSS.n13592 29.4317
R6957 VSS.n14425 VSS.n13610 29.4317
R6958 VSS.n14406 VSS.n13626 29.4317
R6959 VSS.n14147 VSS.n13744 29.4317
R6960 VSS.n14065 VSS.n13777 29.4317
R6961 VSS.n14046 VSS.n13793 29.4317
R6962 VSS.n13964 VSS.n13827 29.4317
R6963 VSS.n13945 VSS.n13844 29.4317
R6964 VSS.n14613 VSS.n14556 29.4317
R6965 VSS.n14684 VSS.n437 29.4317
R6966 VSS.n14710 VSS.n430 29.4317
R6967 VSS.n14729 VSS.n412 29.4317
R6968 VSS.n14291 VSS.t227 28.9887
R6969 VSS.n14913 VSS.t3257 28.9887
R6970 VSS.t3286 VSS.t149 28.6123
R6971 VSS.n14753 VSS.t518 28.2358
R6972 VSS.t116 VSS.t59 28.2358
R6973 VSS.t3350 VSS.n14243 27.8593
R6974 VSS.t136 VSS.n14768 27.4829
R6975 VSS.n15105 VSS.t3366 27.4829
R6976 VSS.n14835 VSS.t209 27.4829
R6977 VSS.n14769 VSS.t3336 27.1064
R6978 VSS.n15024 VSS.t3303 27.1064
R6979 VSS.n15340 VSS.n15339 26.001
R6980 VSS.n281 VSS.n280 26.001
R6981 VSS.n2557 VSS.n2556 26.001
R6982 VSS.t3328 VSS.n389 25.977
R6983 VSS.n14852 VSS.n367 25.7355
R6984 VSS.n14918 VSS.t79 25.7355
R6985 VSS.n2555 VSS.n2550 25.7355
R6986 VSS.n1214 VSS.n465 25.6926
R6987 VSS.n1249 VSS.n1201 25.6926
R6988 VSS.n1140 VSS.n1139 25.6926
R6989 VSS.n1128 VSS.n1127 25.6926
R6990 VSS.n998 VSS.n572 25.6926
R6991 VSS.n894 VSS.n584 25.6926
R6992 VSS.n706 VSS.n705 25.6926
R6993 VSS.n687 VSS.n686 25.6926
R6994 VSS.n681 VSS.n641 25.6926
R6995 VSS.n293 VSS.n240 25.6926
R6996 VSS.n14818 VSS.n14817 25.6926
R6997 VSS.t487 VSS.n307 25.6926
R6998 VSS.n15046 VSS.n15045 25.6926
R6999 VSS.n15100 VSS.n15093 25.6926
R7000 VSS.n496 VSS.t3377 25.6005
R7001 VSS.n1245 VSS.t98 25.6005
R7002 VSS.n1118 VSS.t3375 25.6005
R7003 VSS.n1008 VSS.t132 25.6005
R7004 VSS.n899 VSS.t92 25.6005
R7005 VSS.n785 VSS.t26 25.6005
R7006 VSS.t245 VSS.n638 25.6005
R7007 VSS.n286 VSS.t241 25.6005
R7008 VSS.t417 VSS.t3359 25.2879
R7009 VSS.t7 VSS.t3243 25.2879
R7010 VSS.t19 VSS.t260 25.2879
R7011 VSS.n14837 VSS.t214 25.224
R7012 VSS.t74 VSS.n14917 25.224
R7013 VSS.n789 VSS.n599 24.9894
R7014 VSS.n692 VSS.n691 24.9894
R7015 VSS.n14249 VSS.n14248 24.9894
R7016 VSS.n14747 VSS.n394 24.9894
R7017 VSS.n14874 VSS.n359 24.9894
R7018 VSS.n15061 VSS.n15060 24.9894
R7019 VSS.t484 VSS.n15090 24.9894
R7020 VSS.n497 VSS.t3278 24.8476
R7021 VSS.t96 VSS.n1201 24.8476
R7022 VSS.t3373 VSS.n1117 24.8476
R7023 VSS.t5 VSS.n1007 24.8476
R7024 VSS.n903 VSS.t94 24.8476
R7025 VSS.t28 VSS.n599 24.8476
R7026 VSS.n691 VSS.t204 24.8476
R7027 VSS.t30 VSS.n348 24.8476
R7028 VSS.n287 VSS.t243 24.8476
R7029 VSS.n14809 VSS.n14808 24.8035
R7030 VSS.t3093 VSS.t3492 24.6737
R7031 VSS.t3078 VSS.t3497 24.6737
R7032 VSS.t3063 VSS.t3502 24.6737
R7033 VSS.t3048 VSS.t3507 24.6737
R7034 VSS.t3033 VSS.t3512 24.6737
R7035 VSS.t3018 VSS.t3517 24.6737
R7036 VSS.t3562 VSS.t2875 24.6737
R7037 VSS.t3567 VSS.t2860 24.6737
R7038 VSS.t3572 VSS.t2845 24.6737
R7039 VSS.t3577 VSS.t2830 24.6737
R7040 VSS.t3582 VSS.t2815 24.6737
R7041 VSS.t3587 VSS.t2800 24.6737
R7042 VSS.t2660 VSS.t3632 24.6737
R7043 VSS.t2645 VSS.t3637 24.6737
R7044 VSS.t2630 VSS.t3642 24.6737
R7045 VSS.t2615 VSS.t3647 24.6737
R7046 VSS.t2600 VSS.t3652 24.6737
R7047 VSS.t2585 VSS.t3657 24.6737
R7048 VSS.t2445 VSS.t3702 24.6737
R7049 VSS.t2430 VSS.t3707 24.6737
R7050 VSS.t2415 VSS.t3712 24.6737
R7051 VSS.t2400 VSS.t3717 24.6737
R7052 VSS.t2385 VSS.t3722 24.6737
R7053 VSS.t2370 VSS.t3727 24.6737
R7054 VSS.t3772 VSS.t2230 24.6737
R7055 VSS.t3777 VSS.t2215 24.6737
R7056 VSS.t3782 VSS.t2200 24.6737
R7057 VSS.t3787 VSS.t2185 24.6737
R7058 VSS.t3792 VSS.t2170 24.6737
R7059 VSS.t3797 VSS.t2155 24.6737
R7060 VSS.t3842 VSS.t2015 24.6737
R7061 VSS.t3847 VSS.t2000 24.6737
R7062 VSS.t3852 VSS.t1985 24.6737
R7063 VSS.t3857 VSS.t1970 24.6737
R7064 VSS.t3862 VSS.t1955 24.6737
R7065 VSS.t3867 VSS.t1940 24.6737
R7066 VSS.t1800 VSS.t3912 24.6737
R7067 VSS.t1785 VSS.t3917 24.6737
R7068 VSS.t1770 VSS.t3922 24.6737
R7069 VSS.t1755 VSS.t3927 24.6737
R7070 VSS.t1740 VSS.t3932 24.6737
R7071 VSS.t1725 VSS.t3937 24.6737
R7072 VSS.t1582 VSS.t3982 24.6737
R7073 VSS.t1567 VSS.t3987 24.6737
R7074 VSS.t1552 VSS.t3992 24.6737
R7075 VSS.t1537 VSS.t3997 24.6737
R7076 VSS.t1522 VSS.t4002 24.6737
R7077 VSS.t1507 VSS.t4007 24.6737
R7078 VSS.t4052 VSS.t1367 24.6737
R7079 VSS.t4057 VSS.t1352 24.6737
R7080 VSS.t4062 VSS.t1337 24.6737
R7081 VSS.t4067 VSS.t1322 24.6737
R7082 VSS.t4072 VSS.t1307 24.6737
R7083 VSS.t4077 VSS.t1292 24.6737
R7084 VSS.t4122 VSS.t1152 24.6737
R7085 VSS.t4127 VSS.t1137 24.6737
R7086 VSS.t4132 VSS.t1122 24.6737
R7087 VSS.t4137 VSS.t1107 24.6737
R7088 VSS.t4142 VSS.t1092 24.6737
R7089 VSS.t4147 VSS.t1077 24.6737
R7090 VSS.t937 VSS.t4192 24.6737
R7091 VSS.t922 VSS.t4197 24.6737
R7092 VSS.t907 VSS.t4202 24.6737
R7093 VSS.t892 VSS.t4207 24.6737
R7094 VSS.t877 VSS.t4212 24.6737
R7095 VSS.t862 VSS.t4217 24.6737
R7096 VSS.t722 VSS.t4262 24.6737
R7097 VSS.t667 VSS.t4281 24.6737
R7098 VSS.t652 VSS.t4286 24.6737
R7099 VSS.t4326 VSS.t527 24.6737
R7100 VSS.t12 VSS.n14762 24.4711
R7101 VSS.t63 VSS.n1002 24.0946
R7102 VSS.t92 VSS.n898 24.0946
R7103 VSS.t245 VSS.n687 24.0946
R7104 VSS.n282 VSS.t241 24.0946
R7105 VSS.n15340 VSS.n15271 23.7181
R7106 VSS.n526 VSS.n467 23.7181
R7107 VSS.n1258 VSS.n465 23.7181
R7108 VSS.n1108 VSS.n1107 23.7181
R7109 VSS.t41 VSS.n556 23.7181
R7110 VSS.n915 VSS.n579 23.7181
R7111 VSS.n706 VSS.n630 23.7181
R7112 VSS.n15255 VSS.n240 23.7181
R7113 VSS.n14789 VSS.t104 23.7181
R7114 VSS.t236 VSS.n14832 23.7181
R7115 VSS.n287 VSS.n242 23.7181
R7116 VSS.n14286 VSS.t197 22.9652
R7117 VSS.t147 VSS.n15144 22.9652
R7118 VSS.n14769 VSS.t136 22.9652
R7119 VSS.t251 VSS.n15140 22.7306
R7120 VSS.n1112 VSS.t41 22.2123
R7121 VSS.t3369 VSS.n641 22.2123
R7122 VSS.t65 VSS.n643 22.2123
R7123 VSS.t3369 VSS.n677 22.2123
R7124 VSS.t36 VSS.n39 29.5451
R7125 VSS.t36 VSS.n58 5.06252
R7126 VSS.t3440 VSS.t3326 22.2123
R7127 VSS.n15045 VSS.t3290 22.2123
R7128 VSS.n14788 VSS.t3246 21.8358
R7129 VSS.t230 VSS.n14291 21.8358
R7130 VSS.n14794 VSS.t104 21.4593
R7131 VSS.n15065 VSS.t52 21.4593
R7132 VSS.t52 VSS.n310 21.4593
R7133 VSS.t193 VSS.n15101 21.4593
R7134 VSS.t3405 VSS.n14841 20.7064
R7135 VSS.n14917 VSS.t3257 20.7064
R7136 VSS.n1003 VSS.t63 20.3299
R7137 VSS.n13686 VSS.n13685 20.2516
R7138 VSS.n13695 VSS.n13670 20.2516
R7139 VSS.t3094 VSS.n3466 20.015
R7140 VSS.t3079 VSS.n3516 20.015
R7141 VSS.t3064 VSS.n3566 20.015
R7142 VSS.t3049 VSS.n3616 20.015
R7143 VSS.t3034 VSS.n3666 20.015
R7144 VSS.t3019 VSS.n3716 20.015
R7145 VSS.n5242 VSS.t2876 20.015
R7146 VSS.n5348 VSS.t2861 20.015
R7147 VSS.n5454 VSS.t2846 20.015
R7148 VSS.n5560 VSS.t2831 20.015
R7149 VSS.n5666 VSS.t2816 20.015
R7150 VSS.n5772 VSS.t2801 20.015
R7151 VSS.t2661 VSS.n4489 20.015
R7152 VSS.t2646 VSS.n4539 20.015
R7153 VSS.t2631 VSS.n4589 20.015
R7154 VSS.t2616 VSS.n4639 20.015
R7155 VSS.t2601 VSS.n4689 20.015
R7156 VSS.t2586 VSS.n4739 20.015
R7157 VSS.t2446 VSS.n6570 20.015
R7158 VSS.t2431 VSS.n6620 20.015
R7159 VSS.t2416 VSS.n6670 20.015
R7160 VSS.t2401 VSS.n6720 20.015
R7161 VSS.t2386 VSS.n6770 20.015
R7162 VSS.t2371 VSS.n6820 20.015
R7163 VSS.n7724 VSS.t2231 20.015
R7164 VSS.n7830 VSS.t2216 20.015
R7165 VSS.n7936 VSS.t2201 20.015
R7166 VSS.n8042 VSS.t2186 20.015
R7167 VSS.n8148 VSS.t2171 20.015
R7168 VSS.n8254 VSS.t2156 20.015
R7169 VSS.n8762 VSS.t2016 20.015
R7170 VSS.n8868 VSS.t2001 20.015
R7171 VSS.n8974 VSS.t1986 20.015
R7172 VSS.n9080 VSS.t1971 20.015
R7173 VSS.n9186 VSS.t1956 20.015
R7174 VSS.n9292 VSS.t1941 20.015
R7175 VSS.t1801 VSS.n1936 20.015
R7176 VSS.t1786 VSS.n1986 20.015
R7177 VSS.t1771 VSS.n2036 20.015
R7178 VSS.t1756 VSS.n2086 20.015
R7179 VSS.t1741 VSS.n2136 20.015
R7180 VSS.t1726 VSS.n2186 20.015
R7181 VSS.t1583 VSS.n10090 20.015
R7182 VSS.t1568 VSS.n10140 20.015
R7183 VSS.t1553 VSS.n10190 20.015
R7184 VSS.t1538 VSS.n10240 20.015
R7185 VSS.t1523 VSS.n10290 20.015
R7186 VSS.t1508 VSS.n10340 20.015
R7187 VSS.n11244 VSS.t1368 20.015
R7188 VSS.n11350 VSS.t1353 20.015
R7189 VSS.n11456 VSS.t1338 20.015
R7190 VSS.n11562 VSS.t1323 20.015
R7191 VSS.n11668 VSS.t1308 20.015
R7192 VSS.n11774 VSS.t1293 20.015
R7193 VSS.n12282 VSS.t1153 20.015
R7194 VSS.n12388 VSS.t1138 20.015
R7195 VSS.n12494 VSS.t1123 20.015
R7196 VSS.n12600 VSS.t1108 20.015
R7197 VSS.n12706 VSS.t1093 20.015
R7198 VSS.n12812 VSS.t1078 20.015
R7199 VSS.t938 VSS.n1295 20.015
R7200 VSS.t923 VSS.n1345 20.015
R7201 VSS.t908 VSS.n1395 20.015
R7202 VSS.t893 VSS.n1445 20.015
R7203 VSS.t878 VSS.n1495 20.015
R7204 VSS.t863 VSS.n1545 20.015
R7205 VSS.t723 VSS.n13610 20.015
R7206 VSS.t668 VSS.n13777 20.015
R7207 VSS.t653 VSS.n13827 20.015
R7208 VSS.n14684 VSS.t528 20.015
R7209 VSS.n4461 VSS.n3442 19.8499
R7210 VSS.n4297 VSS.n4296 19.8499
R7211 VSS.n4196 VSS.n4195 19.8499
R7212 VSS.n4095 VSS.n4094 19.8499
R7213 VSS.n3994 VSS.n3993 19.8499
R7214 VSS.n3893 VSS.n3892 19.8499
R7215 VSS.n5110 VSS.n5109 19.8499
R7216 VSS.n5294 VSS.n5293 19.8499
R7217 VSS.n5400 VSS.n5399 19.8499
R7218 VSS.n5506 VSS.n5505 19.8499
R7219 VSS.n5612 VSS.n5611 19.8499
R7220 VSS.n5718 VSS.n5717 19.8499
R7221 VSS.n6542 VSS.n4465 19.8499
R7222 VSS.n6378 VSS.n6377 19.8499
R7223 VSS.n6277 VSS.n6276 19.8499
R7224 VSS.n6176 VSS.n6175 19.8499
R7225 VSS.n6075 VSS.n6074 19.8499
R7226 VSS.n5974 VSS.n5973 19.8499
R7227 VSS.n7584 VSS.n6546 19.8499
R7228 VSS.n7420 VSS.n7419 19.8499
R7229 VSS.n7319 VSS.n7318 19.8499
R7230 VSS.n7218 VSS.n7217 19.8499
R7231 VSS.n7117 VSS.n7116 19.8499
R7232 VSS.n7016 VSS.n7015 19.8499
R7233 VSS.n7671 VSS.n7670 19.8499
R7234 VSS.n7776 VSS.n7775 19.8499
R7235 VSS.n7882 VSS.n7881 19.8499
R7236 VSS.n7988 VSS.n7987 19.8499
R7237 VSS.n8094 VSS.n8093 19.8499
R7238 VSS.n8200 VSS.n8199 19.8499
R7239 VSS.n8630 VSS.n8629 19.8499
R7240 VSS.n8814 VSS.n8813 19.8499
R7241 VSS.n8920 VSS.n8919 19.8499
R7242 VSS.n9026 VSS.n9025 19.8499
R7243 VSS.n9132 VSS.n9131 19.8499
R7244 VSS.n9238 VSS.n9237 19.8499
R7245 VSS.n10062 VSS.n1912 19.8499
R7246 VSS.n9898 VSS.n9897 19.8499
R7247 VSS.n9797 VSS.n9796 19.8499
R7248 VSS.n9696 VSS.n9695 19.8499
R7249 VSS.n9595 VSS.n9594 19.8499
R7250 VSS.n9494 VSS.n9493 19.8499
R7251 VSS.n11104 VSS.n10066 19.8499
R7252 VSS.n10940 VSS.n10939 19.8499
R7253 VSS.n10839 VSS.n10838 19.8499
R7254 VSS.n10738 VSS.n10737 19.8499
R7255 VSS.n10637 VSS.n10636 19.8499
R7256 VSS.n10536 VSS.n10535 19.8499
R7257 VSS.n11191 VSS.n11190 19.8499
R7258 VSS.n11296 VSS.n11295 19.8499
R7259 VSS.n11402 VSS.n11401 19.8499
R7260 VSS.n11508 VSS.n11507 19.8499
R7261 VSS.n11614 VSS.n11613 19.8499
R7262 VSS.n11720 VSS.n11719 19.8499
R7263 VSS.n12150 VSS.n12149 19.8499
R7264 VSS.n12334 VSS.n12333 19.8499
R7265 VSS.n12440 VSS.n12439 19.8499
R7266 VSS.n12546 VSS.n12545 19.8499
R7267 VSS.n12652 VSS.n12651 19.8499
R7268 VSS.n12758 VSS.n12757 19.8499
R7269 VSS.n13582 VSS.n1271 19.8499
R7270 VSS.n13418 VSS.n13417 19.8499
R7271 VSS.n13317 VSS.n13316 19.8499
R7272 VSS.n13216 VSS.n13215 19.8499
R7273 VSS.n13115 VSS.n13114 19.8499
R7274 VSS.n13014 VSS.n13013 19.8499
R7275 VSS.n14547 VSS.n13586 19.8499
R7276 VSS.n14383 VSS.n14382 19.8499
R7277 VSS.n14124 VSS.n14123 19.8499
R7278 VSS.n14023 VSS.n14022 19.8499
R7279 VSS.n14631 VSS.n14630 19.8499
R7280 VSS.t3278 VSS.n496 19.577
R7281 VSS.t96 VSS.n1245 19.577
R7282 VSS.n1118 VSS.t3373 19.577
R7283 VSS.n1008 VSS.t5 19.577
R7284 VSS.n899 VSS.t94 19.577
R7285 VSS.t28 VSS.n785 19.577
R7286 VSS.t204 VSS.n638 19.577
R7287 VSS.t243 VSS.n286 19.577
R7288 VSS.n14841 VSS.t214 19.2005
R7289 VSS.n13673 VSS.n13672 19.0176
R7290 VSS.n13698 VSS.n13697 19.0176
R7291 VSS.t100 VSS.t3380 18.824
R7292 VSS.t54 VSS.t74 18.0711
R7293 VSS.t189 VSS.t76 18.0711
R7294 VSS.n15041 VSS.t154 18.0711
R7295 VSS.t149 VSS.n14812 17.6946
R7296 VSS.t46 VSS.t3408 17.3181
R7297 VSS.t134 VSS.t3255 17.3181
R7298 VSS.n521 VSS.n520 17.1007
R7299 VSS.n1195 VSS.n1194 17.1007
R7300 VSS.n1054 VSS.n1053 17.1007
R7301 VSS.n939 VSS.n938 17.1007
R7302 VSS.n827 VSS.n826 17.1007
R7303 VSS.n756 VSS.n612 17.1007
R7304 VSS.n659 VSS.n658 17.1007
R7305 VSS.n2601 VSS.n2600 17.1007
R7306 VSS.n2628 VSS.n2627 17.1007
R7307 VSS.n3421 VSS.n3420 17.1007
R7308 VSS.n3369 VSS.n2697 17.1007
R7309 VSS.n3317 VSS.n2717 17.1007
R7310 VSS.n3265 VSS.n2737 17.1007
R7311 VSS.n3213 VSS.n2757 17.1007
R7312 VSS.n3161 VSS.n2777 17.1007
R7313 VSS.n3109 VSS.n2797 17.1007
R7314 VSS.n3057 VSS.n2817 17.1007
R7315 VSS.n3005 VSS.n2837 17.1007
R7316 VSS.n2953 VSS.n2857 17.1007
R7317 VSS.n2901 VSS.n2887 17.1007
R7318 VSS.n15130 VSS.n15081 17.0578
R7319 VSS.t3277 VSS.n549 16.9417
R7320 VSS.n14795 VSS.t441 16.9417
R7321 VSS.t184 VSS.t697 16.8587
R7322 VSS.t517 VSS.t112 16.8587
R7323 VSS.n479 VSS.n478 16.7924
R7324 VSS.n803 VSS.n802 16.7924
R7325 VSS.t3555 VSS.t2899 16.6901
R7326 VSS.t3975 VSS.t1606 16.6901
R7327 VSS.t3308 VSS.t138 16.5652
R7328 VSS.n15318 VSS.n15317 16.3546
R7329 VSS.n86 VSS.t384 4.76073
R7330 VSS.n1172 VSS.n537 16.3546
R7331 VSS.n1079 VSS.n1078 16.3546
R7332 VSS.n964 VSS.n963 16.3546
R7333 VSS.n852 VSS.n851 16.3546
R7334 VSS.n733 VSS.n621 16.3546
R7335 VSS.n14340 VSS.n13657 16.3546
R7336 VSS.n87 VSS.t3229 4.76073
R7337 VSS.n2653 VSS.n2652 16.3546
R7338 VSS.n3398 VSS.n2686 16.3546
R7339 VSS.n3346 VSS.n2706 16.3546
R7340 VSS.n3294 VSS.n2726 16.3546
R7341 VSS.n3242 VSS.n2746 16.3546
R7342 VSS.n3190 VSS.n2766 16.3546
R7343 VSS.n3138 VSS.n2786 16.3546
R7344 VSS.n3086 VSS.n2806 16.3546
R7345 VSS.n3034 VSS.n2826 16.3546
R7346 VSS.n2982 VSS.n2846 16.3546
R7347 VSS.n2930 VSS.n2866 16.3546
R7348 VSS.n15218 VSS.n15217 16.1994
R7349 VSS.n14710 VSS.t525 16.1917
R7350 VSS.n14729 VSS.t522 16.1917
R7351 VSS.t217 VSS.n15014 16.1887
R7352 VSS.n15296 VSS.n15295 16.0891
R7353 VSS.n258 VSS.n253 16.0891
R7354 VSS.n15141 VSS.t100 15.8123
R7355 VSS.t57 VSS.t116 15.8123
R7356 VSS.n14947 VSS.n14946 15.4962
R7357 VSS.t26 VSS.n601 15.4598
R7358 VSS.t227 VSS.n13708 15.4358
R7359 VSS.n14813 VSS.t3286 15.4358
R7360 VSS.n1122 VSS.t3375 15.1514
R7361 VSS.n1220 VSS.n1219 15.0834
R7362 VSS.n1104 VSS.n560 15.0834
R7363 VSS.n14315 VSS.n13667 15.0834
R7364 VSS.n5847 VSS.n5812 14.8998
R7365 VSS.n4812 VSS.n4811 14.8998
R7366 VSS.n6893 VSS.n6892 14.8998
R7367 VSS.n8329 VSS.n8294 14.8998
R7368 VSS.n9367 VSS.n9332 14.8998
R7369 VSS.n10413 VSS.n10412 14.8998
R7370 VSS.n11849 VSS.n11814 14.8998
R7371 VSS.n12887 VSS.n12852 14.8998
R7372 VSS.n1618 VSS.n1617 14.8998
R7373 VSS.n13900 VSS.n13899 14.8998
R7374 VSS.n15196 VSS.n15195 14.8998
R7375 VSS.n14975 VSS.n14974 14.8998
R7376 VSS.n526 VSS.n466 14.8179
R7377 VSS.n1255 VSS.n527 14.8179
R7378 VSS.n1107 VSS.n558 14.8179
R7379 VSS.n992 VSS.n576 14.8179
R7380 VSS.n880 VSS.n591 14.8179
R7381 VSS.n877 VSS.n592 14.8179
R7382 VSS.n758 VSS.n610 14.8179
R7383 VSS.t65 VSS.n672 14.8179
R7384 VSS.n668 VSS.n667 14.8179
R7385 VSS.n667 VSS.n663 14.8179
R7386 VSS.n2903 VSS.n2885 14.8179
R7387 VSS.n2606 VSS.n2540 14.8179
R7388 VSS.n3429 VSS.n2539 14.8179
R7389 VSS.n3426 VSS.n2607 14.8179
R7390 VSS.n3371 VSS.n2695 14.8179
R7391 VSS.n3319 VSS.n2715 14.8179
R7392 VSS.n3267 VSS.n2735 14.8179
R7393 VSS.n3215 VSS.n2755 14.8179
R7394 VSS.n3163 VSS.n2775 14.8179
R7395 VSS.n3111 VSS.n2795 14.8179
R7396 VSS.n3059 VSS.n2815 14.8179
R7397 VSS.n3007 VSS.n2835 14.8179
R7398 VSS.n2955 VSS.n2855 14.8179
R7399 VSS.t433 VSS.n373 14.775
R7400 VSS.n1255 VSS.n1254 14.775
R7401 VSS.n1145 VSS.n546 14.775
R7402 VSS.n989 VSS.n577 14.775
R7403 VSS.n15224 VSS.n304 14.775
R7404 VSS.n14295 VSS.t3267 14.7246
R7405 VSS.n492 VSS.t3377 14.4482
R7406 VSS.t98 VSS.n1244 14.4482
R7407 VSS.n1012 VSS.t132 14.4482
R7408 VSS.n15228 VSS.t187 14.3304
R7409 VSS.n5870 VSS.n5869 14.2249
R7410 VSS.n4834 VSS.n4833 14.2249
R7411 VSS.n6915 VSS.n6914 14.2249
R7412 VSS.n8352 VSS.n8351 14.2249
R7413 VSS.n9390 VSS.n9389 14.2249
R7414 VSS.n10435 VSS.n10434 14.2249
R7415 VSS.n11872 VSS.n11871 14.2249
R7416 VSS.n12910 VSS.n12909 14.2249
R7417 VSS.n1640 VSS.n1639 14.2249
R7418 VSS.n13922 VSS.n13921 14.2249
R7419 VSS.t3326 VSS.t3385 14.1852
R7420 VSS.n1259 VSS.n1258 14.0717
R7421 VSS.n1149 VSS.n546 14.0717
R7422 VSS.n1104 VSS.n1103 14.0717
R7423 VSS.n989 VSS.n988 14.0717
R7424 VSS.n881 VSS.n880 14.0717
R7425 VSS.n877 VSS.n876 14.0717
R7426 VSS.n762 VSS.n610 14.0717
R7427 VSS.n710 VSS.n630 14.0717
R7428 VSS.n15255 VSS.n15254 14.0717
R7429 VSS.n15344 VSS.n15271 14.0717
R7430 VSS.n2606 VSS.n2541 14.0717
R7431 VSS.n3430 VSS.n3429 14.0717
R7432 VSS.n3426 VSS.n2608 14.0717
R7433 VSS.n3375 VSS.n2695 14.0717
R7434 VSS.n3323 VSS.n2715 14.0717
R7435 VSS.n3271 VSS.n2735 14.0717
R7436 VSS.n3219 VSS.n2755 14.0717
R7437 VSS.n3167 VSS.n2775 14.0717
R7438 VSS.n3115 VSS.n2795 14.0717
R7439 VSS.n3063 VSS.n2815 14.0717
R7440 VSS.n3011 VSS.n2835 14.0717
R7441 VSS.n2959 VSS.n2855 14.0717
R7442 VSS.n2907 VSS.n2885 14.0717
R7443 VSS.t266 VSS.n14262 14.022
R7444 VSS.n1133 VSS.t3242 13.9299
R7445 VSS.t143 VSS.n15006 13.9299
R7446 VSS.n425 VSS.n422 13.662
R7447 VSS.n407 VSS.n404 13.662
R7448 VSS.n14857 VSS.t3308 13.6456
R7449 VSS.n14266 VSS.n13720 13.6328
R7450 VSS.n14853 VSS.t173 13.5534
R7451 VSS.t3403 VSS.t220 13.5534
R7452 VSS.t3403 VSS.t151 13.5534
R7453 VSS.t151 VSS.t191 13.5534
R7454 VSS.n14832 VSS.t510 13.2179
R7455 VSS.t4274 VSS.n14217 13.1053
R7456 VSS.t4265 VSS.n14360 13.0021
R7457 VSS.t197 VSS.n13710 12.8245
R7458 VSS.n992 VSS.n574 12.8005
R7459 VSS.n14292 VSS.t230 12.8005
R7460 VSS.n14785 VSS.t3246 12.8005
R7461 VSS.n15145 VSS.t147 12.5161
R7462 VSS.n4444 VSS.t3106 12.4514
R7463 VSS.t3091 VSS.n3482 12.4514
R7464 VSS.t3076 VSS.n3532 12.4514
R7465 VSS.t3061 VSS.n3582 12.4514
R7466 VSS.t3046 VSS.n3632 12.4514
R7467 VSS.t3031 VSS.n3682 12.4514
R7468 VSS.n5176 VSS.t2888 12.4514
R7469 VSS.n5268 VSS.t2873 12.4514
R7470 VSS.n5374 VSS.t2858 12.4514
R7471 VSS.n5480 VSS.t2843 12.4514
R7472 VSS.n5586 VSS.t2828 12.4514
R7473 VSS.n5692 VSS.t2813 12.4514
R7474 VSS.n6525 VSS.t2673 12.4514
R7475 VSS.t2658 VSS.n4505 12.4514
R7476 VSS.t2643 VSS.n4555 12.4514
R7477 VSS.t2628 VSS.n4605 12.4514
R7478 VSS.t2613 VSS.n4655 12.4514
R7479 VSS.t2598 VSS.n4705 12.4514
R7480 VSS.n7567 VSS.t2458 12.4514
R7481 VSS.t2443 VSS.n6586 12.4514
R7482 VSS.t2428 VSS.n6636 12.4514
R7483 VSS.t2413 VSS.n6686 12.4514
R7484 VSS.t2398 VSS.n6736 12.4514
R7485 VSS.t2383 VSS.n6786 12.4514
R7486 VSS.n7653 VSS.t2243 12.4514
R7487 VSS.n7750 VSS.t2228 12.4514
R7488 VSS.n7856 VSS.t2213 12.4514
R7489 VSS.n7962 VSS.t2198 12.4514
R7490 VSS.n8068 VSS.t2183 12.4514
R7491 VSS.n8174 VSS.t2168 12.4514
R7492 VSS.n8696 VSS.t2028 12.4514
R7493 VSS.n8788 VSS.t2013 12.4514
R7494 VSS.n8894 VSS.t1998 12.4514
R7495 VSS.n9000 VSS.t1983 12.4514
R7496 VSS.n9106 VSS.t1968 12.4514
R7497 VSS.n9212 VSS.t1953 12.4514
R7498 VSS.n10045 VSS.t1813 12.4514
R7499 VSS.t1798 VSS.n1952 12.4514
R7500 VSS.t1783 VSS.n2002 12.4514
R7501 VSS.t1768 VSS.n2052 12.4514
R7502 VSS.t1753 VSS.n2102 12.4514
R7503 VSS.t1738 VSS.n2152 12.4514
R7504 VSS.n11087 VSS.t1595 12.4514
R7505 VSS.t1580 VSS.n10106 12.4514
R7506 VSS.t1565 VSS.n10156 12.4514
R7507 VSS.t1550 VSS.n10206 12.4514
R7508 VSS.t1535 VSS.n10256 12.4514
R7509 VSS.t1520 VSS.n10306 12.4514
R7510 VSS.n11173 VSS.t1380 12.4514
R7511 VSS.n11270 VSS.t1365 12.4514
R7512 VSS.n11376 VSS.t1350 12.4514
R7513 VSS.n11482 VSS.t1335 12.4514
R7514 VSS.n11588 VSS.t1320 12.4514
R7515 VSS.n11694 VSS.t1305 12.4514
R7516 VSS.n12216 VSS.t1165 12.4514
R7517 VSS.n12308 VSS.t1150 12.4514
R7518 VSS.n12414 VSS.t1135 12.4514
R7519 VSS.n12520 VSS.t1120 12.4514
R7520 VSS.n12626 VSS.t1105 12.4514
R7521 VSS.n12732 VSS.t1090 12.4514
R7522 VSS.n13565 VSS.t950 12.4514
R7523 VSS.t935 VSS.n1311 12.4514
R7524 VSS.t920 VSS.n1361 12.4514
R7525 VSS.t905 VSS.n1411 12.4514
R7526 VSS.t890 VSS.n1461 12.4514
R7527 VSS.t875 VSS.n1511 12.4514
R7528 VSS.n14530 VSS.t735 12.4514
R7529 VSS.t720 VSS.n13626 12.4514
R7530 VSS.t680 VSS.n13744 12.4514
R7531 VSS.t665 VSS.n13793 12.4514
R7532 VSS.n14613 VSS.t540 12.4514
R7533 VSS.t3411 VSS.n14846 11.9309
R7534 VSS.t3306 VSS.t3303 11.6711
R7535 VSS.n3765 VSS.n3764 11.1573
R7536 VSS.n3783 VSS.t3521 11.1573
R7537 VSS.t3490 VSS.n4395 11.1573
R7538 VSS.n4275 VSS.t3495 11.1573
R7539 VSS.n4174 VSS.t3500 11.1573
R7540 VSS.n4073 VSS.t3505 11.1573
R7541 VSS.n3972 VSS.t3510 11.1573
R7542 VSS.n3871 VSS.t3515 11.1573
R7543 VSS.t3560 VSS.n5206 11.1573
R7544 VSS.t3565 VSS.n5312 11.1573
R7545 VSS.t3570 VSS.n5418 11.1573
R7546 VSS.t3575 VSS.n5524 11.1573
R7547 VSS.t3580 VSS.n5630 11.1573
R7548 VSS.t3585 VSS.n5736 11.1573
R7549 VSS.t3630 VSS.n6476 11.1573
R7550 VSS.n6356 VSS.t3635 11.1573
R7551 VSS.n6255 VSS.t3640 11.1573
R7552 VSS.n6154 VSS.t3645 11.1573
R7553 VSS.n6053 VSS.t3650 11.1573
R7554 VSS.n5952 VSS.t3655 11.1573
R7555 VSS.t3700 VSS.n7518 11.1573
R7556 VSS.n7398 VSS.t3705 11.1573
R7557 VSS.n7297 VSS.t3710 11.1573
R7558 VSS.n7196 VSS.t3715 11.1573
R7559 VSS.n7095 VSS.t3720 11.1573
R7560 VSS.n6994 VSS.t3725 11.1573
R7561 VSS.t3770 VSS.n7688 11.1573
R7562 VSS.t3775 VSS.n7794 11.1573
R7563 VSS.t3780 VSS.n7900 11.1573
R7564 VSS.t3785 VSS.n8006 11.1573
R7565 VSS.t3790 VSS.n8112 11.1573
R7566 VSS.t3795 VSS.n8218 11.1573
R7567 VSS.t3840 VSS.n8726 11.1573
R7568 VSS.t3845 VSS.n8832 11.1573
R7569 VSS.t3850 VSS.n8938 11.1573
R7570 VSS.t3855 VSS.n9044 11.1573
R7571 VSS.t3860 VSS.n9150 11.1573
R7572 VSS.t3865 VSS.n9256 11.1573
R7573 VSS.n2235 VSS.n2234 11.1573
R7574 VSS.n2253 VSS.t3941 11.1573
R7575 VSS.t3910 VSS.n9996 11.1573
R7576 VSS.n9876 VSS.t3915 11.1573
R7577 VSS.n9775 VSS.t3920 11.1573
R7578 VSS.n9674 VSS.t3925 11.1573
R7579 VSS.n9573 VSS.t3930 11.1573
R7580 VSS.n9472 VSS.t3935 11.1573
R7581 VSS.t3980 VSS.n11038 11.1573
R7582 VSS.n10918 VSS.t3985 11.1573
R7583 VSS.n10817 VSS.t3990 11.1573
R7584 VSS.n10716 VSS.t3995 11.1573
R7585 VSS.n10615 VSS.t4000 11.1573
R7586 VSS.n10514 VSS.t4005 11.1573
R7587 VSS.t4050 VSS.n11208 11.1573
R7588 VSS.t4055 VSS.n11314 11.1573
R7589 VSS.t4060 VSS.n11420 11.1573
R7590 VSS.t4065 VSS.n11526 11.1573
R7591 VSS.t4070 VSS.n11632 11.1573
R7592 VSS.t4075 VSS.n11738 11.1573
R7593 VSS.t4120 VSS.n12246 11.1573
R7594 VSS.t4125 VSS.n12352 11.1573
R7595 VSS.t4130 VSS.n12458 11.1573
R7596 VSS.t4135 VSS.n12564 11.1573
R7597 VSS.t4140 VSS.n12670 11.1573
R7598 VSS.t4145 VSS.n12776 11.1573
R7599 VSS.t4190 VSS.n13516 11.1573
R7600 VSS.n13396 VSS.t4195 11.1573
R7601 VSS.n13295 VSS.t4200 11.1573
R7602 VSS.n13194 VSS.t4205 11.1573
R7603 VSS.n13093 VSS.t4210 11.1573
R7604 VSS.n12992 VSS.t4215 11.1573
R7605 VSS.t4260 VSS.n14481 11.1573
R7606 VSS.n14361 VSS.t4265 11.1573
R7607 VSS.n14218 VSS.t4274 11.1573
R7608 VSS.n14102 VSS.t4279 11.1573
R7609 VSS.n14001 VSS.t4284 11.1573
R7610 VSS.t4324 VSS.n14648 11.1573
R7611 VSS.t512 VSS.n14795 10.8313
R7612 VSS.t502 VSS.t207 10.8313
R7613 VSS.n14315 VSS.n218 11.7193
R7614 VSS.t266 VSS.n13720 10.5417
R7615 VSS.n14812 VSS.t3294 10.5417
R7616 VSS.t270 VSS.t143 10.5417
R7617 VSS.n15224 VSS.t405 10.4353
R7618 VSS.t125 VSS.t493 10.4353
R7619 VSS.t3015 VSS.t3518 10.3951
R7620 VSS.t2797 VSS.t3588 10.3951
R7621 VSS.t2582 VSS.t3658 10.3951
R7622 VSS.t2367 VSS.t3728 10.3951
R7623 VSS.t2152 VSS.t3798 10.3951
R7624 VSS.t1937 VSS.t3868 10.3951
R7625 VSS.t1722 VSS.t3938 10.3951
R7626 VSS.t1504 VSS.t4008 10.3951
R7627 VSS.t1289 VSS.t4078 10.3951
R7628 VSS.t1074 VSS.t4148 10.3951
R7629 VSS.t859 VSS.t4218 10.3951
R7630 VSS.t649 VSS.t4287 10.3951
R7631 VSS.n13698 VSS.t4303 10.1916
R7632 VSS.t4302 VSS.n13672 10.1916
R7633 VSS.n14763 VSS.t12 10.1652
R7634 VSS.n14913 VSS.t134 10.1652
R7635 VSS.n15015 VSS.t270 10.1652
R7636 VSS.n14292 VSS.t3267 9.97351
R7637 VSS.n15293 VSS.t3112 9.83768
R7638 VSS.n476 VSS.t394 9.83768
R7639 VSS.n255 VSS.t276 9.83768
R7640 VSS.n2552 VSS.t3239 9.83768
R7641 VSS.t3366 VSS.t48 9.78874
R7642 VSS.t193 VSS.t48 9.78874
R7643 VSS.n911 VSS.t3284 9.41227
R7644 VSS.t3353 VSS.n14247 9.41227
R7645 VSS.t176 VSS.t138 9.41227
R7646 VSS.n15297 VSS.n15296 9.3005
R7647 VSS.n15298 VSS.n15291 9.3005
R7648 VSS.n15300 VSS.n15299 9.3005
R7649 VSS.n15288 VSS.n15286 9.3005
R7650 VSS.n15307 VSS.n15306 9.3005
R7651 VSS.n15308 VSS.n15285 9.3005
R7652 VSS.n15310 VSS.n15309 9.3005
R7653 VSS.n15311 VSS.n15284 9.3005
R7654 VSS.n15313 VSS.n15312 9.3005
R7655 VSS.n15314 VSS.n15283 9.3005
R7656 VSS.n15316 VSS.n15315 9.3005
R7657 VSS.n15317 VSS.n15282 9.3005
R7658 VSS.n15319 VSS.n15318 9.3005
R7659 VSS.n15320 VSS.n15281 9.3005
R7660 VSS.n15322 VSS.n15321 9.3005
R7661 VSS.n15278 VSS.n15276 9.3005
R7662 VSS.n15329 VSS.n15328 9.3005
R7663 VSS.n15330 VSS.n15275 9.3005
R7664 VSS.n15332 VSS.n15331 9.3005
R7665 VSS.n15333 VSS.n15274 9.3005
R7666 VSS.n15335 VSS.n15334 9.3005
R7667 VSS.n15336 VSS.n15273 9.3005
R7668 VSS.n15338 VSS.n15337 9.3005
R7669 VSS.n15339 VSS.n15272 9.3005
R7670 VSS.n15341 VSS.n15340 9.3005
R7671 VSS.n15342 VSS.n15271 9.3005
R7672 VSS.n15344 VSS.n15343 9.3005
R7673 VSS.n15347 VSS.n239 9.3005
R7674 VSS.n15349 VSS.n15348 9.3005
R7675 VSS.n15351 VSS.n15350 9.3005
R7676 VSS.n238 VSS.n235 9.3005
R7677 VSS.n1 VSS.n0 0.142246
R7678 VSS.n0 VSS.n125 2.47539
R7679 VSS.n161 VSS.n0 3.82243
R7680 VSS.n2892 VSS.n0 9.3005
R7681 VSS.n0 VSS.n85 9.3005
R7682 VSS.n0 VSS.n32 0.314678
R7683 VSS.n2898 VSS.n2897 9.3005
R7684 VSS.n2899 VSS.n2887 9.3005
R7685 VSS.n2901 VSS.n2900 9.3005
R7686 VSS.n2902 VSS.n2886 9.3005
R7687 VSS.n2904 VSS.n2903 9.3005
R7688 VSS.n2905 VSS.n2885 9.3005
R7689 VSS.n2907 VSS.n2906 9.3005
R7690 VSS.n2910 VSS.n2874 9.3005
R7691 VSS.n2912 VSS.n2911 9.3005
R7692 VSS.n2914 VSS.n2913 9.3005
R7693 VSS.n2873 VSS.n2870 9.3005
R7694 VSS.n2919 VSS.n2869 9.3005
R7695 VSS.n2921 VSS.n2920 9.3005
R7696 VSS.n2922 VSS.n2868 9.3005
R7697 VSS.n2924 VSS.n2923 9.3005
R7698 VSS.n2925 VSS.n2867 9.3005
R7699 VSS.n2927 VSS.n2926 9.3005
R7700 VSS.n2928 VSS.n2866 9.3005
R7701 VSS.n2930 VSS.n2929 9.3005
R7702 VSS.n2933 VSS.n2865 9.3005
R7703 VSS.n2935 VSS.n2934 9.3005
R7704 VSS.n2937 VSS.n2936 9.3005
R7705 VSS.n2864 VSS.n2861 9.3005
R7706 VSS.n2942 VSS.n2860 9.3005
R7707 VSS.n2944 VSS.n2943 9.3005
R7708 VSS.n2945 VSS.n2859 9.3005
R7709 VSS.n2947 VSS.n2946 9.3005
R7710 VSS.n2948 VSS.n2858 9.3005
R7711 VSS.n2950 VSS.n2949 9.3005
R7712 VSS.n2951 VSS.n2857 9.3005
R7713 VSS.n2953 VSS.n2952 9.3005
R7714 VSS.n2954 VSS.n2856 9.3005
R7715 VSS.n2956 VSS.n2955 9.3005
R7716 VSS.n2957 VSS.n2855 9.3005
R7717 VSS.n2959 VSS.n2958 9.3005
R7718 VSS.n2962 VSS.n2854 9.3005
R7719 VSS.n2964 VSS.n2963 9.3005
R7720 VSS.n2966 VSS.n2965 9.3005
R7721 VSS.n2853 VSS.n2850 9.3005
R7722 VSS.n2971 VSS.n2849 9.3005
R7723 VSS.n2973 VSS.n2972 9.3005
R7724 VSS.n2974 VSS.n2848 9.3005
R7725 VSS.n2976 VSS.n2975 9.3005
R7726 VSS.n2977 VSS.n2847 9.3005
R7727 VSS.n2979 VSS.n2978 9.3005
R7728 VSS.n2980 VSS.n2846 9.3005
R7729 VSS.n2982 VSS.n2981 9.3005
R7730 VSS.n2985 VSS.n2845 9.3005
R7731 VSS.n2987 VSS.n2986 9.3005
R7732 VSS.n2989 VSS.n2988 9.3005
R7733 VSS.n2844 VSS.n2841 9.3005
R7734 VSS.n2994 VSS.n2840 9.3005
R7735 VSS.n2996 VSS.n2995 9.3005
R7736 VSS.n2997 VSS.n2839 9.3005
R7737 VSS.n2999 VSS.n2998 9.3005
R7738 VSS.n3000 VSS.n2838 9.3005
R7739 VSS.n3002 VSS.n3001 9.3005
R7740 VSS.n3003 VSS.n2837 9.3005
R7741 VSS.n3005 VSS.n3004 9.3005
R7742 VSS.n3006 VSS.n2836 9.3005
R7743 VSS.n3008 VSS.n3007 9.3005
R7744 VSS.n3009 VSS.n2835 9.3005
R7745 VSS.n3011 VSS.n3010 9.3005
R7746 VSS.n3014 VSS.n2834 9.3005
R7747 VSS.n3016 VSS.n3015 9.3005
R7748 VSS.n3018 VSS.n3017 9.3005
R7749 VSS.n2833 VSS.n2830 9.3005
R7750 VSS.n3023 VSS.n2829 9.3005
R7751 VSS.n3025 VSS.n3024 9.3005
R7752 VSS.n3026 VSS.n2828 9.3005
R7753 VSS.n3028 VSS.n3027 9.3005
R7754 VSS.n3029 VSS.n2827 9.3005
R7755 VSS.n3031 VSS.n3030 9.3005
R7756 VSS.n3032 VSS.n2826 9.3005
R7757 VSS.n3034 VSS.n3033 9.3005
R7758 VSS.n3037 VSS.n2825 9.3005
R7759 VSS.n3039 VSS.n3038 9.3005
R7760 VSS.n3041 VSS.n3040 9.3005
R7761 VSS.n2824 VSS.n2821 9.3005
R7762 VSS.n3046 VSS.n2820 9.3005
R7763 VSS.n3048 VSS.n3047 9.3005
R7764 VSS.n3049 VSS.n2819 9.3005
R7765 VSS.n3051 VSS.n3050 9.3005
R7766 VSS.n3052 VSS.n2818 9.3005
R7767 VSS.n3054 VSS.n3053 9.3005
R7768 VSS.n3055 VSS.n2817 9.3005
R7769 VSS.n3057 VSS.n3056 9.3005
R7770 VSS.n3058 VSS.n2816 9.3005
R7771 VSS.n3060 VSS.n3059 9.3005
R7772 VSS.n3061 VSS.n2815 9.3005
R7773 VSS.n3063 VSS.n3062 9.3005
R7774 VSS.n3066 VSS.n2814 9.3005
R7775 VSS.n3068 VSS.n3067 9.3005
R7776 VSS.n3070 VSS.n3069 9.3005
R7777 VSS.n2813 VSS.n2810 9.3005
R7778 VSS.n3075 VSS.n2809 9.3005
R7779 VSS.n3077 VSS.n3076 9.3005
R7780 VSS.n3078 VSS.n2808 9.3005
R7781 VSS.n3080 VSS.n3079 9.3005
R7782 VSS.n3081 VSS.n2807 9.3005
R7783 VSS.n3083 VSS.n3082 9.3005
R7784 VSS.n3084 VSS.n2806 9.3005
R7785 VSS.n3086 VSS.n3085 9.3005
R7786 VSS.n3089 VSS.n2805 9.3005
R7787 VSS.n3091 VSS.n3090 9.3005
R7788 VSS.n3093 VSS.n3092 9.3005
R7789 VSS.n2804 VSS.n2801 9.3005
R7790 VSS.n3098 VSS.n2800 9.3005
R7791 VSS.n3100 VSS.n3099 9.3005
R7792 VSS.n3101 VSS.n2799 9.3005
R7793 VSS.n3103 VSS.n3102 9.3005
R7794 VSS.n3104 VSS.n2798 9.3005
R7795 VSS.n3106 VSS.n3105 9.3005
R7796 VSS.n3107 VSS.n2797 9.3005
R7797 VSS.n3109 VSS.n3108 9.3005
R7798 VSS.n3110 VSS.n2796 9.3005
R7799 VSS.n3112 VSS.n3111 9.3005
R7800 VSS.n3113 VSS.n2795 9.3005
R7801 VSS.n3115 VSS.n3114 9.3005
R7802 VSS.n3118 VSS.n2794 9.3005
R7803 VSS.n3120 VSS.n3119 9.3005
R7804 VSS.n3122 VSS.n3121 9.3005
R7805 VSS.n2793 VSS.n2790 9.3005
R7806 VSS.n3127 VSS.n2789 9.3005
R7807 VSS.n3129 VSS.n3128 9.3005
R7808 VSS.n3130 VSS.n2788 9.3005
R7809 VSS.n3132 VSS.n3131 9.3005
R7810 VSS.n3133 VSS.n2787 9.3005
R7811 VSS.n3135 VSS.n3134 9.3005
R7812 VSS.n3136 VSS.n2786 9.3005
R7813 VSS.n3138 VSS.n3137 9.3005
R7814 VSS.n3141 VSS.n2785 9.3005
R7815 VSS.n3143 VSS.n3142 9.3005
R7816 VSS.n3145 VSS.n3144 9.3005
R7817 VSS.n2784 VSS.n2781 9.3005
R7818 VSS.n3150 VSS.n2780 9.3005
R7819 VSS.n3152 VSS.n3151 9.3005
R7820 VSS.n3153 VSS.n2779 9.3005
R7821 VSS.n3155 VSS.n3154 9.3005
R7822 VSS.n3156 VSS.n2778 9.3005
R7823 VSS.n3158 VSS.n3157 9.3005
R7824 VSS.n3159 VSS.n2777 9.3005
R7825 VSS.n3161 VSS.n3160 9.3005
R7826 VSS.n3162 VSS.n2776 9.3005
R7827 VSS.n3164 VSS.n3163 9.3005
R7828 VSS.n3165 VSS.n2775 9.3005
R7829 VSS.n3167 VSS.n3166 9.3005
R7830 VSS.n3170 VSS.n2774 9.3005
R7831 VSS.n3172 VSS.n3171 9.3005
R7832 VSS.n3174 VSS.n3173 9.3005
R7833 VSS.n2773 VSS.n2770 9.3005
R7834 VSS.n3179 VSS.n2769 9.3005
R7835 VSS.n3181 VSS.n3180 9.3005
R7836 VSS.n3182 VSS.n2768 9.3005
R7837 VSS.n3184 VSS.n3183 9.3005
R7838 VSS.n3185 VSS.n2767 9.3005
R7839 VSS.n3187 VSS.n3186 9.3005
R7840 VSS.n3188 VSS.n2766 9.3005
R7841 VSS.n3190 VSS.n3189 9.3005
R7842 VSS.n3193 VSS.n2765 9.3005
R7843 VSS.n3195 VSS.n3194 9.3005
R7844 VSS.n3197 VSS.n3196 9.3005
R7845 VSS.n2764 VSS.n2761 9.3005
R7846 VSS.n3202 VSS.n2760 9.3005
R7847 VSS.n3204 VSS.n3203 9.3005
R7848 VSS.n3205 VSS.n2759 9.3005
R7849 VSS.n3207 VSS.n3206 9.3005
R7850 VSS.n3208 VSS.n2758 9.3005
R7851 VSS.n3210 VSS.n3209 9.3005
R7852 VSS.n3211 VSS.n2757 9.3005
R7853 VSS.n3213 VSS.n3212 9.3005
R7854 VSS.n3214 VSS.n2756 9.3005
R7855 VSS.n3216 VSS.n3215 9.3005
R7856 VSS.n3217 VSS.n2755 9.3005
R7857 VSS.n3219 VSS.n3218 9.3005
R7858 VSS.n3222 VSS.n2754 9.3005
R7859 VSS.n3224 VSS.n3223 9.3005
R7860 VSS.n3226 VSS.n3225 9.3005
R7861 VSS.n2753 VSS.n2750 9.3005
R7862 VSS.n3231 VSS.n2749 9.3005
R7863 VSS.n3233 VSS.n3232 9.3005
R7864 VSS.n3234 VSS.n2748 9.3005
R7865 VSS.n3236 VSS.n3235 9.3005
R7866 VSS.n3237 VSS.n2747 9.3005
R7867 VSS.n3239 VSS.n3238 9.3005
R7868 VSS.n3240 VSS.n2746 9.3005
R7869 VSS.n3242 VSS.n3241 9.3005
R7870 VSS.n3245 VSS.n2745 9.3005
R7871 VSS.n3247 VSS.n3246 9.3005
R7872 VSS.n3249 VSS.n3248 9.3005
R7873 VSS.n2744 VSS.n2741 9.3005
R7874 VSS.n3254 VSS.n2740 9.3005
R7875 VSS.n3256 VSS.n3255 9.3005
R7876 VSS.n3257 VSS.n2739 9.3005
R7877 VSS.n3259 VSS.n3258 9.3005
R7878 VSS.n3260 VSS.n2738 9.3005
R7879 VSS.n3262 VSS.n3261 9.3005
R7880 VSS.n3263 VSS.n2737 9.3005
R7881 VSS.n3265 VSS.n3264 9.3005
R7882 VSS.n3266 VSS.n2736 9.3005
R7883 VSS.n3268 VSS.n3267 9.3005
R7884 VSS.n3269 VSS.n2735 9.3005
R7885 VSS.n3271 VSS.n3270 9.3005
R7886 VSS.n3274 VSS.n2734 9.3005
R7887 VSS.n3276 VSS.n3275 9.3005
R7888 VSS.n3278 VSS.n3277 9.3005
R7889 VSS.n2733 VSS.n2730 9.3005
R7890 VSS.n3283 VSS.n2729 9.3005
R7891 VSS.n3285 VSS.n3284 9.3005
R7892 VSS.n3286 VSS.n2728 9.3005
R7893 VSS.n3288 VSS.n3287 9.3005
R7894 VSS.n3289 VSS.n2727 9.3005
R7895 VSS.n3291 VSS.n3290 9.3005
R7896 VSS.n3292 VSS.n2726 9.3005
R7897 VSS.n3294 VSS.n3293 9.3005
R7898 VSS.n3297 VSS.n2725 9.3005
R7899 VSS.n3299 VSS.n3298 9.3005
R7900 VSS.n3301 VSS.n3300 9.3005
R7901 VSS.n2724 VSS.n2721 9.3005
R7902 VSS.n3306 VSS.n2720 9.3005
R7903 VSS.n3308 VSS.n3307 9.3005
R7904 VSS.n3309 VSS.n2719 9.3005
R7905 VSS.n3311 VSS.n3310 9.3005
R7906 VSS.n3312 VSS.n2718 9.3005
R7907 VSS.n3314 VSS.n3313 9.3005
R7908 VSS.n3315 VSS.n2717 9.3005
R7909 VSS.n3317 VSS.n3316 9.3005
R7910 VSS.n3318 VSS.n2716 9.3005
R7911 VSS.n3320 VSS.n3319 9.3005
R7912 VSS.n3321 VSS.n2715 9.3005
R7913 VSS.n3323 VSS.n3322 9.3005
R7914 VSS.n3326 VSS.n2714 9.3005
R7915 VSS.n3328 VSS.n3327 9.3005
R7916 VSS.n3330 VSS.n3329 9.3005
R7917 VSS.n2713 VSS.n2710 9.3005
R7918 VSS.n3335 VSS.n2709 9.3005
R7919 VSS.n3337 VSS.n3336 9.3005
R7920 VSS.n3338 VSS.n2708 9.3005
R7921 VSS.n3340 VSS.n3339 9.3005
R7922 VSS.n3341 VSS.n2707 9.3005
R7923 VSS.n3343 VSS.n3342 9.3005
R7924 VSS.n3344 VSS.n2706 9.3005
R7925 VSS.n3346 VSS.n3345 9.3005
R7926 VSS.n3349 VSS.n2705 9.3005
R7927 VSS.n3351 VSS.n3350 9.3005
R7928 VSS.n3353 VSS.n3352 9.3005
R7929 VSS.n2704 VSS.n2701 9.3005
R7930 VSS.n3358 VSS.n2700 9.3005
R7931 VSS.n3360 VSS.n3359 9.3005
R7932 VSS.n3361 VSS.n2699 9.3005
R7933 VSS.n3363 VSS.n3362 9.3005
R7934 VSS.n3364 VSS.n2698 9.3005
R7935 VSS.n3366 VSS.n3365 9.3005
R7936 VSS.n3367 VSS.n2697 9.3005
R7937 VSS.n3369 VSS.n3368 9.3005
R7938 VSS.n3370 VSS.n2696 9.3005
R7939 VSS.n3372 VSS.n3371 9.3005
R7940 VSS.n3373 VSS.n2695 9.3005
R7941 VSS.n3375 VSS.n3374 9.3005
R7942 VSS.n3378 VSS.n2694 9.3005
R7943 VSS.n3380 VSS.n3379 9.3005
R7944 VSS.n3382 VSS.n3381 9.3005
R7945 VSS.n2693 VSS.n2690 9.3005
R7946 VSS.n3387 VSS.n2689 9.3005
R7947 VSS.n3389 VSS.n3388 9.3005
R7948 VSS.n3390 VSS.n2688 9.3005
R7949 VSS.n3392 VSS.n3391 9.3005
R7950 VSS.n3393 VSS.n2687 9.3005
R7951 VSS.n3395 VSS.n3394 9.3005
R7952 VSS.n3396 VSS.n2686 9.3005
R7953 VSS.n3398 VSS.n3397 9.3005
R7954 VSS.n3401 VSS.n2685 9.3005
R7955 VSS.n3403 VSS.n3402 9.3005
R7956 VSS.n3405 VSS.n3404 9.3005
R7957 VSS.n2684 VSS.n2681 9.3005
R7958 VSS.n3410 VSS.n2680 9.3005
R7959 VSS.n3412 VSS.n3411 9.3005
R7960 VSS.n3413 VSS.n2679 9.3005
R7961 VSS.n3415 VSS.n3414 9.3005
R7962 VSS.n3416 VSS.n2678 9.3005
R7963 VSS.n3418 VSS.n3417 9.3005
R7964 VSS.n3420 VSS.n3419 9.3005
R7965 VSS.n3421 VSS.n2677 9.3005
R7966 VSS.n3423 VSS.n3422 9.3005
R7967 VSS.n3424 VSS.n2607 9.3005
R7968 VSS.n3426 VSS.n3425 9.3005
R7969 VSS.n2676 VSS.n2608 9.3005
R7970 VSS.n2675 VSS.n2674 9.3005
R7971 VSS.n2610 VSS.n2609 9.3005
R7972 VSS.n2670 VSS.n2669 9.3005
R7973 VSS.n2668 VSS.n2667 9.3005
R7974 VSS.n2663 VSS.n2613 9.3005
R7975 VSS.n2662 VSS.n2661 9.3005
R7976 VSS.n2660 VSS.n2614 9.3005
R7977 VSS.n2659 VSS.n2658 9.3005
R7978 VSS.n2657 VSS.n2615 9.3005
R7979 VSS.n2656 VSS.n2655 9.3005
R7980 VSS.n2654 VSS.n2653 9.3005
R7981 VSS.n2652 VSS.n2616 9.3005
R7982 VSS.n2646 VSS.n2617 9.3005
R7983 VSS.n2648 VSS.n2647 9.3005
R7984 VSS.n2645 VSS.n2619 9.3005
R7985 VSS.n2644 VSS.n2643 9.3005
R7986 VSS.n2638 VSS.n2620 9.3005
R7987 VSS.n2637 VSS.n2636 9.3005
R7988 VSS.n2635 VSS.n2621 9.3005
R7989 VSS.n2634 VSS.n2633 9.3005
R7990 VSS.n2632 VSS.n2622 9.3005
R7991 VSS.n2631 VSS.n2630 9.3005
R7992 VSS.n2629 VSS.n2628 9.3005
R7993 VSS.n2627 VSS.n2623 9.3005
R7994 VSS.n2626 VSS.n2625 9.3005
R7995 VSS.n2624 VSS.n2539 9.3005
R7996 VSS.n3429 VSS.n2538 9.3005
R7997 VSS.n3431 VSS.n3430 9.3005
R7998 VSS.n3432 VSS.n2537 9.3005
R7999 VSS.n3434 VSS.n3433 9.3005
R8000 VSS.n2534 VSS.n35 9.3005
R8001 VSS.n35 VSS.n3440 9.3005
R8002 VSS.n57 VSS.n35 0.142246
R8003 VSS.n87 VSS.n35 2.47539
R8004 VSS.n69 VSS.n35 3.82243
R8005 VSS.n2588 VSS.n35 9.3005
R8006 VSS.n35 VSS.n54 9.3005
R8007 VSS.n35 VSS.n36 3.57362
R8008 VSS.n2593 VSS.n2583 9.3005
R8009 VSS.n2595 VSS.n2594 9.3005
R8010 VSS.n2596 VSS.n2582 9.3005
R8011 VSS.n2598 VSS.n2597 9.3005
R8012 VSS.n2600 VSS.n2599 9.3005
R8013 VSS.n2601 VSS.n2581 9.3005
R8014 VSS.n2603 VSS.n2602 9.3005
R8015 VSS.n2604 VSS.n2540 9.3005
R8016 VSS.n2606 VSS.n2605 9.3005
R8017 VSS.n2580 VSS.n2541 9.3005
R8018 VSS.n2579 VSS.n2578 9.3005
R8019 VSS.n2543 VSS.n2542 9.3005
R8020 VSS.n2574 VSS.n2573 9.3005
R8021 VSS.n2572 VSS.n2571 9.3005
R8022 VSS.n2567 VSS.n2546 9.3005
R8023 VSS.n2566 VSS.n2565 9.3005
R8024 VSS.n2564 VSS.n2547 9.3005
R8025 VSS.n2563 VSS.n2562 9.3005
R8026 VSS.n2561 VSS.n2548 9.3005
R8027 VSS.n2560 VSS.n2559 9.3005
R8028 VSS.n2558 VSS.n2557 9.3005
R8029 VSS.n2556 VSS.n2549 9.3005
R8030 VSS.n2555 VSS.n2554 9.3005
R8031 VSS.n2553 VSS.n2550 9.3005
R8032 VSS.n2552 VSS.n2551 9.3005
R8033 VSS.n15295 VSS.n15292 9.3005
R8034 VSS.n15294 VSS.n15293 9.3005
R8035 VSS.n526 VSS.n525 9.3005
R8036 VSS.n255 VSS.n254 9.3005
R8037 VSS.n256 VSS.n253 9.3005
R8038 VSS.n258 VSS.n257 9.3005
R8039 VSS.n261 VSS.n252 9.3005
R8040 VSS.n263 VSS.n262 9.3005
R8041 VSS.n265 VSS.n264 9.3005
R8042 VSS.n251 VSS.n248 9.3005
R8043 VSS.n270 VSS.n247 9.3005
R8044 VSS.n272 VSS.n271 9.3005
R8045 VSS.n273 VSS.n246 9.3005
R8046 VSS.n275 VSS.n274 9.3005
R8047 VSS.n276 VSS.n245 9.3005
R8048 VSS.n278 VSS.n277 9.3005
R8049 VSS.n280 VSS.n279 9.3005
R8050 VSS.n281 VSS.n244 9.3005
R8051 VSS.n283 VSS.n282 9.3005
R8052 VSS.n284 VSS.t241 9.3005
R8053 VSS.n286 VSS.n285 9.3005
R8054 VSS.t243 VSS.n243 9.3005
R8055 VSS.n288 VSS.n287 9.3005
R8056 VSS.n291 VSS.n290 9.3005
R8057 VSS.n292 VSS.n241 9.3005
R8058 VSS.n294 VSS.n293 9.3005
R8059 VSS.n295 VSS.n240 9.3005
R8060 VSS.n15255 VSS.n296 9.3005
R8061 VSS.n15254 VSS.n15253 9.3005
R8062 VSS.n15252 VSS.n15251 9.3005
R8063 VSS.n298 VSS.n297 9.3005
R8064 VSS.n15247 VSS.n15246 9.3005
R8065 VSS.n15245 VSS.n15244 9.3005
R8066 VSS.n3 VSS.n2 0.142246
R8067 VSS.n126 VSS.n2 2.47539
R8068 VSS.n162 VSS.n2 3.82243
R8069 VSS.n651 VSS.n2 9.3005
R8070 VSS.n2 VSS.n84 9.3005
R8071 VSS.n2 VSS.n31 0.314678
R8072 VSS.n656 VSS.n655 9.3005
R8073 VSS.n658 VSS.n657 9.3005
R8074 VSS.n659 VSS.n646 9.3005
R8075 VSS.n661 VSS.n660 9.3005
R8076 VSS.n663 VSS.n662 9.3005
R8077 VSS.n667 VSS.n645 9.3005
R8078 VSS.n669 VSS.n668 9.3005
R8079 VSS.n671 VSS.n670 9.3005
R8080 VSS.n672 VSS.n644 9.3005
R8081 VSS.n673 VSS.t65 9.3005
R8082 VSS.n674 VSS.n643 9.3005
R8083 VSS.n676 VSS.n675 9.3005
R8084 VSS.n677 VSS.n642 9.3005
R8085 VSS.n678 VSS.t3369 9.3005
R8086 VSS.n679 VSS.n641 9.3005
R8087 VSS.n681 VSS.n680 9.3005
R8088 VSS.n682 VSS.n640 9.3005
R8089 VSS.n684 VSS.n683 9.3005
R8090 VSS.n686 VSS.n685 9.3005
R8091 VSS.n687 VSS.n639 9.3005
R8092 VSS.n688 VSS.t245 9.3005
R8093 VSS.n689 VSS.n638 9.3005
R8094 VSS.t204 VSS.n690 9.3005
R8095 VSS.n691 VSS.n637 9.3005
R8096 VSS.n693 VSS.n692 9.3005
R8097 VSS.n695 VSS.n694 9.3005
R8098 VSS.n636 VSS.n634 9.3005
R8099 VSS.n699 VSS.n633 9.3005
R8100 VSS.n701 VSS.n700 9.3005
R8101 VSS.n702 VSS.n632 9.3005
R8102 VSS.n704 VSS.n703 9.3005
R8103 VSS.n705 VSS.n631 9.3005
R8104 VSS.n707 VSS.n706 9.3005
R8105 VSS.n708 VSS.n630 9.3005
R8106 VSS.n710 VSS.n709 9.3005
R8107 VSS.n713 VSS.n629 9.3005
R8108 VSS.n715 VSS.n714 9.3005
R8109 VSS.n717 VSS.n716 9.3005
R8110 VSS.n628 VSS.n625 9.3005
R8111 VSS.n722 VSS.n624 9.3005
R8112 VSS.n724 VSS.n723 9.3005
R8113 VSS.n725 VSS.n623 9.3005
R8114 VSS.n727 VSS.n726 9.3005
R8115 VSS.n728 VSS.n622 9.3005
R8116 VSS.n730 VSS.n729 9.3005
R8117 VSS.n731 VSS.n621 9.3005
R8118 VSS.n733 VSS.n732 9.3005
R8119 VSS.n736 VSS.n620 9.3005
R8120 VSS.n738 VSS.n737 9.3005
R8121 VSS.n740 VSS.n739 9.3005
R8122 VSS.n619 VSS.n616 9.3005
R8123 VSS.n745 VSS.n615 9.3005
R8124 VSS.n747 VSS.n746 9.3005
R8125 VSS.n748 VSS.n614 9.3005
R8126 VSS.n750 VSS.n749 9.3005
R8127 VSS.n751 VSS.n613 9.3005
R8128 VSS.n753 VSS.n752 9.3005
R8129 VSS.n754 VSS.n612 9.3005
R8130 VSS.n756 VSS.n755 9.3005
R8131 VSS.n757 VSS.n611 9.3005
R8132 VSS.n759 VSS.n758 9.3005
R8133 VSS.n760 VSS.n610 9.3005
R8134 VSS.n762 VSS.n761 9.3005
R8135 VSS.n765 VSS.n609 9.3005
R8136 VSS.n767 VSS.n766 9.3005
R8137 VSS.n769 VSS.n768 9.3005
R8138 VSS.n608 VSS.n605 9.3005
R8139 VSS.n774 VSS.n604 9.3005
R8140 VSS.n776 VSS.n775 9.3005
R8141 VSS.n777 VSS.n603 9.3005
R8142 VSS.n779 VSS.n778 9.3005
R8143 VSS.n780 VSS.n602 9.3005
R8144 VSS.n782 VSS.n781 9.3005
R8145 VSS.n783 VSS.n601 9.3005
R8146 VSS.t26 VSS.n784 9.3005
R8147 VSS.n785 VSS.n600 9.3005
R8148 VSS.n786 VSS.t28 9.3005
R8149 VSS.n787 VSS.n599 9.3005
R8150 VSS.n789 VSS.n788 9.3005
R8151 VSS.n598 VSS.n596 9.3005
R8152 VSS.n794 VSS.n793 9.3005
R8153 VSS.n795 VSS.n595 9.3005
R8154 VSS.n797 VSS.n796 9.3005
R8155 VSS.n798 VSS.n594 9.3005
R8156 VSS.n800 VSS.n799 9.3005
R8157 VSS.n802 VSS.n801 9.3005
R8158 VSS.n803 VSS.n593 9.3005
R8159 VSS.n805 VSS.n804 9.3005
R8160 VSS.n806 VSS.n592 9.3005
R8161 VSS.n877 VSS.n807 9.3005
R8162 VSS.n876 VSS.n875 9.3005
R8163 VSS.n874 VSS.n873 9.3005
R8164 VSS.n809 VSS.n808 9.3005
R8165 VSS.n869 VSS.n868 9.3005
R8166 VSS.n867 VSS.n866 9.3005
R8167 VSS.n862 VSS.n812 9.3005
R8168 VSS.n861 VSS.n860 9.3005
R8169 VSS.n859 VSS.n813 9.3005
R8170 VSS.n858 VSS.n857 9.3005
R8171 VSS.n856 VSS.n814 9.3005
R8172 VSS.n855 VSS.n854 9.3005
R8173 VSS.n853 VSS.n852 9.3005
R8174 VSS.n851 VSS.n815 9.3005
R8175 VSS.n845 VSS.n816 9.3005
R8176 VSS.n847 VSS.n846 9.3005
R8177 VSS.n844 VSS.n818 9.3005
R8178 VSS.n843 VSS.n842 9.3005
R8179 VSS.n837 VSS.n819 9.3005
R8180 VSS.n836 VSS.n835 9.3005
R8181 VSS.n834 VSS.n820 9.3005
R8182 VSS.n833 VSS.n832 9.3005
R8183 VSS.n831 VSS.n821 9.3005
R8184 VSS.n830 VSS.n829 9.3005
R8185 VSS.n828 VSS.n827 9.3005
R8186 VSS.n826 VSS.n822 9.3005
R8187 VSS.n825 VSS.n824 9.3005
R8188 VSS.n823 VSS.n591 9.3005
R8189 VSS.n880 VSS.n590 9.3005
R8190 VSS.n882 VSS.n881 9.3005
R8191 VSS.n884 VSS.n883 9.3005
R8192 VSS.n588 VSS.n587 9.3005
R8193 VSS.n889 VSS.n888 9.3005
R8194 VSS.n890 VSS.n586 9.3005
R8195 VSS.n892 VSS.n891 9.3005
R8196 VSS.n893 VSS.n585 9.3005
R8197 VSS.n895 VSS.n894 9.3005
R8198 VSS.n896 VSS.n584 9.3005
R8199 VSS.n898 VSS.n897 9.3005
R8200 VSS.t92 VSS.n583 9.3005
R8201 VSS.n900 VSS.n899 9.3005
R8202 VSS.n901 VSS.t94 9.3005
R8203 VSS.n903 VSS.n902 9.3005
R8204 VSS.n904 VSS.n582 9.3005
R8205 VSS.n906 VSS.n905 9.3005
R8206 VSS.n907 VSS.n581 9.3005
R8207 VSS.n909 VSS.n908 9.3005
R8208 VSS.n910 VSS.n580 9.3005
R8209 VSS.n912 VSS.n911 9.3005
R8210 VSS.n913 VSS.n579 9.3005
R8211 VSS.n916 VSS.n578 9.3005
R8212 VSS.n918 VSS.n917 9.3005
R8213 VSS.n919 VSS.n577 9.3005
R8214 VSS.n989 VSS.n920 9.3005
R8215 VSS.n988 VSS.n987 9.3005
R8216 VSS.n986 VSS.n985 9.3005
R8217 VSS.n922 VSS.n921 9.3005
R8218 VSS.n981 VSS.n980 9.3005
R8219 VSS.n979 VSS.n978 9.3005
R8220 VSS.n974 VSS.n925 9.3005
R8221 VSS.n973 VSS.n972 9.3005
R8222 VSS.n971 VSS.n926 9.3005
R8223 VSS.n970 VSS.n969 9.3005
R8224 VSS.n968 VSS.n927 9.3005
R8225 VSS.n967 VSS.n966 9.3005
R8226 VSS.n965 VSS.n964 9.3005
R8227 VSS.n963 VSS.n928 9.3005
R8228 VSS.n957 VSS.n929 9.3005
R8229 VSS.n959 VSS.n958 9.3005
R8230 VSS.n956 VSS.n931 9.3005
R8231 VSS.n955 VSS.n954 9.3005
R8232 VSS.n949 VSS.n932 9.3005
R8233 VSS.n948 VSS.n947 9.3005
R8234 VSS.n946 VSS.n933 9.3005
R8235 VSS.n945 VSS.n944 9.3005
R8236 VSS.n943 VSS.n934 9.3005
R8237 VSS.n942 VSS.n941 9.3005
R8238 VSS.n940 VSS.n939 9.3005
R8239 VSS.n938 VSS.n935 9.3005
R8240 VSS.n937 VSS.n936 9.3005
R8241 VSS.n576 VSS.n575 9.3005
R8242 VSS.n993 VSS.n992 9.3005
R8243 VSS.n996 VSS.n995 9.3005
R8244 VSS.n997 VSS.n573 9.3005
R8245 VSS.n999 VSS.n998 9.3005
R8246 VSS.n1000 VSS.n572 9.3005
R8247 VSS.n1002 VSS.n1001 9.3005
R8248 VSS.t63 VSS.n571 9.3005
R8249 VSS.n1004 VSS.n1003 9.3005
R8250 VSS.n1005 VSS.n570 9.3005
R8251 VSS.n1007 VSS.n1006 9.3005
R8252 VSS.t5 VSS.n569 9.3005
R8253 VSS.n1009 VSS.n1008 9.3005
R8254 VSS.n1010 VSS.t132 9.3005
R8255 VSS.n1012 VSS.n1011 9.3005
R8256 VSS.n1015 VSS.n568 9.3005
R8257 VSS.n1017 VSS.n1016 9.3005
R8258 VSS.n1019 VSS.n1018 9.3005
R8259 VSS.n567 VSS.n564 9.3005
R8260 VSS.n1024 VSS.n563 9.3005
R8261 VSS.n1026 VSS.n1025 9.3005
R8262 VSS.n1027 VSS.n562 9.3005
R8263 VSS.n1029 VSS.n1028 9.3005
R8264 VSS.n1030 VSS.n561 9.3005
R8265 VSS.n1032 VSS.n1031 9.3005
R8266 VSS.n1033 VSS.n560 9.3005
R8267 VSS.n1104 VSS.n1034 9.3005
R8268 VSS.n1103 VSS.n1102 9.3005
R8269 VSS.n1101 VSS.n1100 9.3005
R8270 VSS.n1036 VSS.n1035 9.3005
R8271 VSS.n1096 VSS.n1095 9.3005
R8272 VSS.n1094 VSS.n1093 9.3005
R8273 VSS.n1089 VSS.n1039 9.3005
R8274 VSS.n1088 VSS.n1087 9.3005
R8275 VSS.n1086 VSS.n1040 9.3005
R8276 VSS.n1085 VSS.n1084 9.3005
R8277 VSS.n1083 VSS.n1041 9.3005
R8278 VSS.n1082 VSS.n1081 9.3005
R8279 VSS.n1080 VSS.n1079 9.3005
R8280 VSS.n1078 VSS.n1042 9.3005
R8281 VSS.n1072 VSS.n1043 9.3005
R8282 VSS.n1074 VSS.n1073 9.3005
R8283 VSS.n1071 VSS.n1045 9.3005
R8284 VSS.n1070 VSS.n1069 9.3005
R8285 VSS.n1064 VSS.n1046 9.3005
R8286 VSS.n1063 VSS.n1062 9.3005
R8287 VSS.n1061 VSS.n1047 9.3005
R8288 VSS.n1060 VSS.n1059 9.3005
R8289 VSS.n1058 VSS.n1048 9.3005
R8290 VSS.n1057 VSS.n1056 9.3005
R8291 VSS.n1055 VSS.n1054 9.3005
R8292 VSS.n1053 VSS.n1049 9.3005
R8293 VSS.n1052 VSS.n1051 9.3005
R8294 VSS.n1050 VSS.n558 9.3005
R8295 VSS.n1107 VSS.n557 9.3005
R8296 VSS.n1109 VSS.n1108 9.3005
R8297 VSS.n1110 VSS.n556 9.3005
R8298 VSS.t41 VSS.n1111 9.3005
R8299 VSS.n1112 VSS.n555 9.3005
R8300 VSS.n1114 VSS.n1113 9.3005
R8301 VSS.n1115 VSS.n554 9.3005
R8302 VSS.n1117 VSS.n1116 9.3005
R8303 VSS.t3373 VSS.n553 9.3005
R8304 VSS.n1119 VSS.n1118 9.3005
R8305 VSS.n1120 VSS.t3375 9.3005
R8306 VSS.n1122 VSS.n1121 9.3005
R8307 VSS.n1123 VSS.n552 9.3005
R8308 VSS.n1125 VSS.n1124 9.3005
R8309 VSS.n1127 VSS.n1126 9.3005
R8310 VSS.n1128 VSS.n551 9.3005
R8311 VSS.n1130 VSS.n1129 9.3005
R8312 VSS.n1131 VSS.t3242 9.3005
R8313 VSS.n1133 VSS.n1132 9.3005
R8314 VSS.n1134 VSS.n550 9.3005
R8315 VSS.n1136 VSS.n1135 9.3005
R8316 VSS.n1137 VSS.n549 9.3005
R8317 VSS.t3277 VSS.n1138 9.3005
R8318 VSS.n1139 VSS.n548 9.3005
R8319 VSS.n1141 VSS.n1140 9.3005
R8320 VSS.n1143 VSS.n1142 9.3005
R8321 VSS.n1144 VSS.n547 9.3005
R8322 VSS.n1146 VSS.n1145 9.3005
R8323 VSS.n1147 VSS.n546 9.3005
R8324 VSS.n1149 VSS.n1148 9.3005
R8325 VSS.n1152 VSS.n545 9.3005
R8326 VSS.n1154 VSS.n1153 9.3005
R8327 VSS.n1156 VSS.n1155 9.3005
R8328 VSS.n544 VSS.n541 9.3005
R8329 VSS.n1161 VSS.n540 9.3005
R8330 VSS.n1163 VSS.n1162 9.3005
R8331 VSS.n1164 VSS.n539 9.3005
R8332 VSS.n1166 VSS.n1165 9.3005
R8333 VSS.n1167 VSS.n538 9.3005
R8334 VSS.n1169 VSS.n1168 9.3005
R8335 VSS.n1170 VSS.n537 9.3005
R8336 VSS.n1172 VSS.n1171 9.3005
R8337 VSS.n1175 VSS.n536 9.3005
R8338 VSS.n1177 VSS.n1176 9.3005
R8339 VSS.n1179 VSS.n1178 9.3005
R8340 VSS.n535 VSS.n532 9.3005
R8341 VSS.n1184 VSS.n531 9.3005
R8342 VSS.n1186 VSS.n1185 9.3005
R8343 VSS.n1187 VSS.n530 9.3005
R8344 VSS.n1189 VSS.n1188 9.3005
R8345 VSS.n1190 VSS.n529 9.3005
R8346 VSS.n1192 VSS.n1191 9.3005
R8347 VSS.n1194 VSS.n1193 9.3005
R8348 VSS.n1195 VSS.n528 9.3005
R8349 VSS.n1197 VSS.n1196 9.3005
R8350 VSS.n1198 VSS.n527 9.3005
R8351 VSS.n1255 VSS.n1199 9.3005
R8352 VSS.n1254 VSS.n1253 9.3005
R8353 VSS.n1252 VSS.n1251 9.3005
R8354 VSS.n1250 VSS.n1200 9.3005
R8355 VSS.n1249 VSS.n1248 9.3005
R8356 VSS.n1247 VSS.n1201 9.3005
R8357 VSS.n1246 VSS.t96 9.3005
R8358 VSS.n1245 VSS.n1202 9.3005
R8359 VSS.t98 VSS.n1203 9.3005
R8360 VSS.n1244 VSS.n1243 9.3005
R8361 VSS.n1242 VSS.n1241 9.3005
R8362 VSS.n1205 VSS.n1204 9.3005
R8363 VSS.n1237 VSS.n1236 9.3005
R8364 VSS.n1235 VSS.n1234 9.3005
R8365 VSS.n1230 VSS.n1208 9.3005
R8366 VSS.n1229 VSS.n1228 9.3005
R8367 VSS.n1227 VSS.n1209 9.3005
R8368 VSS.n1226 VSS.n1225 9.3005
R8369 VSS.n1224 VSS.n1210 9.3005
R8370 VSS.n1223 VSS.n1222 9.3005
R8371 VSS.n1221 VSS.n1220 9.3005
R8372 VSS.n1218 VSS.n1217 9.3005
R8373 VSS.n1216 VSS.n1212 9.3005
R8374 VSS.n1215 VSS.n1214 9.3005
R8375 VSS.n1213 VSS.n465 9.3005
R8376 VSS.n1258 VSS.n464 9.3005
R8377 VSS.n1260 VSS.n1259 9.3005
R8378 VSS.n1261 VSS.n463 9.3005
R8379 VSS.n1263 VSS.n1262 9.3005
R8380 VSS.n460 VSS.n37 9.3005
R8381 VSS.n37 VSS.n1269 9.3005
R8382 VSS.n56 VSS.n37 0.142246
R8383 VSS.n86 VSS.n37 2.47539
R8384 VSS.n70 VSS.n37 3.82243
R8385 VSS.n508 VSS.n37 9.3005
R8386 VSS.n37 VSS.n55 9.3005
R8387 VSS.n37 VSS.n38 3.57362
R8388 VSS.n513 VSS.n503 9.3005
R8389 VSS.n515 VSS.n514 9.3005
R8390 VSS.n516 VSS.n502 9.3005
R8391 VSS.n518 VSS.n517 9.3005
R8392 VSS.n520 VSS.n519 9.3005
R8393 VSS.n521 VSS.n501 9.3005
R8394 VSS.n523 VSS.n522 9.3005
R8395 VSS.n524 VSS.n466 9.3005
R8396 VSS.n500 VSS.n467 9.3005
R8397 VSS.n499 VSS.n498 9.3005
R8398 VSS.n497 VSS.n468 9.3005
R8399 VSS.t3278 VSS.n469 9.3005
R8400 VSS.n496 VSS.n495 9.3005
R8401 VSS.n494 VSS.t3377 9.3005
R8402 VSS.n493 VSS.n492 9.3005
R8403 VSS.n471 VSS.n470 9.3005
R8404 VSS.n488 VSS.n487 9.3005
R8405 VSS.n486 VSS.n485 9.3005
R8406 VSS.n484 VSS.n473 9.3005
R8407 VSS.n483 VSS.n482 9.3005
R8408 VSS.n481 VSS.n474 9.3005
R8409 VSS.n480 VSS.n479 9.3005
R8410 VSS.n478 VSS.n475 9.3005
R8411 VSS.n477 VSS.n476 9.3005
R8412 VSS.n3756 VSS.n3755 9.3005
R8413 VSS.n3758 VSS.n3757 9.3005
R8414 VSS.t3433 VSS.n127 9.3005
R8415 VSS.n3768 VSS.n3767 9.3005
R8416 VSS.n3750 VSS.n3749 9.3005
R8417 VSS.n3775 VSS.n3774 9.3005
R8418 VSS.n3777 VSS.n3776 9.3005
R8419 VSS.n3778 VSS.n3747 9.3005
R8420 VSS.n3780 VSS.n3779 9.3005
R8421 VSS.n3745 VSS.n3744 9.3005
R8422 VSS.n3785 VSS.n3743 9.3005
R8423 VSS.n3787 VSS.n3786 9.3005
R8424 VSS.n3788 VSS.n3742 9.3005
R8425 VSS.n3790 VSS.n3789 9.3005
R8426 VSS.n3791 VSS.n3740 9.3005
R8427 VSS.n3798 VSS.n3797 9.3005
R8428 VSS.n3799 VSS.n3738 9.3005
R8429 VSS.n3801 VSS.n3800 9.3005
R8430 VSS.n3802 VSS.n3737 9.3005
R8431 VSS.n193 VSS.n192 0.138245
R8432 VSS.n3804 VSS.n193 3.04638
R8433 VSS.n3804 VSS.n198 9.3005
R8434 VSS.n3807 VSS.n3806 9.3005
R8435 VSS.n3808 VSS.n3736 9.3005
R8436 VSS.n3810 VSS.n3809 9.3005
R8437 VSS.n3811 VSS.n3735 9.3005
R8438 VSS.n3815 VSS.n3814 9.3005
R8439 VSS.n3734 VSS.n3731 9.3005
R8440 VSS.n3727 VSS.n3725 9.3005
R8441 VSS.n3820 VSS.n3819 9.3005
R8442 VSS.n3822 VSS.n3821 9.3005
R8443 VSS.n3724 VSS.n3721 9.3005
R8444 VSS.n3824 VSS.n3719 9.3005
R8445 VSS.n3826 VSS.n3825 9.3005
R8446 VSS.n3827 VSS.n3718 9.3005
R8447 VSS.n3829 VSS.n3828 9.3005
R8448 VSS.n3830 VSS.n3717 9.3005
R8449 VSS.n3832 VSS.n3831 9.3005
R8450 VSS.n3834 VSS.n3833 9.3005
R8451 VSS.n3837 VSS.n3715 9.3005
R8452 VSS.n3839 VSS.n3838 9.3005
R8453 VSS.n3841 VSS.n3840 9.3005
R8454 VSS.n3713 VSS.n3710 9.3005
R8455 VSS.n3847 VSS.n3846 9.3005
R8456 VSS.n3849 VSS.n3848 9.3005
R8457 VSS.n3707 VSS.n3705 9.3005
R8458 VSS.n3856 VSS.n3855 9.3005
R8459 VSS.n3857 VSS.n3704 9.3005
R8460 VSS.n3859 VSS.n3858 9.3005
R8461 VSS.n3860 VSS.n3703 9.3005
R8462 VSS.n3862 VSS.n3861 9.3005
R8463 VSS.n3863 VSS.t3552 9.3005
R8464 VSS.n3865 VSS.n3864 9.3005
R8465 VSS.n3866 VSS.n3702 9.3005
R8466 VSS.n3874 VSS.n3873 9.3005
R8467 VSS.n3876 VSS.n3875 9.3005
R8468 VSS.n3698 VSS.n3695 9.3005
R8469 VSS.n3881 VSS.n3694 9.3005
R8470 VSS.n3883 VSS.n3882 9.3005
R8471 VSS.n3885 VSS.n3884 9.3005
R8472 VSS.n3894 VSS.n3893 9.3005
R8473 VSS.n3895 VSS.n3692 9.3005
R8474 VSS.n3897 VSS.n3896 9.3005
R8475 VSS.n3689 VSS.n3687 9.3005
R8476 VSS.n3904 VSS.n3903 9.3005
R8477 VSS.n3905 VSS.n3686 9.3005
R8478 VSS.n3907 VSS.n3906 9.3005
R8479 VSS.n3908 VSS.n3685 9.3005
R8480 VSS.n3910 VSS.n3909 9.3005
R8481 VSS.t3513 VSS.n3911 9.3005
R8482 VSS.n3912 VSS.n3684 9.3005
R8483 VSS.n3914 VSS.n3913 9.3005
R8484 VSS.n3916 VSS.n3915 9.3005
R8485 VSS.n3683 VSS.n3681 9.3005
R8486 VSS.n3677 VSS.n3675 9.3005
R8487 VSS.n3921 VSS.n3920 9.3005
R8488 VSS.n3923 VSS.n3922 9.3005
R8489 VSS.n3674 VSS.n3671 9.3005
R8490 VSS.n3925 VSS.n3669 9.3005
R8491 VSS.n3927 VSS.n3926 9.3005
R8492 VSS.n3928 VSS.n3668 9.3005
R8493 VSS.n3930 VSS.n3929 9.3005
R8494 VSS.n3931 VSS.n3667 9.3005
R8495 VSS.n3933 VSS.n3932 9.3005
R8496 VSS.n3935 VSS.n3934 9.3005
R8497 VSS.n3938 VSS.n3665 9.3005
R8498 VSS.n3940 VSS.n3939 9.3005
R8499 VSS.n3942 VSS.n3941 9.3005
R8500 VSS.n3663 VSS.n3660 9.3005
R8501 VSS.n3948 VSS.n3947 9.3005
R8502 VSS.n3950 VSS.n3949 9.3005
R8503 VSS.n3657 VSS.n3655 9.3005
R8504 VSS.n3957 VSS.n3956 9.3005
R8505 VSS.n3958 VSS.n3654 9.3005
R8506 VSS.n3960 VSS.n3959 9.3005
R8507 VSS.n3961 VSS.n3653 9.3005
R8508 VSS.n3963 VSS.n3962 9.3005
R8509 VSS.n3964 VSS.t3547 9.3005
R8510 VSS.n3966 VSS.n3965 9.3005
R8511 VSS.n3967 VSS.n3652 9.3005
R8512 VSS.n3975 VSS.n3974 9.3005
R8513 VSS.n3977 VSS.n3976 9.3005
R8514 VSS.n3648 VSS.n3645 9.3005
R8515 VSS.n3982 VSS.n3644 9.3005
R8516 VSS.n3984 VSS.n3983 9.3005
R8517 VSS.n3986 VSS.n3985 9.3005
R8518 VSS.n3995 VSS.n3994 9.3005
R8519 VSS.n3996 VSS.n3642 9.3005
R8520 VSS.n3998 VSS.n3997 9.3005
R8521 VSS.n3639 VSS.n3637 9.3005
R8522 VSS.n4005 VSS.n4004 9.3005
R8523 VSS.n4006 VSS.n3636 9.3005
R8524 VSS.n4008 VSS.n4007 9.3005
R8525 VSS.n4009 VSS.n3635 9.3005
R8526 VSS.n4011 VSS.n4010 9.3005
R8527 VSS.t3508 VSS.n4012 9.3005
R8528 VSS.n4013 VSS.n3634 9.3005
R8529 VSS.n4015 VSS.n4014 9.3005
R8530 VSS.n4017 VSS.n4016 9.3005
R8531 VSS.n3633 VSS.n3631 9.3005
R8532 VSS.n3627 VSS.n3625 9.3005
R8533 VSS.n4022 VSS.n4021 9.3005
R8534 VSS.n4024 VSS.n4023 9.3005
R8535 VSS.n3624 VSS.n3621 9.3005
R8536 VSS.n4026 VSS.n3619 9.3005
R8537 VSS.n4028 VSS.n4027 9.3005
R8538 VSS.n4029 VSS.n3618 9.3005
R8539 VSS.n4031 VSS.n4030 9.3005
R8540 VSS.n4032 VSS.n3617 9.3005
R8541 VSS.n4034 VSS.n4033 9.3005
R8542 VSS.n4036 VSS.n4035 9.3005
R8543 VSS.n4039 VSS.n3615 9.3005
R8544 VSS.n4041 VSS.n4040 9.3005
R8545 VSS.n4043 VSS.n4042 9.3005
R8546 VSS.n3613 VSS.n3610 9.3005
R8547 VSS.n4049 VSS.n4048 9.3005
R8548 VSS.n4051 VSS.n4050 9.3005
R8549 VSS.n3607 VSS.n3605 9.3005
R8550 VSS.n4058 VSS.n4057 9.3005
R8551 VSS.n4059 VSS.n3604 9.3005
R8552 VSS.n4061 VSS.n4060 9.3005
R8553 VSS.n4062 VSS.n3603 9.3005
R8554 VSS.n4064 VSS.n4063 9.3005
R8555 VSS.n4065 VSS.t3542 9.3005
R8556 VSS.n4067 VSS.n4066 9.3005
R8557 VSS.n4068 VSS.n3602 9.3005
R8558 VSS.n4076 VSS.n4075 9.3005
R8559 VSS.n4078 VSS.n4077 9.3005
R8560 VSS.n3598 VSS.n3595 9.3005
R8561 VSS.n4083 VSS.n3594 9.3005
R8562 VSS.n4085 VSS.n4084 9.3005
R8563 VSS.n4087 VSS.n4086 9.3005
R8564 VSS.n4096 VSS.n4095 9.3005
R8565 VSS.n4097 VSS.n3592 9.3005
R8566 VSS.n4099 VSS.n4098 9.3005
R8567 VSS.n3589 VSS.n3587 9.3005
R8568 VSS.n4106 VSS.n4105 9.3005
R8569 VSS.n4107 VSS.n3586 9.3005
R8570 VSS.n4109 VSS.n4108 9.3005
R8571 VSS.n4110 VSS.n3585 9.3005
R8572 VSS.n4112 VSS.n4111 9.3005
R8573 VSS.t3503 VSS.n4113 9.3005
R8574 VSS.n4114 VSS.n3584 9.3005
R8575 VSS.n4116 VSS.n4115 9.3005
R8576 VSS.n4118 VSS.n4117 9.3005
R8577 VSS.n3583 VSS.n3581 9.3005
R8578 VSS.n3577 VSS.n3575 9.3005
R8579 VSS.n4123 VSS.n4122 9.3005
R8580 VSS.n4125 VSS.n4124 9.3005
R8581 VSS.n3574 VSS.n3571 9.3005
R8582 VSS.n4127 VSS.n3569 9.3005
R8583 VSS.n4129 VSS.n4128 9.3005
R8584 VSS.n4130 VSS.n3568 9.3005
R8585 VSS.n4132 VSS.n4131 9.3005
R8586 VSS.n4133 VSS.n3567 9.3005
R8587 VSS.n4135 VSS.n4134 9.3005
R8588 VSS.n4137 VSS.n4136 9.3005
R8589 VSS.n4140 VSS.n3565 9.3005
R8590 VSS.n4142 VSS.n4141 9.3005
R8591 VSS.n4144 VSS.n4143 9.3005
R8592 VSS.n3563 VSS.n3560 9.3005
R8593 VSS.n4150 VSS.n4149 9.3005
R8594 VSS.n4152 VSS.n4151 9.3005
R8595 VSS.n3557 VSS.n3555 9.3005
R8596 VSS.n4159 VSS.n4158 9.3005
R8597 VSS.n4160 VSS.n3554 9.3005
R8598 VSS.n4162 VSS.n4161 9.3005
R8599 VSS.n4163 VSS.n3553 9.3005
R8600 VSS.n4165 VSS.n4164 9.3005
R8601 VSS.n4166 VSS.t3537 9.3005
R8602 VSS.n4168 VSS.n4167 9.3005
R8603 VSS.n4169 VSS.n3552 9.3005
R8604 VSS.n4177 VSS.n4176 9.3005
R8605 VSS.n4179 VSS.n4178 9.3005
R8606 VSS.n3548 VSS.n3545 9.3005
R8607 VSS.n4184 VSS.n3544 9.3005
R8608 VSS.n4186 VSS.n4185 9.3005
R8609 VSS.n4188 VSS.n4187 9.3005
R8610 VSS.n4197 VSS.n4196 9.3005
R8611 VSS.n4198 VSS.n3542 9.3005
R8612 VSS.n4200 VSS.n4199 9.3005
R8613 VSS.n3539 VSS.n3537 9.3005
R8614 VSS.n4207 VSS.n4206 9.3005
R8615 VSS.n4208 VSS.n3536 9.3005
R8616 VSS.n4210 VSS.n4209 9.3005
R8617 VSS.n4211 VSS.n3535 9.3005
R8618 VSS.n4213 VSS.n4212 9.3005
R8619 VSS.t3498 VSS.n4214 9.3005
R8620 VSS.n4215 VSS.n3534 9.3005
R8621 VSS.n4217 VSS.n4216 9.3005
R8622 VSS.n4219 VSS.n4218 9.3005
R8623 VSS.n3533 VSS.n3531 9.3005
R8624 VSS.n3527 VSS.n3525 9.3005
R8625 VSS.n4224 VSS.n4223 9.3005
R8626 VSS.n4226 VSS.n4225 9.3005
R8627 VSS.n3524 VSS.n3521 9.3005
R8628 VSS.n4228 VSS.n3519 9.3005
R8629 VSS.n4230 VSS.n4229 9.3005
R8630 VSS.n4231 VSS.n3518 9.3005
R8631 VSS.n4233 VSS.n4232 9.3005
R8632 VSS.n4234 VSS.n3517 9.3005
R8633 VSS.n4236 VSS.n4235 9.3005
R8634 VSS.n4238 VSS.n4237 9.3005
R8635 VSS.n4241 VSS.n3515 9.3005
R8636 VSS.n4243 VSS.n4242 9.3005
R8637 VSS.n4245 VSS.n4244 9.3005
R8638 VSS.n3513 VSS.n3510 9.3005
R8639 VSS.n4251 VSS.n4250 9.3005
R8640 VSS.n4253 VSS.n4252 9.3005
R8641 VSS.n3507 VSS.n3505 9.3005
R8642 VSS.n4260 VSS.n4259 9.3005
R8643 VSS.n4261 VSS.n3504 9.3005
R8644 VSS.n4263 VSS.n4262 9.3005
R8645 VSS.n4264 VSS.n3503 9.3005
R8646 VSS.n4266 VSS.n4265 9.3005
R8647 VSS.n4267 VSS.t3532 9.3005
R8648 VSS.n4269 VSS.n4268 9.3005
R8649 VSS.n4270 VSS.n3502 9.3005
R8650 VSS.n4278 VSS.n4277 9.3005
R8651 VSS.n4280 VSS.n4279 9.3005
R8652 VSS.n3498 VSS.n3495 9.3005
R8653 VSS.n4285 VSS.n3494 9.3005
R8654 VSS.n4287 VSS.n4286 9.3005
R8655 VSS.n4289 VSS.n4288 9.3005
R8656 VSS.n4298 VSS.n4297 9.3005
R8657 VSS.n4299 VSS.n3492 9.3005
R8658 VSS.n4301 VSS.n4300 9.3005
R8659 VSS.n3489 VSS.n3487 9.3005
R8660 VSS.n4308 VSS.n4307 9.3005
R8661 VSS.n4309 VSS.n3486 9.3005
R8662 VSS.n4311 VSS.n4310 9.3005
R8663 VSS.n4312 VSS.n3485 9.3005
R8664 VSS.n4314 VSS.n4313 9.3005
R8665 VSS.t3493 VSS.n4315 9.3005
R8666 VSS.n4316 VSS.n3484 9.3005
R8667 VSS.n4318 VSS.n4317 9.3005
R8668 VSS.n4320 VSS.n4319 9.3005
R8669 VSS.n3483 VSS.n3481 9.3005
R8670 VSS.n3477 VSS.n3475 9.3005
R8671 VSS.n4325 VSS.n4324 9.3005
R8672 VSS.n4327 VSS.n4326 9.3005
R8673 VSS.n3474 VSS.n3471 9.3005
R8674 VSS.n4329 VSS.n3469 9.3005
R8675 VSS.n4331 VSS.n4330 9.3005
R8676 VSS.n4332 VSS.n3468 9.3005
R8677 VSS.n4334 VSS.n4333 9.3005
R8678 VSS.n4335 VSS.n3467 9.3005
R8679 VSS.n4337 VSS.n4336 9.3005
R8680 VSS.n4339 VSS.n4338 9.3005
R8681 VSS.n4342 VSS.n3465 9.3005
R8682 VSS.n4344 VSS.n4343 9.3005
R8683 VSS.n4346 VSS.n4345 9.3005
R8684 VSS.n3463 VSS.n3460 9.3005
R8685 VSS.n4352 VSS.n4351 9.3005
R8686 VSS.n4354 VSS.n4353 9.3005
R8687 VSS.n3457 VSS.n3455 9.3005
R8688 VSS.n4361 VSS.n4360 9.3005
R8689 VSS.n4362 VSS.n3454 9.3005
R8690 VSS.n4364 VSS.n4363 9.3005
R8691 VSS.n4365 VSS.n3453 9.3005
R8692 VSS.n4367 VSS.n4366 9.3005
R8693 VSS.t3527 VSS.n4368 9.3005
R8694 VSS.n4369 VSS.n3452 9.3005
R8695 VSS.n4371 VSS.n4370 9.3005
R8696 VSS.n4393 VSS.n4392 9.3005
R8697 VSS.n4376 VSS.n4375 9.3005
R8698 VSS.n4386 VSS.n4385 9.3005
R8699 VSS.n4384 VSS.n4383 9.3005
R8700 VSS.n4382 VSS.n4379 9.3005
R8701 VSS.n4381 VSS.n4380 9.3005
R8702 VSS.n88 VSS.n4462 2.25403
R8703 VSS.n88 VSS.n6 0.192834
R8704 VSS.n3442 VSS.n6 9.3005
R8705 VSS.n6 VSS.n83 4.07296
R8706 VSS.n6 VSS.n59 9.3005
R8707 VSS.n6 VSS.n4455 9.3005
R8708 VSS.n52 VSS.n6 3.96704
R8709 VSS.n6 VSS.n4450 9.3005
R8710 VSS.n4449 VSS.n5 9.3005
R8711 VSS.t3488 VSS.n4448 9.3005
R8712 VSS.n4447 VSS.n3446 9.3005
R8713 VSS.n4446 VSS.n4445 9.3005
R8714 VSS.n3448 VSS.n3447 9.3005
R8715 VSS.n4438 VSS.n3449 9.3005
R8716 VSS.n4440 VSS.n4439 9.3005
R8717 VSS.n4437 VSS.n4398 9.3005
R8718 VSS.n4436 VSS.n4435 9.3005
R8719 VSS.n4430 VSS.n4399 9.3005
R8720 VSS.n4424 VSS.n4401 9.3005
R8721 VSS.n4426 VSS.n4425 9.3005
R8722 VSS.n4423 VSS.n4422 9.3005
R8723 VSS.n4418 VSS.n4404 9.3005
R8724 VSS.n4417 VSS.n4416 9.3005
R8725 VSS.n4415 VSS.n4414 9.3005
R8726 VSS.n4413 VSS.n4405 9.3005
R8727 VSS.t3523 VSS.n4412 9.3005
R8728 VSS.n4411 VSS.n4406 9.3005
R8729 VSS.n4410 VSS.n4409 9.3005
R8730 VSS.n4408 VSS.n4407 9.3005
R8731 VSS.n5827 VSS.n5822 9.3005
R8732 VSS.n5829 VSS.n5828 9.3005
R8733 VSS.n5831 VSS.n5830 9.3005
R8734 VSS.n5821 VSS.n5817 9.3005
R8735 VSS.n5836 VSS.n5815 9.3005
R8736 VSS.n5838 VSS.n5837 9.3005
R8737 VSS.n5839 VSS.n5814 9.3005
R8738 VSS.n5841 VSS.n5840 9.3005
R8739 VSS.n5842 VSS.n5813 9.3005
R8740 VSS.n5844 VSS.n5843 9.3005
R8741 VSS.n5845 VSS.n5812 9.3005
R8742 VSS.n5847 VSS.n5846 9.3005
R8743 VSS.n5850 VSS.n5809 9.3005
R8744 VSS.n5852 VSS.n5851 9.3005
R8745 VSS.n5854 VSS.n5853 9.3005
R8746 VSS.n5808 VSS.n5804 9.3005
R8747 VSS.n5859 VSS.n5802 9.3005
R8748 VSS.n5861 VSS.n5860 9.3005
R8749 VSS.n5862 VSS.n5801 9.3005
R8750 VSS.n5864 VSS.n5863 9.3005
R8751 VSS.n5865 VSS.n5800 9.3005
R8752 VSS.n5867 VSS.n5866 9.3005
R8753 VSS.n5869 VSS.n5868 9.3005
R8754 VSS.n5874 VSS.n4847 9.3005
R8755 VSS.n5876 VSS.n5875 9.3005
R8756 VSS.n5877 VSS.n4846 9.3005
R8757 VSS.n5879 VSS.n5878 9.3005
R8758 VSS.n189 VSS.n190 0.138245
R8759 VSS.n5882 VSS.n190 3.04638
R8760 VSS.n5882 VSS.n199 9.3005
R8761 VSS.n4860 VSS.n4859 9.3005
R8762 VSS.n4861 VSS.n4856 9.3005
R8763 VSS.n4863 VSS.n4862 9.3005
R8764 VSS.n4864 VSS.n4855 9.3005
R8765 VSS.n4868 VSS.n4867 9.3005
R8766 VSS.n5792 VSS.n4852 9.3005
R8767 VSS.n5794 VSS.n5793 9.3005
R8768 VSS.n5796 VSS.n5795 9.3005
R8769 VSS.n4869 VSS.n4851 9.3005
R8770 VSS.n5782 VSS.n135 9.3005
R8771 VSS.n5784 VSS.n5783 9.3005
R8772 VSS.n5781 VSS.n4870 9.3005
R8773 VSS.n5780 VSS.n5779 9.3005
R8774 VSS.n5777 VSS.n4871 9.3005
R8775 VSS.n5776 VSS.n5775 9.3005
R8776 VSS.n5774 VSS.n5773 9.3005
R8777 VSS.n4873 VSS.n4872 9.3005
R8778 VSS.n5771 VSS.n5770 9.3005
R8779 VSS.n5769 VSS.n4874 9.3005
R8780 VSS.n5768 VSS.n5767 9.3005
R8781 VSS.n5759 VSS.n4876 9.3005
R8782 VSS.n5755 VSS.n4878 9.3005
R8783 VSS.n5757 VSS.n5756 9.3005
R8784 VSS.n5754 VSS.n5753 9.3005
R8785 VSS.n4882 VSS.n4881 9.3005
R8786 VSS.n5747 VSS.n5746 9.3005
R8787 VSS.n5745 VSS.n4883 9.3005
R8788 VSS.n5744 VSS.n5743 9.3005
R8789 VSS.n5742 VSS.n4884 9.3005
R8790 VSS.t3622 VSS.n5741 9.3005
R8791 VSS.n5740 VSS.n4885 9.3005
R8792 VSS.n5739 VSS.n5738 9.3005
R8793 VSS.n5734 VSS.n5733 9.3005
R8794 VSS.n4891 VSS.n4890 9.3005
R8795 VSS.n5727 VSS.n5726 9.3005
R8796 VSS.n5725 VSS.n5724 9.3005
R8797 VSS.n5723 VSS.n4894 9.3005
R8798 VSS.n5722 VSS.n5721 9.3005
R8799 VSS.n5719 VSS.n5718 9.3005
R8800 VSS.n4900 VSS.n4896 9.3005
R8801 VSS.n5711 VSS.n5710 9.3005
R8802 VSS.n5709 VSS.n4902 9.3005
R8803 VSS.n5708 VSS.n5707 9.3005
R8804 VSS.n5702 VSS.n4903 9.3005
R8805 VSS.n5701 VSS.n5700 9.3005
R8806 VSS.n5699 VSS.n5698 9.3005
R8807 VSS.n5697 VSS.n4904 9.3005
R8808 VSS.t3583 VSS.n5696 9.3005
R8809 VSS.n5695 VSS.n4905 9.3005
R8810 VSS.n5694 VSS.n5693 9.3005
R8811 VSS.n4907 VSS.n4906 9.3005
R8812 VSS.n5686 VSS.n4908 9.3005
R8813 VSS.n5688 VSS.n5687 9.3005
R8814 VSS.n5685 VSS.n4910 9.3005
R8815 VSS.n5684 VSS.n5683 9.3005
R8816 VSS.n5678 VSS.n4911 9.3005
R8817 VSS.n5677 VSS.n5676 9.3005
R8818 VSS.n5675 VSS.n4912 9.3005
R8819 VSS.n5674 VSS.n5673 9.3005
R8820 VSS.n5671 VSS.n4913 9.3005
R8821 VSS.n5670 VSS.n5669 9.3005
R8822 VSS.n5668 VSS.n5667 9.3005
R8823 VSS.n4915 VSS.n4914 9.3005
R8824 VSS.n5665 VSS.n5664 9.3005
R8825 VSS.n5663 VSS.n4916 9.3005
R8826 VSS.n5662 VSS.n5661 9.3005
R8827 VSS.n5653 VSS.n4918 9.3005
R8828 VSS.n5649 VSS.n4920 9.3005
R8829 VSS.n5651 VSS.n5650 9.3005
R8830 VSS.n5648 VSS.n5647 9.3005
R8831 VSS.n4924 VSS.n4923 9.3005
R8832 VSS.n5641 VSS.n5640 9.3005
R8833 VSS.n5639 VSS.n4925 9.3005
R8834 VSS.n5638 VSS.n5637 9.3005
R8835 VSS.n5636 VSS.n4926 9.3005
R8836 VSS.t3617 VSS.n5635 9.3005
R8837 VSS.n5634 VSS.n4927 9.3005
R8838 VSS.n5633 VSS.n5632 9.3005
R8839 VSS.n5628 VSS.n5627 9.3005
R8840 VSS.n4933 VSS.n4932 9.3005
R8841 VSS.n5621 VSS.n5620 9.3005
R8842 VSS.n5619 VSS.n5618 9.3005
R8843 VSS.n5617 VSS.n4936 9.3005
R8844 VSS.n5616 VSS.n5615 9.3005
R8845 VSS.n5613 VSS.n5612 9.3005
R8846 VSS.n4942 VSS.n4938 9.3005
R8847 VSS.n5605 VSS.n5604 9.3005
R8848 VSS.n5603 VSS.n4944 9.3005
R8849 VSS.n5602 VSS.n5601 9.3005
R8850 VSS.n5596 VSS.n4945 9.3005
R8851 VSS.n5595 VSS.n5594 9.3005
R8852 VSS.n5593 VSS.n5592 9.3005
R8853 VSS.n5591 VSS.n4946 9.3005
R8854 VSS.t3578 VSS.n5590 9.3005
R8855 VSS.n5589 VSS.n4947 9.3005
R8856 VSS.n5588 VSS.n5587 9.3005
R8857 VSS.n4949 VSS.n4948 9.3005
R8858 VSS.n5580 VSS.n4950 9.3005
R8859 VSS.n5582 VSS.n5581 9.3005
R8860 VSS.n5579 VSS.n4952 9.3005
R8861 VSS.n5578 VSS.n5577 9.3005
R8862 VSS.n5572 VSS.n4953 9.3005
R8863 VSS.n5571 VSS.n5570 9.3005
R8864 VSS.n5569 VSS.n4954 9.3005
R8865 VSS.n5568 VSS.n5567 9.3005
R8866 VSS.n5565 VSS.n4955 9.3005
R8867 VSS.n5564 VSS.n5563 9.3005
R8868 VSS.n5562 VSS.n5561 9.3005
R8869 VSS.n4957 VSS.n4956 9.3005
R8870 VSS.n5559 VSS.n5558 9.3005
R8871 VSS.n5557 VSS.n4958 9.3005
R8872 VSS.n5556 VSS.n5555 9.3005
R8873 VSS.n5547 VSS.n4960 9.3005
R8874 VSS.n5543 VSS.n4962 9.3005
R8875 VSS.n5545 VSS.n5544 9.3005
R8876 VSS.n5542 VSS.n5541 9.3005
R8877 VSS.n4966 VSS.n4965 9.3005
R8878 VSS.n5535 VSS.n5534 9.3005
R8879 VSS.n5533 VSS.n4967 9.3005
R8880 VSS.n5532 VSS.n5531 9.3005
R8881 VSS.n5530 VSS.n4968 9.3005
R8882 VSS.t3612 VSS.n5529 9.3005
R8883 VSS.n5528 VSS.n4969 9.3005
R8884 VSS.n5527 VSS.n5526 9.3005
R8885 VSS.n5522 VSS.n5521 9.3005
R8886 VSS.n4975 VSS.n4974 9.3005
R8887 VSS.n5515 VSS.n5514 9.3005
R8888 VSS.n5513 VSS.n5512 9.3005
R8889 VSS.n5511 VSS.n4978 9.3005
R8890 VSS.n5510 VSS.n5509 9.3005
R8891 VSS.n5507 VSS.n5506 9.3005
R8892 VSS.n4984 VSS.n4980 9.3005
R8893 VSS.n5499 VSS.n5498 9.3005
R8894 VSS.n5497 VSS.n4986 9.3005
R8895 VSS.n5496 VSS.n5495 9.3005
R8896 VSS.n5490 VSS.n4987 9.3005
R8897 VSS.n5489 VSS.n5488 9.3005
R8898 VSS.n5487 VSS.n5486 9.3005
R8899 VSS.n5485 VSS.n4988 9.3005
R8900 VSS.t3573 VSS.n5484 9.3005
R8901 VSS.n5483 VSS.n4989 9.3005
R8902 VSS.n5482 VSS.n5481 9.3005
R8903 VSS.n4991 VSS.n4990 9.3005
R8904 VSS.n5474 VSS.n4992 9.3005
R8905 VSS.n5476 VSS.n5475 9.3005
R8906 VSS.n5473 VSS.n4994 9.3005
R8907 VSS.n5472 VSS.n5471 9.3005
R8908 VSS.n5466 VSS.n4995 9.3005
R8909 VSS.n5465 VSS.n5464 9.3005
R8910 VSS.n5463 VSS.n4996 9.3005
R8911 VSS.n5462 VSS.n5461 9.3005
R8912 VSS.n5459 VSS.n4997 9.3005
R8913 VSS.n5458 VSS.n5457 9.3005
R8914 VSS.n5456 VSS.n5455 9.3005
R8915 VSS.n4999 VSS.n4998 9.3005
R8916 VSS.n5453 VSS.n5452 9.3005
R8917 VSS.n5451 VSS.n5000 9.3005
R8918 VSS.n5450 VSS.n5449 9.3005
R8919 VSS.n5441 VSS.n5002 9.3005
R8920 VSS.n5437 VSS.n5004 9.3005
R8921 VSS.n5439 VSS.n5438 9.3005
R8922 VSS.n5436 VSS.n5435 9.3005
R8923 VSS.n5008 VSS.n5007 9.3005
R8924 VSS.n5429 VSS.n5428 9.3005
R8925 VSS.n5427 VSS.n5009 9.3005
R8926 VSS.n5426 VSS.n5425 9.3005
R8927 VSS.n5424 VSS.n5010 9.3005
R8928 VSS.t3607 VSS.n5423 9.3005
R8929 VSS.n5422 VSS.n5011 9.3005
R8930 VSS.n5421 VSS.n5420 9.3005
R8931 VSS.n5416 VSS.n5415 9.3005
R8932 VSS.n5017 VSS.n5016 9.3005
R8933 VSS.n5409 VSS.n5408 9.3005
R8934 VSS.n5407 VSS.n5406 9.3005
R8935 VSS.n5405 VSS.n5020 9.3005
R8936 VSS.n5404 VSS.n5403 9.3005
R8937 VSS.n5401 VSS.n5400 9.3005
R8938 VSS.n5026 VSS.n5022 9.3005
R8939 VSS.n5393 VSS.n5392 9.3005
R8940 VSS.n5391 VSS.n5028 9.3005
R8941 VSS.n5390 VSS.n5389 9.3005
R8942 VSS.n5384 VSS.n5029 9.3005
R8943 VSS.n5383 VSS.n5382 9.3005
R8944 VSS.n5381 VSS.n5380 9.3005
R8945 VSS.n5379 VSS.n5030 9.3005
R8946 VSS.t3568 VSS.n5378 9.3005
R8947 VSS.n5377 VSS.n5031 9.3005
R8948 VSS.n5376 VSS.n5375 9.3005
R8949 VSS.n5033 VSS.n5032 9.3005
R8950 VSS.n5368 VSS.n5034 9.3005
R8951 VSS.n5370 VSS.n5369 9.3005
R8952 VSS.n5367 VSS.n5036 9.3005
R8953 VSS.n5366 VSS.n5365 9.3005
R8954 VSS.n5360 VSS.n5037 9.3005
R8955 VSS.n5359 VSS.n5358 9.3005
R8956 VSS.n5357 VSS.n5038 9.3005
R8957 VSS.n5356 VSS.n5355 9.3005
R8958 VSS.n5353 VSS.n5039 9.3005
R8959 VSS.n5352 VSS.n5351 9.3005
R8960 VSS.n5350 VSS.n5349 9.3005
R8961 VSS.n5041 VSS.n5040 9.3005
R8962 VSS.n5347 VSS.n5346 9.3005
R8963 VSS.n5345 VSS.n5042 9.3005
R8964 VSS.n5344 VSS.n5343 9.3005
R8965 VSS.n5335 VSS.n5044 9.3005
R8966 VSS.n5331 VSS.n5046 9.3005
R8967 VSS.n5333 VSS.n5332 9.3005
R8968 VSS.n5330 VSS.n5329 9.3005
R8969 VSS.n5050 VSS.n5049 9.3005
R8970 VSS.n5323 VSS.n5322 9.3005
R8971 VSS.n5321 VSS.n5051 9.3005
R8972 VSS.n5320 VSS.n5319 9.3005
R8973 VSS.n5318 VSS.n5052 9.3005
R8974 VSS.t3602 VSS.n5317 9.3005
R8975 VSS.n5316 VSS.n5053 9.3005
R8976 VSS.n5315 VSS.n5314 9.3005
R8977 VSS.n5310 VSS.n5309 9.3005
R8978 VSS.n5059 VSS.n5058 9.3005
R8979 VSS.n5303 VSS.n5302 9.3005
R8980 VSS.n5301 VSS.n5300 9.3005
R8981 VSS.n5299 VSS.n5062 9.3005
R8982 VSS.n5298 VSS.n5297 9.3005
R8983 VSS.n5295 VSS.n5294 9.3005
R8984 VSS.n5068 VSS.n5064 9.3005
R8985 VSS.n5287 VSS.n5286 9.3005
R8986 VSS.n5285 VSS.n5070 9.3005
R8987 VSS.n5284 VSS.n5283 9.3005
R8988 VSS.n5278 VSS.n5071 9.3005
R8989 VSS.n5277 VSS.n5276 9.3005
R8990 VSS.n5275 VSS.n5274 9.3005
R8991 VSS.n5273 VSS.n5072 9.3005
R8992 VSS.t3563 VSS.n5272 9.3005
R8993 VSS.n5271 VSS.n5073 9.3005
R8994 VSS.n5270 VSS.n5269 9.3005
R8995 VSS.n5075 VSS.n5074 9.3005
R8996 VSS.n5262 VSS.n5076 9.3005
R8997 VSS.n5264 VSS.n5263 9.3005
R8998 VSS.n5261 VSS.n5078 9.3005
R8999 VSS.n5260 VSS.n5259 9.3005
R9000 VSS.n5254 VSS.n5079 9.3005
R9001 VSS.n5253 VSS.n5252 9.3005
R9002 VSS.n5251 VSS.n5080 9.3005
R9003 VSS.n5250 VSS.n5249 9.3005
R9004 VSS.n5247 VSS.n5081 9.3005
R9005 VSS.n5246 VSS.n5245 9.3005
R9006 VSS.n5244 VSS.n5243 9.3005
R9007 VSS.n5083 VSS.n5082 9.3005
R9008 VSS.n5241 VSS.n5240 9.3005
R9009 VSS.n5239 VSS.n5084 9.3005
R9010 VSS.n5238 VSS.n5237 9.3005
R9011 VSS.n5229 VSS.n5086 9.3005
R9012 VSS.n5225 VSS.n5088 9.3005
R9013 VSS.n5227 VSS.n5226 9.3005
R9014 VSS.n5224 VSS.n5223 9.3005
R9015 VSS.n5092 VSS.n5091 9.3005
R9016 VSS.n5217 VSS.n5216 9.3005
R9017 VSS.n5215 VSS.n5093 9.3005
R9018 VSS.n5214 VSS.n5213 9.3005
R9019 VSS.n5212 VSS.n5094 9.3005
R9020 VSS.t3597 VSS.n5211 9.3005
R9021 VSS.n5210 VSS.n5095 9.3005
R9022 VSS.n5209 VSS.n5208 9.3005
R9023 VSS.n5204 VSS.n5203 9.3005
R9024 VSS.n5101 VSS.n5100 9.3005
R9025 VSS.n5197 VSS.n5196 9.3005
R9026 VSS.n5195 VSS.n5194 9.3005
R9027 VSS.n5193 VSS.n5104 9.3005
R9028 VSS.n5192 VSS.n5191 9.3005
R9029 VSS.n89 VSS.n229 2.25403
R9030 VSS.n8 VSS.n89 0.192834
R9031 VSS.n5110 VSS.n8 9.3005
R9032 VSS.n8 VSS.n82 4.07296
R9033 VSS.n5187 VSS.n8 9.3005
R9034 VSS.n8 VSS.n5186 9.3005
R9035 VSS.n51 VSS.n8 3.96704
R9036 VSS.n8 VSS.n5182 9.3005
R9037 VSS.n5181 VSS.n7 9.3005
R9038 VSS.t3558 VSS.n5180 9.3005
R9039 VSS.n5179 VSS.n5114 9.3005
R9040 VSS.n5178 VSS.n5177 9.3005
R9041 VSS.n5116 VSS.n5115 9.3005
R9042 VSS.n5170 VSS.n5117 9.3005
R9043 VSS.n5172 VSS.n5171 9.3005
R9044 VSS.n5169 VSS.n5130 9.3005
R9045 VSS.n5168 VSS.n5167 9.3005
R9046 VSS.n5162 VSS.n5131 9.3005
R9047 VSS.n5156 VSS.n5133 9.3005
R9048 VSS.n5158 VSS.n5157 9.3005
R9049 VSS.n5155 VSS.n5154 9.3005
R9050 VSS.n5150 VSS.n5136 9.3005
R9051 VSS.n5149 VSS.n5148 9.3005
R9052 VSS.n5147 VSS.n5146 9.3005
R9053 VSS.n5145 VSS.n5137 9.3005
R9054 VSS.t3593 VSS.n5144 9.3005
R9055 VSS.n5143 VSS.n5138 9.3005
R9056 VSS.n5142 VSS.n5141 9.3005
R9057 VSS.n5140 VSS.n5139 9.3005
R9058 VSS.n4792 VSS.n4791 9.3005
R9059 VSS.n4794 VSS.n4793 9.3005
R9060 VSS.n4785 VSS.n4782 9.3005
R9061 VSS.n4801 VSS.n4800 9.3005
R9062 VSS.n4802 VSS.n4781 9.3005
R9063 VSS.n4804 VSS.n4803 9.3005
R9064 VSS.n4805 VSS.n4780 9.3005
R9065 VSS.n4807 VSS.n4806 9.3005
R9066 VSS.n4808 VSS.n4779 9.3005
R9067 VSS.n4810 VSS.n4809 9.3005
R9068 VSS.n4811 VSS.n4778 9.3005
R9069 VSS.n4813 VSS.n4812 9.3005
R9070 VSS.n4814 VSS.n4777 9.3005
R9071 VSS.n4816 VSS.n4815 9.3005
R9072 VSS.n4771 VSS.n4768 9.3005
R9073 VSS.n4823 VSS.n4822 9.3005
R9074 VSS.n4824 VSS.n4767 9.3005
R9075 VSS.n4826 VSS.n4825 9.3005
R9076 VSS.n4827 VSS.n4766 9.3005
R9077 VSS.n4829 VSS.n4828 9.3005
R9078 VSS.n4830 VSS.n4765 9.3005
R9079 VSS.n4832 VSS.n4831 9.3005
R9080 VSS.n4833 VSS.n4763 9.3005
R9081 VSS.n4840 VSS.n4839 9.3005
R9082 VSS.n4841 VSS.n4761 9.3005
R9083 VSS.n4843 VSS.n4842 9.3005
R9084 VSS.n4844 VSS.n4760 9.3005
R9085 VSS.n188 VSS.n187 0.138245
R9086 VSS.n5885 VSS.n188 3.04638
R9087 VSS.n5885 VSS.n201 9.3005
R9088 VSS.n5888 VSS.n5887 9.3005
R9089 VSS.n5889 VSS.n4759 9.3005
R9090 VSS.n5891 VSS.n5890 9.3005
R9091 VSS.n5892 VSS.n4758 9.3005
R9092 VSS.n5896 VSS.n5895 9.3005
R9093 VSS.n4757 VSS.n4754 9.3005
R9094 VSS.n4750 VSS.n4748 9.3005
R9095 VSS.n5901 VSS.n5900 9.3005
R9096 VSS.n5903 VSS.n5902 9.3005
R9097 VSS.n4747 VSS.n4744 9.3005
R9098 VSS.n5905 VSS.n4742 9.3005
R9099 VSS.n5907 VSS.n5906 9.3005
R9100 VSS.n5908 VSS.n4741 9.3005
R9101 VSS.n5910 VSS.n5909 9.3005
R9102 VSS.n5911 VSS.n4740 9.3005
R9103 VSS.n5913 VSS.n5912 9.3005
R9104 VSS.n5915 VSS.n5914 9.3005
R9105 VSS.n5918 VSS.n4738 9.3005
R9106 VSS.n5920 VSS.n5919 9.3005
R9107 VSS.n5922 VSS.n5921 9.3005
R9108 VSS.n4736 VSS.n4733 9.3005
R9109 VSS.n5928 VSS.n5927 9.3005
R9110 VSS.n5930 VSS.n5929 9.3005
R9111 VSS.n4730 VSS.n4728 9.3005
R9112 VSS.n5937 VSS.n5936 9.3005
R9113 VSS.n5938 VSS.n4727 9.3005
R9114 VSS.n5940 VSS.n5939 9.3005
R9115 VSS.n5941 VSS.n4726 9.3005
R9116 VSS.n5943 VSS.n5942 9.3005
R9117 VSS.n5944 VSS.t3692 9.3005
R9118 VSS.n5946 VSS.n5945 9.3005
R9119 VSS.n5947 VSS.n4725 9.3005
R9120 VSS.n5955 VSS.n5954 9.3005
R9121 VSS.n5957 VSS.n5956 9.3005
R9122 VSS.n4721 VSS.n4718 9.3005
R9123 VSS.n5962 VSS.n4717 9.3005
R9124 VSS.n5964 VSS.n5963 9.3005
R9125 VSS.n5966 VSS.n5965 9.3005
R9126 VSS.n5975 VSS.n5974 9.3005
R9127 VSS.n5976 VSS.n4715 9.3005
R9128 VSS.n5978 VSS.n5977 9.3005
R9129 VSS.n4712 VSS.n4710 9.3005
R9130 VSS.n5985 VSS.n5984 9.3005
R9131 VSS.n5986 VSS.n4709 9.3005
R9132 VSS.n5988 VSS.n5987 9.3005
R9133 VSS.n5989 VSS.n4708 9.3005
R9134 VSS.n5991 VSS.n5990 9.3005
R9135 VSS.t3653 VSS.n5992 9.3005
R9136 VSS.n5993 VSS.n4707 9.3005
R9137 VSS.n5995 VSS.n5994 9.3005
R9138 VSS.n5997 VSS.n5996 9.3005
R9139 VSS.n4706 VSS.n4704 9.3005
R9140 VSS.n4700 VSS.n4698 9.3005
R9141 VSS.n6002 VSS.n6001 9.3005
R9142 VSS.n6004 VSS.n6003 9.3005
R9143 VSS.n4697 VSS.n4694 9.3005
R9144 VSS.n6006 VSS.n4692 9.3005
R9145 VSS.n6008 VSS.n6007 9.3005
R9146 VSS.n6009 VSS.n4691 9.3005
R9147 VSS.n6011 VSS.n6010 9.3005
R9148 VSS.n6012 VSS.n4690 9.3005
R9149 VSS.n6014 VSS.n6013 9.3005
R9150 VSS.n6016 VSS.n6015 9.3005
R9151 VSS.n6019 VSS.n4688 9.3005
R9152 VSS.n6021 VSS.n6020 9.3005
R9153 VSS.n6023 VSS.n6022 9.3005
R9154 VSS.n4686 VSS.n4683 9.3005
R9155 VSS.n6029 VSS.n6028 9.3005
R9156 VSS.n6031 VSS.n6030 9.3005
R9157 VSS.n4680 VSS.n4678 9.3005
R9158 VSS.n6038 VSS.n6037 9.3005
R9159 VSS.n6039 VSS.n4677 9.3005
R9160 VSS.n6041 VSS.n6040 9.3005
R9161 VSS.n6042 VSS.n4676 9.3005
R9162 VSS.n6044 VSS.n6043 9.3005
R9163 VSS.n6045 VSS.t3687 9.3005
R9164 VSS.n6047 VSS.n6046 9.3005
R9165 VSS.n6048 VSS.n4675 9.3005
R9166 VSS.n6056 VSS.n6055 9.3005
R9167 VSS.n6058 VSS.n6057 9.3005
R9168 VSS.n4671 VSS.n4668 9.3005
R9169 VSS.n6063 VSS.n4667 9.3005
R9170 VSS.n6065 VSS.n6064 9.3005
R9171 VSS.n6067 VSS.n6066 9.3005
R9172 VSS.n6076 VSS.n6075 9.3005
R9173 VSS.n6077 VSS.n4665 9.3005
R9174 VSS.n6079 VSS.n6078 9.3005
R9175 VSS.n4662 VSS.n4660 9.3005
R9176 VSS.n6086 VSS.n6085 9.3005
R9177 VSS.n6087 VSS.n4659 9.3005
R9178 VSS.n6089 VSS.n6088 9.3005
R9179 VSS.n6090 VSS.n4658 9.3005
R9180 VSS.n6092 VSS.n6091 9.3005
R9181 VSS.t3648 VSS.n6093 9.3005
R9182 VSS.n6094 VSS.n4657 9.3005
R9183 VSS.n6096 VSS.n6095 9.3005
R9184 VSS.n6098 VSS.n6097 9.3005
R9185 VSS.n4656 VSS.n4654 9.3005
R9186 VSS.n4650 VSS.n4648 9.3005
R9187 VSS.n6103 VSS.n6102 9.3005
R9188 VSS.n6105 VSS.n6104 9.3005
R9189 VSS.n4647 VSS.n4644 9.3005
R9190 VSS.n6107 VSS.n4642 9.3005
R9191 VSS.n6109 VSS.n6108 9.3005
R9192 VSS.n6110 VSS.n4641 9.3005
R9193 VSS.n6112 VSS.n6111 9.3005
R9194 VSS.n6113 VSS.n4640 9.3005
R9195 VSS.n6115 VSS.n6114 9.3005
R9196 VSS.n6117 VSS.n6116 9.3005
R9197 VSS.n6120 VSS.n4638 9.3005
R9198 VSS.n6122 VSS.n6121 9.3005
R9199 VSS.n6124 VSS.n6123 9.3005
R9200 VSS.n4636 VSS.n4633 9.3005
R9201 VSS.n6130 VSS.n6129 9.3005
R9202 VSS.n6132 VSS.n6131 9.3005
R9203 VSS.n4630 VSS.n4628 9.3005
R9204 VSS.n6139 VSS.n6138 9.3005
R9205 VSS.n6140 VSS.n4627 9.3005
R9206 VSS.n6142 VSS.n6141 9.3005
R9207 VSS.n6143 VSS.n4626 9.3005
R9208 VSS.n6145 VSS.n6144 9.3005
R9209 VSS.n6146 VSS.t3682 9.3005
R9210 VSS.n6148 VSS.n6147 9.3005
R9211 VSS.n6149 VSS.n4625 9.3005
R9212 VSS.n6157 VSS.n6156 9.3005
R9213 VSS.n6159 VSS.n6158 9.3005
R9214 VSS.n4621 VSS.n4618 9.3005
R9215 VSS.n6164 VSS.n4617 9.3005
R9216 VSS.n6166 VSS.n6165 9.3005
R9217 VSS.n6168 VSS.n6167 9.3005
R9218 VSS.n6177 VSS.n6176 9.3005
R9219 VSS.n6178 VSS.n4615 9.3005
R9220 VSS.n6180 VSS.n6179 9.3005
R9221 VSS.n4612 VSS.n4610 9.3005
R9222 VSS.n6187 VSS.n6186 9.3005
R9223 VSS.n6188 VSS.n4609 9.3005
R9224 VSS.n6190 VSS.n6189 9.3005
R9225 VSS.n6191 VSS.n4608 9.3005
R9226 VSS.n6193 VSS.n6192 9.3005
R9227 VSS.t3643 VSS.n6194 9.3005
R9228 VSS.n6195 VSS.n4607 9.3005
R9229 VSS.n6197 VSS.n6196 9.3005
R9230 VSS.n6199 VSS.n6198 9.3005
R9231 VSS.n4606 VSS.n4604 9.3005
R9232 VSS.n4600 VSS.n4598 9.3005
R9233 VSS.n6204 VSS.n6203 9.3005
R9234 VSS.n6206 VSS.n6205 9.3005
R9235 VSS.n4597 VSS.n4594 9.3005
R9236 VSS.n6208 VSS.n4592 9.3005
R9237 VSS.n6210 VSS.n6209 9.3005
R9238 VSS.n6211 VSS.n4591 9.3005
R9239 VSS.n6213 VSS.n6212 9.3005
R9240 VSS.n6214 VSS.n4590 9.3005
R9241 VSS.n6216 VSS.n6215 9.3005
R9242 VSS.n6218 VSS.n6217 9.3005
R9243 VSS.n6221 VSS.n4588 9.3005
R9244 VSS.n6223 VSS.n6222 9.3005
R9245 VSS.n6225 VSS.n6224 9.3005
R9246 VSS.n4586 VSS.n4583 9.3005
R9247 VSS.n6231 VSS.n6230 9.3005
R9248 VSS.n6233 VSS.n6232 9.3005
R9249 VSS.n4580 VSS.n4578 9.3005
R9250 VSS.n6240 VSS.n6239 9.3005
R9251 VSS.n6241 VSS.n4577 9.3005
R9252 VSS.n6243 VSS.n6242 9.3005
R9253 VSS.n6244 VSS.n4576 9.3005
R9254 VSS.n6246 VSS.n6245 9.3005
R9255 VSS.n6247 VSS.t3677 9.3005
R9256 VSS.n6249 VSS.n6248 9.3005
R9257 VSS.n6250 VSS.n4575 9.3005
R9258 VSS.n6258 VSS.n6257 9.3005
R9259 VSS.n6260 VSS.n6259 9.3005
R9260 VSS.n4571 VSS.n4568 9.3005
R9261 VSS.n6265 VSS.n4567 9.3005
R9262 VSS.n6267 VSS.n6266 9.3005
R9263 VSS.n6269 VSS.n6268 9.3005
R9264 VSS.n6278 VSS.n6277 9.3005
R9265 VSS.n6279 VSS.n4565 9.3005
R9266 VSS.n6281 VSS.n6280 9.3005
R9267 VSS.n4562 VSS.n4560 9.3005
R9268 VSS.n6288 VSS.n6287 9.3005
R9269 VSS.n6289 VSS.n4559 9.3005
R9270 VSS.n6291 VSS.n6290 9.3005
R9271 VSS.n6292 VSS.n4558 9.3005
R9272 VSS.n6294 VSS.n6293 9.3005
R9273 VSS.t3638 VSS.n6295 9.3005
R9274 VSS.n6296 VSS.n4557 9.3005
R9275 VSS.n6298 VSS.n6297 9.3005
R9276 VSS.n6300 VSS.n6299 9.3005
R9277 VSS.n4556 VSS.n4554 9.3005
R9278 VSS.n4550 VSS.n4548 9.3005
R9279 VSS.n6305 VSS.n6304 9.3005
R9280 VSS.n6307 VSS.n6306 9.3005
R9281 VSS.n4547 VSS.n4544 9.3005
R9282 VSS.n6309 VSS.n4542 9.3005
R9283 VSS.n6311 VSS.n6310 9.3005
R9284 VSS.n6312 VSS.n4541 9.3005
R9285 VSS.n6314 VSS.n6313 9.3005
R9286 VSS.n6315 VSS.n4540 9.3005
R9287 VSS.n6317 VSS.n6316 9.3005
R9288 VSS.n6319 VSS.n6318 9.3005
R9289 VSS.n6322 VSS.n4538 9.3005
R9290 VSS.n6324 VSS.n6323 9.3005
R9291 VSS.n6326 VSS.n6325 9.3005
R9292 VSS.n4536 VSS.n4533 9.3005
R9293 VSS.n6332 VSS.n6331 9.3005
R9294 VSS.n6334 VSS.n6333 9.3005
R9295 VSS.n4530 VSS.n4528 9.3005
R9296 VSS.n6341 VSS.n6340 9.3005
R9297 VSS.n6342 VSS.n4527 9.3005
R9298 VSS.n6344 VSS.n6343 9.3005
R9299 VSS.n6345 VSS.n4526 9.3005
R9300 VSS.n6347 VSS.n6346 9.3005
R9301 VSS.n6348 VSS.t3672 9.3005
R9302 VSS.n6350 VSS.n6349 9.3005
R9303 VSS.n6351 VSS.n4525 9.3005
R9304 VSS.n6359 VSS.n6358 9.3005
R9305 VSS.n6361 VSS.n6360 9.3005
R9306 VSS.n4521 VSS.n4518 9.3005
R9307 VSS.n6366 VSS.n4517 9.3005
R9308 VSS.n6368 VSS.n6367 9.3005
R9309 VSS.n6370 VSS.n6369 9.3005
R9310 VSS.n6379 VSS.n6378 9.3005
R9311 VSS.n6380 VSS.n4515 9.3005
R9312 VSS.n6382 VSS.n6381 9.3005
R9313 VSS.n4512 VSS.n4510 9.3005
R9314 VSS.n6389 VSS.n6388 9.3005
R9315 VSS.n6390 VSS.n4509 9.3005
R9316 VSS.n6392 VSS.n6391 9.3005
R9317 VSS.n6393 VSS.n4508 9.3005
R9318 VSS.n6395 VSS.n6394 9.3005
R9319 VSS.t3633 VSS.n6396 9.3005
R9320 VSS.n6397 VSS.n4507 9.3005
R9321 VSS.n6399 VSS.n6398 9.3005
R9322 VSS.n6401 VSS.n6400 9.3005
R9323 VSS.n4506 VSS.n4504 9.3005
R9324 VSS.n4500 VSS.n4498 9.3005
R9325 VSS.n6406 VSS.n6405 9.3005
R9326 VSS.n6408 VSS.n6407 9.3005
R9327 VSS.n4497 VSS.n4494 9.3005
R9328 VSS.n6410 VSS.n4492 9.3005
R9329 VSS.n6412 VSS.n6411 9.3005
R9330 VSS.n6413 VSS.n4491 9.3005
R9331 VSS.n6415 VSS.n6414 9.3005
R9332 VSS.n6416 VSS.n4490 9.3005
R9333 VSS.n6418 VSS.n6417 9.3005
R9334 VSS.n6420 VSS.n6419 9.3005
R9335 VSS.n6423 VSS.n4488 9.3005
R9336 VSS.n6425 VSS.n6424 9.3005
R9337 VSS.n6427 VSS.n6426 9.3005
R9338 VSS.n4486 VSS.n4483 9.3005
R9339 VSS.n6433 VSS.n6432 9.3005
R9340 VSS.n6435 VSS.n6434 9.3005
R9341 VSS.n4480 VSS.n4478 9.3005
R9342 VSS.n6442 VSS.n6441 9.3005
R9343 VSS.n6443 VSS.n4477 9.3005
R9344 VSS.n6445 VSS.n6444 9.3005
R9345 VSS.n6446 VSS.n4476 9.3005
R9346 VSS.n6448 VSS.n6447 9.3005
R9347 VSS.t3667 VSS.n6449 9.3005
R9348 VSS.n6450 VSS.n4475 9.3005
R9349 VSS.n6452 VSS.n6451 9.3005
R9350 VSS.n6474 VSS.n6473 9.3005
R9351 VSS.n6457 VSS.n6456 9.3005
R9352 VSS.n6467 VSS.n6466 9.3005
R9353 VSS.n6465 VSS.n6464 9.3005
R9354 VSS.n6463 VSS.n6460 9.3005
R9355 VSS.n6462 VSS.n6461 9.3005
R9356 VSS.n90 VSS.n6543 2.25403
R9357 VSS.n90 VSS.n10 0.192834
R9358 VSS.n4465 VSS.n10 9.3005
R9359 VSS.n10 VSS.n81 4.07296
R9360 VSS.n10 VSS.n60 9.3005
R9361 VSS.n10 VSS.n6536 9.3005
R9362 VSS.n50 VSS.n10 3.96704
R9363 VSS.n10 VSS.n6531 9.3005
R9364 VSS.n6530 VSS.n9 9.3005
R9365 VSS.t3628 VSS.n6529 9.3005
R9366 VSS.n6528 VSS.n4469 9.3005
R9367 VSS.n6527 VSS.n6526 9.3005
R9368 VSS.n4471 VSS.n4470 9.3005
R9369 VSS.n6519 VSS.n4472 9.3005
R9370 VSS.n6521 VSS.n6520 9.3005
R9371 VSS.n6518 VSS.n6479 9.3005
R9372 VSS.n6517 VSS.n6516 9.3005
R9373 VSS.n6511 VSS.n6480 9.3005
R9374 VSS.n6505 VSS.n6482 9.3005
R9375 VSS.n6507 VSS.n6506 9.3005
R9376 VSS.n6504 VSS.n6503 9.3005
R9377 VSS.n6499 VSS.n6485 9.3005
R9378 VSS.n6498 VSS.n6497 9.3005
R9379 VSS.n6496 VSS.n6495 9.3005
R9380 VSS.n6494 VSS.n6486 9.3005
R9381 VSS.t3663 VSS.n6493 9.3005
R9382 VSS.n6492 VSS.n6487 9.3005
R9383 VSS.n6491 VSS.n6490 9.3005
R9384 VSS.n6489 VSS.n6488 9.3005
R9385 VSS.n6873 VSS.n6872 9.3005
R9386 VSS.n6875 VSS.n6874 9.3005
R9387 VSS.n6866 VSS.n6863 9.3005
R9388 VSS.n6882 VSS.n6881 9.3005
R9389 VSS.n6883 VSS.n6862 9.3005
R9390 VSS.n6885 VSS.n6884 9.3005
R9391 VSS.n6886 VSS.n6861 9.3005
R9392 VSS.n6888 VSS.n6887 9.3005
R9393 VSS.n6889 VSS.n6860 9.3005
R9394 VSS.n6891 VSS.n6890 9.3005
R9395 VSS.n6892 VSS.n6859 9.3005
R9396 VSS.n6894 VSS.n6893 9.3005
R9397 VSS.n6895 VSS.n6858 9.3005
R9398 VSS.n6897 VSS.n6896 9.3005
R9399 VSS.n6852 VSS.n6849 9.3005
R9400 VSS.n6904 VSS.n6903 9.3005
R9401 VSS.n6905 VSS.n6848 9.3005
R9402 VSS.n6907 VSS.n6906 9.3005
R9403 VSS.n6908 VSS.n6847 9.3005
R9404 VSS.n6910 VSS.n6909 9.3005
R9405 VSS.n6911 VSS.n6846 9.3005
R9406 VSS.n6913 VSS.n6912 9.3005
R9407 VSS.n6914 VSS.n6844 9.3005
R9408 VSS.n6921 VSS.n6920 9.3005
R9409 VSS.n6922 VSS.n6842 9.3005
R9410 VSS.n6924 VSS.n6923 9.3005
R9411 VSS.n6925 VSS.n6841 9.3005
R9412 VSS.n185 VSS.n184 0.138245
R9413 VSS.n6927 VSS.n185 3.04638
R9414 VSS.n6927 VSS.n203 9.3005
R9415 VSS.n6930 VSS.n6929 9.3005
R9416 VSS.n6931 VSS.n6840 9.3005
R9417 VSS.n6933 VSS.n6932 9.3005
R9418 VSS.n6934 VSS.n6839 9.3005
R9419 VSS.n6938 VSS.n6937 9.3005
R9420 VSS.n6838 VSS.n6835 9.3005
R9421 VSS.n6831 VSS.n6829 9.3005
R9422 VSS.n6943 VSS.n6942 9.3005
R9423 VSS.n6945 VSS.n6944 9.3005
R9424 VSS.n6828 VSS.n6825 9.3005
R9425 VSS.n6947 VSS.n6823 9.3005
R9426 VSS.n6949 VSS.n6948 9.3005
R9427 VSS.n6950 VSS.n6822 9.3005
R9428 VSS.n6952 VSS.n6951 9.3005
R9429 VSS.n6953 VSS.n6821 9.3005
R9430 VSS.n6955 VSS.n6954 9.3005
R9431 VSS.n6957 VSS.n6956 9.3005
R9432 VSS.n6960 VSS.n6819 9.3005
R9433 VSS.n6962 VSS.n6961 9.3005
R9434 VSS.n6964 VSS.n6963 9.3005
R9435 VSS.n6817 VSS.n6814 9.3005
R9436 VSS.n6970 VSS.n6969 9.3005
R9437 VSS.n6972 VSS.n6971 9.3005
R9438 VSS.n6811 VSS.n6809 9.3005
R9439 VSS.n6979 VSS.n6978 9.3005
R9440 VSS.n6980 VSS.n6808 9.3005
R9441 VSS.n6982 VSS.n6981 9.3005
R9442 VSS.n6983 VSS.n6807 9.3005
R9443 VSS.n6985 VSS.n6984 9.3005
R9444 VSS.n6986 VSS.t3762 9.3005
R9445 VSS.n6988 VSS.n6987 9.3005
R9446 VSS.n6989 VSS.n6806 9.3005
R9447 VSS.n6997 VSS.n6996 9.3005
R9448 VSS.n6999 VSS.n6998 9.3005
R9449 VSS.n6802 VSS.n6799 9.3005
R9450 VSS.n7004 VSS.n6798 9.3005
R9451 VSS.n7006 VSS.n7005 9.3005
R9452 VSS.n7008 VSS.n7007 9.3005
R9453 VSS.n7017 VSS.n7016 9.3005
R9454 VSS.n7018 VSS.n6796 9.3005
R9455 VSS.n7020 VSS.n7019 9.3005
R9456 VSS.n6793 VSS.n6791 9.3005
R9457 VSS.n7027 VSS.n7026 9.3005
R9458 VSS.n7028 VSS.n6790 9.3005
R9459 VSS.n7030 VSS.n7029 9.3005
R9460 VSS.n7031 VSS.n6789 9.3005
R9461 VSS.n7033 VSS.n7032 9.3005
R9462 VSS.t3723 VSS.n7034 9.3005
R9463 VSS.n7035 VSS.n6788 9.3005
R9464 VSS.n7037 VSS.n7036 9.3005
R9465 VSS.n7039 VSS.n7038 9.3005
R9466 VSS.n6787 VSS.n6785 9.3005
R9467 VSS.n6781 VSS.n6779 9.3005
R9468 VSS.n7044 VSS.n7043 9.3005
R9469 VSS.n7046 VSS.n7045 9.3005
R9470 VSS.n6778 VSS.n6775 9.3005
R9471 VSS.n7048 VSS.n6773 9.3005
R9472 VSS.n7050 VSS.n7049 9.3005
R9473 VSS.n7051 VSS.n6772 9.3005
R9474 VSS.n7053 VSS.n7052 9.3005
R9475 VSS.n7054 VSS.n6771 9.3005
R9476 VSS.n7056 VSS.n7055 9.3005
R9477 VSS.n7058 VSS.n7057 9.3005
R9478 VSS.n7061 VSS.n6769 9.3005
R9479 VSS.n7063 VSS.n7062 9.3005
R9480 VSS.n7065 VSS.n7064 9.3005
R9481 VSS.n6767 VSS.n6764 9.3005
R9482 VSS.n7071 VSS.n7070 9.3005
R9483 VSS.n7073 VSS.n7072 9.3005
R9484 VSS.n6761 VSS.n6759 9.3005
R9485 VSS.n7080 VSS.n7079 9.3005
R9486 VSS.n7081 VSS.n6758 9.3005
R9487 VSS.n7083 VSS.n7082 9.3005
R9488 VSS.n7084 VSS.n6757 9.3005
R9489 VSS.n7086 VSS.n7085 9.3005
R9490 VSS.n7087 VSS.t3757 9.3005
R9491 VSS.n7089 VSS.n7088 9.3005
R9492 VSS.n7090 VSS.n6756 9.3005
R9493 VSS.n7098 VSS.n7097 9.3005
R9494 VSS.n7100 VSS.n7099 9.3005
R9495 VSS.n6752 VSS.n6749 9.3005
R9496 VSS.n7105 VSS.n6748 9.3005
R9497 VSS.n7107 VSS.n7106 9.3005
R9498 VSS.n7109 VSS.n7108 9.3005
R9499 VSS.n7118 VSS.n7117 9.3005
R9500 VSS.n7119 VSS.n6746 9.3005
R9501 VSS.n7121 VSS.n7120 9.3005
R9502 VSS.n6743 VSS.n6741 9.3005
R9503 VSS.n7128 VSS.n7127 9.3005
R9504 VSS.n7129 VSS.n6740 9.3005
R9505 VSS.n7131 VSS.n7130 9.3005
R9506 VSS.n7132 VSS.n6739 9.3005
R9507 VSS.n7134 VSS.n7133 9.3005
R9508 VSS.t3718 VSS.n7135 9.3005
R9509 VSS.n7136 VSS.n6738 9.3005
R9510 VSS.n7138 VSS.n7137 9.3005
R9511 VSS.n7140 VSS.n7139 9.3005
R9512 VSS.n6737 VSS.n6735 9.3005
R9513 VSS.n6731 VSS.n6729 9.3005
R9514 VSS.n7145 VSS.n7144 9.3005
R9515 VSS.n7147 VSS.n7146 9.3005
R9516 VSS.n6728 VSS.n6725 9.3005
R9517 VSS.n7149 VSS.n6723 9.3005
R9518 VSS.n7151 VSS.n7150 9.3005
R9519 VSS.n7152 VSS.n6722 9.3005
R9520 VSS.n7154 VSS.n7153 9.3005
R9521 VSS.n7155 VSS.n6721 9.3005
R9522 VSS.n7157 VSS.n7156 9.3005
R9523 VSS.n7159 VSS.n7158 9.3005
R9524 VSS.n7162 VSS.n6719 9.3005
R9525 VSS.n7164 VSS.n7163 9.3005
R9526 VSS.n7166 VSS.n7165 9.3005
R9527 VSS.n6717 VSS.n6714 9.3005
R9528 VSS.n7172 VSS.n7171 9.3005
R9529 VSS.n7174 VSS.n7173 9.3005
R9530 VSS.n6711 VSS.n6709 9.3005
R9531 VSS.n7181 VSS.n7180 9.3005
R9532 VSS.n7182 VSS.n6708 9.3005
R9533 VSS.n7184 VSS.n7183 9.3005
R9534 VSS.n7185 VSS.n6707 9.3005
R9535 VSS.n7187 VSS.n7186 9.3005
R9536 VSS.n7188 VSS.t3752 9.3005
R9537 VSS.n7190 VSS.n7189 9.3005
R9538 VSS.n7191 VSS.n6706 9.3005
R9539 VSS.n7199 VSS.n7198 9.3005
R9540 VSS.n7201 VSS.n7200 9.3005
R9541 VSS.n6702 VSS.n6699 9.3005
R9542 VSS.n7206 VSS.n6698 9.3005
R9543 VSS.n7208 VSS.n7207 9.3005
R9544 VSS.n7210 VSS.n7209 9.3005
R9545 VSS.n7219 VSS.n7218 9.3005
R9546 VSS.n7220 VSS.n6696 9.3005
R9547 VSS.n7222 VSS.n7221 9.3005
R9548 VSS.n6693 VSS.n6691 9.3005
R9549 VSS.n7229 VSS.n7228 9.3005
R9550 VSS.n7230 VSS.n6690 9.3005
R9551 VSS.n7232 VSS.n7231 9.3005
R9552 VSS.n7233 VSS.n6689 9.3005
R9553 VSS.n7235 VSS.n7234 9.3005
R9554 VSS.t3713 VSS.n7236 9.3005
R9555 VSS.n7237 VSS.n6688 9.3005
R9556 VSS.n7239 VSS.n7238 9.3005
R9557 VSS.n7241 VSS.n7240 9.3005
R9558 VSS.n6687 VSS.n6685 9.3005
R9559 VSS.n6681 VSS.n6679 9.3005
R9560 VSS.n7246 VSS.n7245 9.3005
R9561 VSS.n7248 VSS.n7247 9.3005
R9562 VSS.n6678 VSS.n6675 9.3005
R9563 VSS.n7250 VSS.n6673 9.3005
R9564 VSS.n7252 VSS.n7251 9.3005
R9565 VSS.n7253 VSS.n6672 9.3005
R9566 VSS.n7255 VSS.n7254 9.3005
R9567 VSS.n7256 VSS.n6671 9.3005
R9568 VSS.n7258 VSS.n7257 9.3005
R9569 VSS.n7260 VSS.n7259 9.3005
R9570 VSS.n7263 VSS.n6669 9.3005
R9571 VSS.n7265 VSS.n7264 9.3005
R9572 VSS.n7267 VSS.n7266 9.3005
R9573 VSS.n6667 VSS.n6664 9.3005
R9574 VSS.n7273 VSS.n7272 9.3005
R9575 VSS.n7275 VSS.n7274 9.3005
R9576 VSS.n6661 VSS.n6659 9.3005
R9577 VSS.n7282 VSS.n7281 9.3005
R9578 VSS.n7283 VSS.n6658 9.3005
R9579 VSS.n7285 VSS.n7284 9.3005
R9580 VSS.n7286 VSS.n6657 9.3005
R9581 VSS.n7288 VSS.n7287 9.3005
R9582 VSS.n7289 VSS.t3747 9.3005
R9583 VSS.n7291 VSS.n7290 9.3005
R9584 VSS.n7292 VSS.n6656 9.3005
R9585 VSS.n7300 VSS.n7299 9.3005
R9586 VSS.n7302 VSS.n7301 9.3005
R9587 VSS.n6652 VSS.n6649 9.3005
R9588 VSS.n7307 VSS.n6648 9.3005
R9589 VSS.n7309 VSS.n7308 9.3005
R9590 VSS.n7311 VSS.n7310 9.3005
R9591 VSS.n7320 VSS.n7319 9.3005
R9592 VSS.n7321 VSS.n6646 9.3005
R9593 VSS.n7323 VSS.n7322 9.3005
R9594 VSS.n6643 VSS.n6641 9.3005
R9595 VSS.n7330 VSS.n7329 9.3005
R9596 VSS.n7331 VSS.n6640 9.3005
R9597 VSS.n7333 VSS.n7332 9.3005
R9598 VSS.n7334 VSS.n6639 9.3005
R9599 VSS.n7336 VSS.n7335 9.3005
R9600 VSS.t3708 VSS.n7337 9.3005
R9601 VSS.n7338 VSS.n6638 9.3005
R9602 VSS.n7340 VSS.n7339 9.3005
R9603 VSS.n7342 VSS.n7341 9.3005
R9604 VSS.n6637 VSS.n6635 9.3005
R9605 VSS.n6631 VSS.n6629 9.3005
R9606 VSS.n7347 VSS.n7346 9.3005
R9607 VSS.n7349 VSS.n7348 9.3005
R9608 VSS.n6628 VSS.n6625 9.3005
R9609 VSS.n7351 VSS.n6623 9.3005
R9610 VSS.n7353 VSS.n7352 9.3005
R9611 VSS.n7354 VSS.n6622 9.3005
R9612 VSS.n7356 VSS.n7355 9.3005
R9613 VSS.n7357 VSS.n6621 9.3005
R9614 VSS.n7359 VSS.n7358 9.3005
R9615 VSS.n7361 VSS.n7360 9.3005
R9616 VSS.n7364 VSS.n6619 9.3005
R9617 VSS.n7366 VSS.n7365 9.3005
R9618 VSS.n7368 VSS.n7367 9.3005
R9619 VSS.n6617 VSS.n6614 9.3005
R9620 VSS.n7374 VSS.n7373 9.3005
R9621 VSS.n7376 VSS.n7375 9.3005
R9622 VSS.n6611 VSS.n6609 9.3005
R9623 VSS.n7383 VSS.n7382 9.3005
R9624 VSS.n7384 VSS.n6608 9.3005
R9625 VSS.n7386 VSS.n7385 9.3005
R9626 VSS.n7387 VSS.n6607 9.3005
R9627 VSS.n7389 VSS.n7388 9.3005
R9628 VSS.n7390 VSS.t3742 9.3005
R9629 VSS.n7392 VSS.n7391 9.3005
R9630 VSS.n7393 VSS.n6606 9.3005
R9631 VSS.n7401 VSS.n7400 9.3005
R9632 VSS.n7403 VSS.n7402 9.3005
R9633 VSS.n6602 VSS.n6599 9.3005
R9634 VSS.n7408 VSS.n6598 9.3005
R9635 VSS.n7410 VSS.n7409 9.3005
R9636 VSS.n7412 VSS.n7411 9.3005
R9637 VSS.n7421 VSS.n7420 9.3005
R9638 VSS.n7422 VSS.n6596 9.3005
R9639 VSS.n7424 VSS.n7423 9.3005
R9640 VSS.n6593 VSS.n6591 9.3005
R9641 VSS.n7431 VSS.n7430 9.3005
R9642 VSS.n7432 VSS.n6590 9.3005
R9643 VSS.n7434 VSS.n7433 9.3005
R9644 VSS.n7435 VSS.n6589 9.3005
R9645 VSS.n7437 VSS.n7436 9.3005
R9646 VSS.t3703 VSS.n7438 9.3005
R9647 VSS.n7439 VSS.n6588 9.3005
R9648 VSS.n7441 VSS.n7440 9.3005
R9649 VSS.n7443 VSS.n7442 9.3005
R9650 VSS.n6587 VSS.n6585 9.3005
R9651 VSS.n6581 VSS.n6579 9.3005
R9652 VSS.n7448 VSS.n7447 9.3005
R9653 VSS.n7450 VSS.n7449 9.3005
R9654 VSS.n6578 VSS.n6575 9.3005
R9655 VSS.n7452 VSS.n6573 9.3005
R9656 VSS.n7454 VSS.n7453 9.3005
R9657 VSS.n7455 VSS.n6572 9.3005
R9658 VSS.n7457 VSS.n7456 9.3005
R9659 VSS.n7458 VSS.n6571 9.3005
R9660 VSS.n7460 VSS.n7459 9.3005
R9661 VSS.n7462 VSS.n7461 9.3005
R9662 VSS.n7465 VSS.n6569 9.3005
R9663 VSS.n7467 VSS.n7466 9.3005
R9664 VSS.n7469 VSS.n7468 9.3005
R9665 VSS.n6567 VSS.n6564 9.3005
R9666 VSS.n7475 VSS.n7474 9.3005
R9667 VSS.n7477 VSS.n7476 9.3005
R9668 VSS.n6561 VSS.n6559 9.3005
R9669 VSS.n7484 VSS.n7483 9.3005
R9670 VSS.n7485 VSS.n6558 9.3005
R9671 VSS.n7487 VSS.n7486 9.3005
R9672 VSS.n7488 VSS.n6557 9.3005
R9673 VSS.n7490 VSS.n7489 9.3005
R9674 VSS.t3737 VSS.n7491 9.3005
R9675 VSS.n7492 VSS.n6556 9.3005
R9676 VSS.n7494 VSS.n7493 9.3005
R9677 VSS.n7516 VSS.n7515 9.3005
R9678 VSS.n7499 VSS.n7498 9.3005
R9679 VSS.n7509 VSS.n7508 9.3005
R9680 VSS.n7507 VSS.n7506 9.3005
R9681 VSS.n7505 VSS.n7502 9.3005
R9682 VSS.n7504 VSS.n7503 9.3005
R9683 VSS.n91 VSS.n7585 2.25403
R9684 VSS.n91 VSS.n12 0.192834
R9685 VSS.n6546 VSS.n12 9.3005
R9686 VSS.n12 VSS.n80 4.07296
R9687 VSS.n12 VSS.n61 9.3005
R9688 VSS.n12 VSS.n7578 9.3005
R9689 VSS.n49 VSS.n12 3.96704
R9690 VSS.n12 VSS.n7573 9.3005
R9691 VSS.n7572 VSS.n11 9.3005
R9692 VSS.t3698 VSS.n7571 9.3005
R9693 VSS.n7570 VSS.n6550 9.3005
R9694 VSS.n7569 VSS.n7568 9.3005
R9695 VSS.n6552 VSS.n6551 9.3005
R9696 VSS.n7561 VSS.n6553 9.3005
R9697 VSS.n7563 VSS.n7562 9.3005
R9698 VSS.n7560 VSS.n7521 9.3005
R9699 VSS.n7559 VSS.n7558 9.3005
R9700 VSS.n7553 VSS.n7522 9.3005
R9701 VSS.n7547 VSS.n7524 9.3005
R9702 VSS.n7549 VSS.n7548 9.3005
R9703 VSS.n7546 VSS.n7545 9.3005
R9704 VSS.n7541 VSS.n7527 9.3005
R9705 VSS.n7540 VSS.n7539 9.3005
R9706 VSS.n7538 VSS.n7537 9.3005
R9707 VSS.n7536 VSS.n7528 9.3005
R9708 VSS.t3733 VSS.n7535 9.3005
R9709 VSS.n7534 VSS.n7529 9.3005
R9710 VSS.n7533 VSS.n7532 9.3005
R9711 VSS.n7531 VSS.n7530 9.3005
R9712 VSS.n8309 VSS.n8304 9.3005
R9713 VSS.n8311 VSS.n8310 9.3005
R9714 VSS.n8313 VSS.n8312 9.3005
R9715 VSS.n8303 VSS.n8299 9.3005
R9716 VSS.n8318 VSS.n8297 9.3005
R9717 VSS.n8320 VSS.n8319 9.3005
R9718 VSS.n8321 VSS.n8296 9.3005
R9719 VSS.n8323 VSS.n8322 9.3005
R9720 VSS.n8324 VSS.n8295 9.3005
R9721 VSS.n8326 VSS.n8325 9.3005
R9722 VSS.n8327 VSS.n8294 9.3005
R9723 VSS.n8329 VSS.n8328 9.3005
R9724 VSS.n8332 VSS.n8291 9.3005
R9725 VSS.n8334 VSS.n8333 9.3005
R9726 VSS.n8336 VSS.n8335 9.3005
R9727 VSS.n8290 VSS.n8286 9.3005
R9728 VSS.n8341 VSS.n8284 9.3005
R9729 VSS.n8343 VSS.n8342 9.3005
R9730 VSS.n8344 VSS.n8283 9.3005
R9731 VSS.n8346 VSS.n8345 9.3005
R9732 VSS.n8347 VSS.n8282 9.3005
R9733 VSS.n8349 VSS.n8348 9.3005
R9734 VSS.n8351 VSS.n8350 9.3005
R9735 VSS.n8356 VSS.n2275 9.3005
R9736 VSS.n8358 VSS.n8357 9.3005
R9737 VSS.n8359 VSS.n2274 9.3005
R9738 VSS.n8361 VSS.n8360 9.3005
R9739 VSS.n181 VSS.n182 0.138245
R9740 VSS.n8364 VSS.n182 3.04638
R9741 VSS.n8364 VSS.n204 9.3005
R9742 VSS.n2288 VSS.n2287 9.3005
R9743 VSS.n2289 VSS.n2284 9.3005
R9744 VSS.n2291 VSS.n2290 9.3005
R9745 VSS.n2292 VSS.n2283 9.3005
R9746 VSS.n2296 VSS.n2295 9.3005
R9747 VSS.n8274 VSS.n2280 9.3005
R9748 VSS.n8276 VSS.n8275 9.3005
R9749 VSS.n8278 VSS.n8277 9.3005
R9750 VSS.n2297 VSS.n2279 9.3005
R9751 VSS.n8264 VSS.n141 9.3005
R9752 VSS.n8266 VSS.n8265 9.3005
R9753 VSS.n8263 VSS.n2298 9.3005
R9754 VSS.n8262 VSS.n8261 9.3005
R9755 VSS.n8259 VSS.n2299 9.3005
R9756 VSS.n8258 VSS.n8257 9.3005
R9757 VSS.n8256 VSS.n8255 9.3005
R9758 VSS.n2301 VSS.n2300 9.3005
R9759 VSS.n8253 VSS.n8252 9.3005
R9760 VSS.n8251 VSS.n2302 9.3005
R9761 VSS.n8250 VSS.n8249 9.3005
R9762 VSS.n8241 VSS.n2304 9.3005
R9763 VSS.n8237 VSS.n2306 9.3005
R9764 VSS.n8239 VSS.n8238 9.3005
R9765 VSS.n8236 VSS.n8235 9.3005
R9766 VSS.n2310 VSS.n2309 9.3005
R9767 VSS.n8229 VSS.n8228 9.3005
R9768 VSS.n8227 VSS.n2311 9.3005
R9769 VSS.n8226 VSS.n8225 9.3005
R9770 VSS.n8224 VSS.n2312 9.3005
R9771 VSS.t3832 VSS.n8223 9.3005
R9772 VSS.n8222 VSS.n2313 9.3005
R9773 VSS.n8221 VSS.n8220 9.3005
R9774 VSS.n8216 VSS.n8215 9.3005
R9775 VSS.n2319 VSS.n2318 9.3005
R9776 VSS.n8209 VSS.n8208 9.3005
R9777 VSS.n8207 VSS.n8206 9.3005
R9778 VSS.n8205 VSS.n2322 9.3005
R9779 VSS.n8204 VSS.n8203 9.3005
R9780 VSS.n8201 VSS.n8200 9.3005
R9781 VSS.n2328 VSS.n2324 9.3005
R9782 VSS.n8193 VSS.n8192 9.3005
R9783 VSS.n8191 VSS.n2330 9.3005
R9784 VSS.n8190 VSS.n8189 9.3005
R9785 VSS.n8184 VSS.n2331 9.3005
R9786 VSS.n8183 VSS.n8182 9.3005
R9787 VSS.n8181 VSS.n8180 9.3005
R9788 VSS.n8179 VSS.n2332 9.3005
R9789 VSS.t3793 VSS.n8178 9.3005
R9790 VSS.n8177 VSS.n2333 9.3005
R9791 VSS.n8176 VSS.n8175 9.3005
R9792 VSS.n2335 VSS.n2334 9.3005
R9793 VSS.n8168 VSS.n2336 9.3005
R9794 VSS.n8170 VSS.n8169 9.3005
R9795 VSS.n8167 VSS.n2338 9.3005
R9796 VSS.n8166 VSS.n8165 9.3005
R9797 VSS.n8160 VSS.n2339 9.3005
R9798 VSS.n8159 VSS.n8158 9.3005
R9799 VSS.n8157 VSS.n2340 9.3005
R9800 VSS.n8156 VSS.n8155 9.3005
R9801 VSS.n8153 VSS.n2341 9.3005
R9802 VSS.n8152 VSS.n8151 9.3005
R9803 VSS.n8150 VSS.n8149 9.3005
R9804 VSS.n2343 VSS.n2342 9.3005
R9805 VSS.n8147 VSS.n8146 9.3005
R9806 VSS.n8145 VSS.n2344 9.3005
R9807 VSS.n8144 VSS.n8143 9.3005
R9808 VSS.n8135 VSS.n2346 9.3005
R9809 VSS.n8131 VSS.n2348 9.3005
R9810 VSS.n8133 VSS.n8132 9.3005
R9811 VSS.n8130 VSS.n8129 9.3005
R9812 VSS.n2352 VSS.n2351 9.3005
R9813 VSS.n8123 VSS.n8122 9.3005
R9814 VSS.n8121 VSS.n2353 9.3005
R9815 VSS.n8120 VSS.n8119 9.3005
R9816 VSS.n8118 VSS.n2354 9.3005
R9817 VSS.t3827 VSS.n8117 9.3005
R9818 VSS.n8116 VSS.n2355 9.3005
R9819 VSS.n8115 VSS.n8114 9.3005
R9820 VSS.n8110 VSS.n8109 9.3005
R9821 VSS.n2361 VSS.n2360 9.3005
R9822 VSS.n8103 VSS.n8102 9.3005
R9823 VSS.n8101 VSS.n8100 9.3005
R9824 VSS.n8099 VSS.n2364 9.3005
R9825 VSS.n8098 VSS.n8097 9.3005
R9826 VSS.n8095 VSS.n8094 9.3005
R9827 VSS.n2370 VSS.n2366 9.3005
R9828 VSS.n8087 VSS.n8086 9.3005
R9829 VSS.n8085 VSS.n2372 9.3005
R9830 VSS.n8084 VSS.n8083 9.3005
R9831 VSS.n8078 VSS.n2373 9.3005
R9832 VSS.n8077 VSS.n8076 9.3005
R9833 VSS.n8075 VSS.n8074 9.3005
R9834 VSS.n8073 VSS.n2374 9.3005
R9835 VSS.t3788 VSS.n8072 9.3005
R9836 VSS.n8071 VSS.n2375 9.3005
R9837 VSS.n8070 VSS.n8069 9.3005
R9838 VSS.n2377 VSS.n2376 9.3005
R9839 VSS.n8062 VSS.n2378 9.3005
R9840 VSS.n8064 VSS.n8063 9.3005
R9841 VSS.n8061 VSS.n2380 9.3005
R9842 VSS.n8060 VSS.n8059 9.3005
R9843 VSS.n8054 VSS.n2381 9.3005
R9844 VSS.n8053 VSS.n8052 9.3005
R9845 VSS.n8051 VSS.n2382 9.3005
R9846 VSS.n8050 VSS.n8049 9.3005
R9847 VSS.n8047 VSS.n2383 9.3005
R9848 VSS.n8046 VSS.n8045 9.3005
R9849 VSS.n8044 VSS.n8043 9.3005
R9850 VSS.n2385 VSS.n2384 9.3005
R9851 VSS.n8041 VSS.n8040 9.3005
R9852 VSS.n8039 VSS.n2386 9.3005
R9853 VSS.n8038 VSS.n8037 9.3005
R9854 VSS.n8029 VSS.n2388 9.3005
R9855 VSS.n8025 VSS.n2390 9.3005
R9856 VSS.n8027 VSS.n8026 9.3005
R9857 VSS.n8024 VSS.n8023 9.3005
R9858 VSS.n2394 VSS.n2393 9.3005
R9859 VSS.n8017 VSS.n8016 9.3005
R9860 VSS.n8015 VSS.n2395 9.3005
R9861 VSS.n8014 VSS.n8013 9.3005
R9862 VSS.n8012 VSS.n2396 9.3005
R9863 VSS.t3822 VSS.n8011 9.3005
R9864 VSS.n8010 VSS.n2397 9.3005
R9865 VSS.n8009 VSS.n8008 9.3005
R9866 VSS.n8004 VSS.n8003 9.3005
R9867 VSS.n2403 VSS.n2402 9.3005
R9868 VSS.n7997 VSS.n7996 9.3005
R9869 VSS.n7995 VSS.n7994 9.3005
R9870 VSS.n7993 VSS.n2406 9.3005
R9871 VSS.n7992 VSS.n7991 9.3005
R9872 VSS.n7989 VSS.n7988 9.3005
R9873 VSS.n2412 VSS.n2408 9.3005
R9874 VSS.n7981 VSS.n7980 9.3005
R9875 VSS.n7979 VSS.n2414 9.3005
R9876 VSS.n7978 VSS.n7977 9.3005
R9877 VSS.n7972 VSS.n2415 9.3005
R9878 VSS.n7971 VSS.n7970 9.3005
R9879 VSS.n7969 VSS.n7968 9.3005
R9880 VSS.n7967 VSS.n2416 9.3005
R9881 VSS.t3783 VSS.n7966 9.3005
R9882 VSS.n7965 VSS.n2417 9.3005
R9883 VSS.n7964 VSS.n7963 9.3005
R9884 VSS.n2419 VSS.n2418 9.3005
R9885 VSS.n7956 VSS.n2420 9.3005
R9886 VSS.n7958 VSS.n7957 9.3005
R9887 VSS.n7955 VSS.n2422 9.3005
R9888 VSS.n7954 VSS.n7953 9.3005
R9889 VSS.n7948 VSS.n2423 9.3005
R9890 VSS.n7947 VSS.n7946 9.3005
R9891 VSS.n7945 VSS.n2424 9.3005
R9892 VSS.n7944 VSS.n7943 9.3005
R9893 VSS.n7941 VSS.n2425 9.3005
R9894 VSS.n7940 VSS.n7939 9.3005
R9895 VSS.n7938 VSS.n7937 9.3005
R9896 VSS.n2427 VSS.n2426 9.3005
R9897 VSS.n7935 VSS.n7934 9.3005
R9898 VSS.n7933 VSS.n2428 9.3005
R9899 VSS.n7932 VSS.n7931 9.3005
R9900 VSS.n7923 VSS.n2430 9.3005
R9901 VSS.n7919 VSS.n2432 9.3005
R9902 VSS.n7921 VSS.n7920 9.3005
R9903 VSS.n7918 VSS.n7917 9.3005
R9904 VSS.n2436 VSS.n2435 9.3005
R9905 VSS.n7911 VSS.n7910 9.3005
R9906 VSS.n7909 VSS.n2437 9.3005
R9907 VSS.n7908 VSS.n7907 9.3005
R9908 VSS.n7906 VSS.n2438 9.3005
R9909 VSS.t3817 VSS.n7905 9.3005
R9910 VSS.n7904 VSS.n2439 9.3005
R9911 VSS.n7903 VSS.n7902 9.3005
R9912 VSS.n7898 VSS.n7897 9.3005
R9913 VSS.n2445 VSS.n2444 9.3005
R9914 VSS.n7891 VSS.n7890 9.3005
R9915 VSS.n7889 VSS.n7888 9.3005
R9916 VSS.n7887 VSS.n2448 9.3005
R9917 VSS.n7886 VSS.n7885 9.3005
R9918 VSS.n7883 VSS.n7882 9.3005
R9919 VSS.n2454 VSS.n2450 9.3005
R9920 VSS.n7875 VSS.n7874 9.3005
R9921 VSS.n7873 VSS.n2456 9.3005
R9922 VSS.n7872 VSS.n7871 9.3005
R9923 VSS.n7866 VSS.n2457 9.3005
R9924 VSS.n7865 VSS.n7864 9.3005
R9925 VSS.n7863 VSS.n7862 9.3005
R9926 VSS.n7861 VSS.n2458 9.3005
R9927 VSS.t3778 VSS.n7860 9.3005
R9928 VSS.n7859 VSS.n2459 9.3005
R9929 VSS.n7858 VSS.n7857 9.3005
R9930 VSS.n2461 VSS.n2460 9.3005
R9931 VSS.n7850 VSS.n2462 9.3005
R9932 VSS.n7852 VSS.n7851 9.3005
R9933 VSS.n7849 VSS.n2464 9.3005
R9934 VSS.n7848 VSS.n7847 9.3005
R9935 VSS.n7842 VSS.n2465 9.3005
R9936 VSS.n7841 VSS.n7840 9.3005
R9937 VSS.n7839 VSS.n2466 9.3005
R9938 VSS.n7838 VSS.n7837 9.3005
R9939 VSS.n7835 VSS.n2467 9.3005
R9940 VSS.n7834 VSS.n7833 9.3005
R9941 VSS.n7832 VSS.n7831 9.3005
R9942 VSS.n2469 VSS.n2468 9.3005
R9943 VSS.n7829 VSS.n7828 9.3005
R9944 VSS.n7827 VSS.n2470 9.3005
R9945 VSS.n7826 VSS.n7825 9.3005
R9946 VSS.n7817 VSS.n2472 9.3005
R9947 VSS.n7813 VSS.n2474 9.3005
R9948 VSS.n7815 VSS.n7814 9.3005
R9949 VSS.n7812 VSS.n7811 9.3005
R9950 VSS.n2478 VSS.n2477 9.3005
R9951 VSS.n7805 VSS.n7804 9.3005
R9952 VSS.n7803 VSS.n2479 9.3005
R9953 VSS.n7802 VSS.n7801 9.3005
R9954 VSS.n7800 VSS.n2480 9.3005
R9955 VSS.t3812 VSS.n7799 9.3005
R9956 VSS.n7798 VSS.n2481 9.3005
R9957 VSS.n7797 VSS.n7796 9.3005
R9958 VSS.n7792 VSS.n7791 9.3005
R9959 VSS.n2487 VSS.n2486 9.3005
R9960 VSS.n7785 VSS.n7784 9.3005
R9961 VSS.n7783 VSS.n7782 9.3005
R9962 VSS.n7781 VSS.n2490 9.3005
R9963 VSS.n7780 VSS.n7779 9.3005
R9964 VSS.n7777 VSS.n7776 9.3005
R9965 VSS.n2496 VSS.n2492 9.3005
R9966 VSS.n7769 VSS.n7768 9.3005
R9967 VSS.n7767 VSS.n2498 9.3005
R9968 VSS.n7766 VSS.n7765 9.3005
R9969 VSS.n7760 VSS.n2499 9.3005
R9970 VSS.n7759 VSS.n7758 9.3005
R9971 VSS.n7757 VSS.n7756 9.3005
R9972 VSS.n7755 VSS.n2500 9.3005
R9973 VSS.t3773 VSS.n7754 9.3005
R9974 VSS.n7753 VSS.n2501 9.3005
R9975 VSS.n7752 VSS.n7751 9.3005
R9976 VSS.n2503 VSS.n2502 9.3005
R9977 VSS.n7744 VSS.n2504 9.3005
R9978 VSS.n7746 VSS.n7745 9.3005
R9979 VSS.n7743 VSS.n2506 9.3005
R9980 VSS.n7742 VSS.n7741 9.3005
R9981 VSS.n7736 VSS.n2507 9.3005
R9982 VSS.n7735 VSS.n7734 9.3005
R9983 VSS.n7733 VSS.n2508 9.3005
R9984 VSS.n7732 VSS.n7731 9.3005
R9985 VSS.n7729 VSS.n2509 9.3005
R9986 VSS.n7728 VSS.n7727 9.3005
R9987 VSS.n7726 VSS.n7725 9.3005
R9988 VSS.n2511 VSS.n2510 9.3005
R9989 VSS.n7723 VSS.n7722 9.3005
R9990 VSS.n7721 VSS.n2512 9.3005
R9991 VSS.n7720 VSS.n7719 9.3005
R9992 VSS.n7711 VSS.n2514 9.3005
R9993 VSS.n7707 VSS.n2516 9.3005
R9994 VSS.n7709 VSS.n7708 9.3005
R9995 VSS.n7706 VSS.n7705 9.3005
R9996 VSS.n2520 VSS.n2519 9.3005
R9997 VSS.n7699 VSS.n7698 9.3005
R9998 VSS.n7697 VSS.n2521 9.3005
R9999 VSS.n7696 VSS.n7695 9.3005
R10000 VSS.n7694 VSS.n2522 9.3005
R10001 VSS.t3807 VSS.n7693 9.3005
R10002 VSS.n7692 VSS.n2523 9.3005
R10003 VSS.n7691 VSS.n7690 9.3005
R10004 VSS.n7686 VSS.n7685 9.3005
R10005 VSS.n2529 VSS.n2528 9.3005
R10006 VSS.n7679 VSS.n7678 9.3005
R10007 VSS.n7677 VSS.n7676 9.3005
R10008 VSS.n7675 VSS.n2532 9.3005
R10009 VSS.n7674 VSS.n7673 9.3005
R10010 VSS.n92 VSS.n230 2.25403
R10011 VSS.n14 VSS.n92 0.192834
R10012 VSS.n14 VSS.n7671 9.3005
R10013 VSS.n14 VSS.n79 4.07296
R10014 VSS.n14 VSS.n62 9.3005
R10015 VSS.n14 VSS.n7664 9.3005
R10016 VSS.n48 VSS.n14 3.96704
R10017 VSS.n14 VSS.n7659 9.3005
R10018 VSS.n7658 VSS.n13 9.3005
R10019 VSS.t3768 VSS.n7657 9.3005
R10020 VSS.n7656 VSS.n7591 9.3005
R10021 VSS.n7655 VSS.n7654 9.3005
R10022 VSS.n7593 VSS.n7592 9.3005
R10023 VSS.n7647 VSS.n7594 9.3005
R10024 VSS.n7649 VSS.n7648 9.3005
R10025 VSS.n7646 VSS.n7607 9.3005
R10026 VSS.n7645 VSS.n7644 9.3005
R10027 VSS.n7639 VSS.n7608 9.3005
R10028 VSS.n7633 VSS.n7610 9.3005
R10029 VSS.n7635 VSS.n7634 9.3005
R10030 VSS.n7632 VSS.n7631 9.3005
R10031 VSS.n7627 VSS.n7613 9.3005
R10032 VSS.n7626 VSS.n7625 9.3005
R10033 VSS.n7624 VSS.n7623 9.3005
R10034 VSS.n7622 VSS.n7614 9.3005
R10035 VSS.t3803 VSS.n7621 9.3005
R10036 VSS.n7620 VSS.n7615 9.3005
R10037 VSS.n7619 VSS.n7618 9.3005
R10038 VSS.n7617 VSS.n7616 9.3005
R10039 VSS.n9347 VSS.n9342 9.3005
R10040 VSS.n9349 VSS.n9348 9.3005
R10041 VSS.n9351 VSS.n9350 9.3005
R10042 VSS.n9341 VSS.n9337 9.3005
R10043 VSS.n9356 VSS.n9335 9.3005
R10044 VSS.n9358 VSS.n9357 9.3005
R10045 VSS.n9359 VSS.n9334 9.3005
R10046 VSS.n9361 VSS.n9360 9.3005
R10047 VSS.n9362 VSS.n9333 9.3005
R10048 VSS.n9364 VSS.n9363 9.3005
R10049 VSS.n9365 VSS.n9332 9.3005
R10050 VSS.n9367 VSS.n9366 9.3005
R10051 VSS.n9370 VSS.n9329 9.3005
R10052 VSS.n9372 VSS.n9371 9.3005
R10053 VSS.n9374 VSS.n9373 9.3005
R10054 VSS.n9328 VSS.n9324 9.3005
R10055 VSS.n9379 VSS.n9322 9.3005
R10056 VSS.n9381 VSS.n9380 9.3005
R10057 VSS.n9382 VSS.n9321 9.3005
R10058 VSS.n9384 VSS.n9383 9.3005
R10059 VSS.n9385 VSS.n9320 9.3005
R10060 VSS.n9387 VSS.n9386 9.3005
R10061 VSS.n9389 VSS.n9388 9.3005
R10062 VSS.n9394 VSS.n8367 9.3005
R10063 VSS.n9396 VSS.n9395 9.3005
R10064 VSS.n9397 VSS.n8366 9.3005
R10065 VSS.n9399 VSS.n9398 9.3005
R10066 VSS.n179 VSS.n180 0.138245
R10067 VSS.n9402 VSS.n180 3.04638
R10068 VSS.n9402 VSS.n205 9.3005
R10069 VSS.n8380 VSS.n8379 9.3005
R10070 VSS.n8381 VSS.n8376 9.3005
R10071 VSS.n8383 VSS.n8382 9.3005
R10072 VSS.n8384 VSS.n8375 9.3005
R10073 VSS.n8388 VSS.n8387 9.3005
R10074 VSS.n9312 VSS.n8372 9.3005
R10075 VSS.n9314 VSS.n9313 9.3005
R10076 VSS.n9316 VSS.n9315 9.3005
R10077 VSS.n8389 VSS.n8371 9.3005
R10078 VSS.n9302 VSS.n147 9.3005
R10079 VSS.n9304 VSS.n9303 9.3005
R10080 VSS.n9301 VSS.n8390 9.3005
R10081 VSS.n9300 VSS.n9299 9.3005
R10082 VSS.n9297 VSS.n8391 9.3005
R10083 VSS.n9296 VSS.n9295 9.3005
R10084 VSS.n9294 VSS.n9293 9.3005
R10085 VSS.n8393 VSS.n8392 9.3005
R10086 VSS.n9291 VSS.n9290 9.3005
R10087 VSS.n9289 VSS.n8394 9.3005
R10088 VSS.n9288 VSS.n9287 9.3005
R10089 VSS.n9279 VSS.n8396 9.3005
R10090 VSS.n9275 VSS.n8398 9.3005
R10091 VSS.n9277 VSS.n9276 9.3005
R10092 VSS.n9274 VSS.n9273 9.3005
R10093 VSS.n8402 VSS.n8401 9.3005
R10094 VSS.n9267 VSS.n9266 9.3005
R10095 VSS.n9265 VSS.n8403 9.3005
R10096 VSS.n9264 VSS.n9263 9.3005
R10097 VSS.n9262 VSS.n8404 9.3005
R10098 VSS.t3902 VSS.n9261 9.3005
R10099 VSS.n9260 VSS.n8405 9.3005
R10100 VSS.n9259 VSS.n9258 9.3005
R10101 VSS.n9254 VSS.n9253 9.3005
R10102 VSS.n8411 VSS.n8410 9.3005
R10103 VSS.n9247 VSS.n9246 9.3005
R10104 VSS.n9245 VSS.n9244 9.3005
R10105 VSS.n9243 VSS.n8414 9.3005
R10106 VSS.n9242 VSS.n9241 9.3005
R10107 VSS.n9239 VSS.n9238 9.3005
R10108 VSS.n8420 VSS.n8416 9.3005
R10109 VSS.n9231 VSS.n9230 9.3005
R10110 VSS.n9229 VSS.n8422 9.3005
R10111 VSS.n9228 VSS.n9227 9.3005
R10112 VSS.n9222 VSS.n8423 9.3005
R10113 VSS.n9221 VSS.n9220 9.3005
R10114 VSS.n9219 VSS.n9218 9.3005
R10115 VSS.n9217 VSS.n8424 9.3005
R10116 VSS.t3863 VSS.n9216 9.3005
R10117 VSS.n9215 VSS.n8425 9.3005
R10118 VSS.n9214 VSS.n9213 9.3005
R10119 VSS.n8427 VSS.n8426 9.3005
R10120 VSS.n9206 VSS.n8428 9.3005
R10121 VSS.n9208 VSS.n9207 9.3005
R10122 VSS.n9205 VSS.n8430 9.3005
R10123 VSS.n9204 VSS.n9203 9.3005
R10124 VSS.n9198 VSS.n8431 9.3005
R10125 VSS.n9197 VSS.n9196 9.3005
R10126 VSS.n9195 VSS.n8432 9.3005
R10127 VSS.n9194 VSS.n9193 9.3005
R10128 VSS.n9191 VSS.n8433 9.3005
R10129 VSS.n9190 VSS.n9189 9.3005
R10130 VSS.n9188 VSS.n9187 9.3005
R10131 VSS.n8435 VSS.n8434 9.3005
R10132 VSS.n9185 VSS.n9184 9.3005
R10133 VSS.n9183 VSS.n8436 9.3005
R10134 VSS.n9182 VSS.n9181 9.3005
R10135 VSS.n9173 VSS.n8438 9.3005
R10136 VSS.n9169 VSS.n8440 9.3005
R10137 VSS.n9171 VSS.n9170 9.3005
R10138 VSS.n9168 VSS.n9167 9.3005
R10139 VSS.n8444 VSS.n8443 9.3005
R10140 VSS.n9161 VSS.n9160 9.3005
R10141 VSS.n9159 VSS.n8445 9.3005
R10142 VSS.n9158 VSS.n9157 9.3005
R10143 VSS.n9156 VSS.n8446 9.3005
R10144 VSS.t3897 VSS.n9155 9.3005
R10145 VSS.n9154 VSS.n8447 9.3005
R10146 VSS.n9153 VSS.n9152 9.3005
R10147 VSS.n9148 VSS.n9147 9.3005
R10148 VSS.n8453 VSS.n8452 9.3005
R10149 VSS.n9141 VSS.n9140 9.3005
R10150 VSS.n9139 VSS.n9138 9.3005
R10151 VSS.n9137 VSS.n8456 9.3005
R10152 VSS.n9136 VSS.n9135 9.3005
R10153 VSS.n9133 VSS.n9132 9.3005
R10154 VSS.n8462 VSS.n8458 9.3005
R10155 VSS.n9125 VSS.n9124 9.3005
R10156 VSS.n9123 VSS.n8464 9.3005
R10157 VSS.n9122 VSS.n9121 9.3005
R10158 VSS.n9116 VSS.n8465 9.3005
R10159 VSS.n9115 VSS.n9114 9.3005
R10160 VSS.n9113 VSS.n9112 9.3005
R10161 VSS.n9111 VSS.n8466 9.3005
R10162 VSS.t3858 VSS.n9110 9.3005
R10163 VSS.n9109 VSS.n8467 9.3005
R10164 VSS.n9108 VSS.n9107 9.3005
R10165 VSS.n8469 VSS.n8468 9.3005
R10166 VSS.n9100 VSS.n8470 9.3005
R10167 VSS.n9102 VSS.n9101 9.3005
R10168 VSS.n9099 VSS.n8472 9.3005
R10169 VSS.n9098 VSS.n9097 9.3005
R10170 VSS.n9092 VSS.n8473 9.3005
R10171 VSS.n9091 VSS.n9090 9.3005
R10172 VSS.n9089 VSS.n8474 9.3005
R10173 VSS.n9088 VSS.n9087 9.3005
R10174 VSS.n9085 VSS.n8475 9.3005
R10175 VSS.n9084 VSS.n9083 9.3005
R10176 VSS.n9082 VSS.n9081 9.3005
R10177 VSS.n8477 VSS.n8476 9.3005
R10178 VSS.n9079 VSS.n9078 9.3005
R10179 VSS.n9077 VSS.n8478 9.3005
R10180 VSS.n9076 VSS.n9075 9.3005
R10181 VSS.n9067 VSS.n8480 9.3005
R10182 VSS.n9063 VSS.n8482 9.3005
R10183 VSS.n9065 VSS.n9064 9.3005
R10184 VSS.n9062 VSS.n9061 9.3005
R10185 VSS.n8486 VSS.n8485 9.3005
R10186 VSS.n9055 VSS.n9054 9.3005
R10187 VSS.n9053 VSS.n8487 9.3005
R10188 VSS.n9052 VSS.n9051 9.3005
R10189 VSS.n9050 VSS.n8488 9.3005
R10190 VSS.t3892 VSS.n9049 9.3005
R10191 VSS.n9048 VSS.n8489 9.3005
R10192 VSS.n9047 VSS.n9046 9.3005
R10193 VSS.n9042 VSS.n9041 9.3005
R10194 VSS.n8495 VSS.n8494 9.3005
R10195 VSS.n9035 VSS.n9034 9.3005
R10196 VSS.n9033 VSS.n9032 9.3005
R10197 VSS.n9031 VSS.n8498 9.3005
R10198 VSS.n9030 VSS.n9029 9.3005
R10199 VSS.n9027 VSS.n9026 9.3005
R10200 VSS.n8504 VSS.n8500 9.3005
R10201 VSS.n9019 VSS.n9018 9.3005
R10202 VSS.n9017 VSS.n8506 9.3005
R10203 VSS.n9016 VSS.n9015 9.3005
R10204 VSS.n9010 VSS.n8507 9.3005
R10205 VSS.n9009 VSS.n9008 9.3005
R10206 VSS.n9007 VSS.n9006 9.3005
R10207 VSS.n9005 VSS.n8508 9.3005
R10208 VSS.t3853 VSS.n9004 9.3005
R10209 VSS.n9003 VSS.n8509 9.3005
R10210 VSS.n9002 VSS.n9001 9.3005
R10211 VSS.n8511 VSS.n8510 9.3005
R10212 VSS.n8994 VSS.n8512 9.3005
R10213 VSS.n8996 VSS.n8995 9.3005
R10214 VSS.n8993 VSS.n8514 9.3005
R10215 VSS.n8992 VSS.n8991 9.3005
R10216 VSS.n8986 VSS.n8515 9.3005
R10217 VSS.n8985 VSS.n8984 9.3005
R10218 VSS.n8983 VSS.n8516 9.3005
R10219 VSS.n8982 VSS.n8981 9.3005
R10220 VSS.n8979 VSS.n8517 9.3005
R10221 VSS.n8978 VSS.n8977 9.3005
R10222 VSS.n8976 VSS.n8975 9.3005
R10223 VSS.n8519 VSS.n8518 9.3005
R10224 VSS.n8973 VSS.n8972 9.3005
R10225 VSS.n8971 VSS.n8520 9.3005
R10226 VSS.n8970 VSS.n8969 9.3005
R10227 VSS.n8961 VSS.n8522 9.3005
R10228 VSS.n8957 VSS.n8524 9.3005
R10229 VSS.n8959 VSS.n8958 9.3005
R10230 VSS.n8956 VSS.n8955 9.3005
R10231 VSS.n8528 VSS.n8527 9.3005
R10232 VSS.n8949 VSS.n8948 9.3005
R10233 VSS.n8947 VSS.n8529 9.3005
R10234 VSS.n8946 VSS.n8945 9.3005
R10235 VSS.n8944 VSS.n8530 9.3005
R10236 VSS.t3887 VSS.n8943 9.3005
R10237 VSS.n8942 VSS.n8531 9.3005
R10238 VSS.n8941 VSS.n8940 9.3005
R10239 VSS.n8936 VSS.n8935 9.3005
R10240 VSS.n8537 VSS.n8536 9.3005
R10241 VSS.n8929 VSS.n8928 9.3005
R10242 VSS.n8927 VSS.n8926 9.3005
R10243 VSS.n8925 VSS.n8540 9.3005
R10244 VSS.n8924 VSS.n8923 9.3005
R10245 VSS.n8921 VSS.n8920 9.3005
R10246 VSS.n8546 VSS.n8542 9.3005
R10247 VSS.n8913 VSS.n8912 9.3005
R10248 VSS.n8911 VSS.n8548 9.3005
R10249 VSS.n8910 VSS.n8909 9.3005
R10250 VSS.n8904 VSS.n8549 9.3005
R10251 VSS.n8903 VSS.n8902 9.3005
R10252 VSS.n8901 VSS.n8900 9.3005
R10253 VSS.n8899 VSS.n8550 9.3005
R10254 VSS.t3848 VSS.n8898 9.3005
R10255 VSS.n8897 VSS.n8551 9.3005
R10256 VSS.n8896 VSS.n8895 9.3005
R10257 VSS.n8553 VSS.n8552 9.3005
R10258 VSS.n8888 VSS.n8554 9.3005
R10259 VSS.n8890 VSS.n8889 9.3005
R10260 VSS.n8887 VSS.n8556 9.3005
R10261 VSS.n8886 VSS.n8885 9.3005
R10262 VSS.n8880 VSS.n8557 9.3005
R10263 VSS.n8879 VSS.n8878 9.3005
R10264 VSS.n8877 VSS.n8558 9.3005
R10265 VSS.n8876 VSS.n8875 9.3005
R10266 VSS.n8873 VSS.n8559 9.3005
R10267 VSS.n8872 VSS.n8871 9.3005
R10268 VSS.n8870 VSS.n8869 9.3005
R10269 VSS.n8561 VSS.n8560 9.3005
R10270 VSS.n8867 VSS.n8866 9.3005
R10271 VSS.n8865 VSS.n8562 9.3005
R10272 VSS.n8864 VSS.n8863 9.3005
R10273 VSS.n8855 VSS.n8564 9.3005
R10274 VSS.n8851 VSS.n8566 9.3005
R10275 VSS.n8853 VSS.n8852 9.3005
R10276 VSS.n8850 VSS.n8849 9.3005
R10277 VSS.n8570 VSS.n8569 9.3005
R10278 VSS.n8843 VSS.n8842 9.3005
R10279 VSS.n8841 VSS.n8571 9.3005
R10280 VSS.n8840 VSS.n8839 9.3005
R10281 VSS.n8838 VSS.n8572 9.3005
R10282 VSS.t3882 VSS.n8837 9.3005
R10283 VSS.n8836 VSS.n8573 9.3005
R10284 VSS.n8835 VSS.n8834 9.3005
R10285 VSS.n8830 VSS.n8829 9.3005
R10286 VSS.n8579 VSS.n8578 9.3005
R10287 VSS.n8823 VSS.n8822 9.3005
R10288 VSS.n8821 VSS.n8820 9.3005
R10289 VSS.n8819 VSS.n8582 9.3005
R10290 VSS.n8818 VSS.n8817 9.3005
R10291 VSS.n8815 VSS.n8814 9.3005
R10292 VSS.n8588 VSS.n8584 9.3005
R10293 VSS.n8807 VSS.n8806 9.3005
R10294 VSS.n8805 VSS.n8590 9.3005
R10295 VSS.n8804 VSS.n8803 9.3005
R10296 VSS.n8798 VSS.n8591 9.3005
R10297 VSS.n8797 VSS.n8796 9.3005
R10298 VSS.n8795 VSS.n8794 9.3005
R10299 VSS.n8793 VSS.n8592 9.3005
R10300 VSS.t3843 VSS.n8792 9.3005
R10301 VSS.n8791 VSS.n8593 9.3005
R10302 VSS.n8790 VSS.n8789 9.3005
R10303 VSS.n8595 VSS.n8594 9.3005
R10304 VSS.n8782 VSS.n8596 9.3005
R10305 VSS.n8784 VSS.n8783 9.3005
R10306 VSS.n8781 VSS.n8598 9.3005
R10307 VSS.n8780 VSS.n8779 9.3005
R10308 VSS.n8774 VSS.n8599 9.3005
R10309 VSS.n8773 VSS.n8772 9.3005
R10310 VSS.n8771 VSS.n8600 9.3005
R10311 VSS.n8770 VSS.n8769 9.3005
R10312 VSS.n8767 VSS.n8601 9.3005
R10313 VSS.n8766 VSS.n8765 9.3005
R10314 VSS.n8764 VSS.n8763 9.3005
R10315 VSS.n8603 VSS.n8602 9.3005
R10316 VSS.n8761 VSS.n8760 9.3005
R10317 VSS.n8759 VSS.n8604 9.3005
R10318 VSS.n8758 VSS.n8757 9.3005
R10319 VSS.n8749 VSS.n8606 9.3005
R10320 VSS.n8745 VSS.n8608 9.3005
R10321 VSS.n8747 VSS.n8746 9.3005
R10322 VSS.n8744 VSS.n8743 9.3005
R10323 VSS.n8612 VSS.n8611 9.3005
R10324 VSS.n8737 VSS.n8736 9.3005
R10325 VSS.n8735 VSS.n8613 9.3005
R10326 VSS.n8734 VSS.n8733 9.3005
R10327 VSS.n8732 VSS.n8614 9.3005
R10328 VSS.t3877 VSS.n8731 9.3005
R10329 VSS.n8730 VSS.n8615 9.3005
R10330 VSS.n8729 VSS.n8728 9.3005
R10331 VSS.n8724 VSS.n8723 9.3005
R10332 VSS.n8621 VSS.n8620 9.3005
R10333 VSS.n8717 VSS.n8716 9.3005
R10334 VSS.n8715 VSS.n8714 9.3005
R10335 VSS.n8713 VSS.n8624 9.3005
R10336 VSS.n8712 VSS.n8711 9.3005
R10337 VSS.n93 VSS.n231 2.25403
R10338 VSS.n16 VSS.n93 0.192834
R10339 VSS.n8630 VSS.n16 9.3005
R10340 VSS.n16 VSS.n78 4.07296
R10341 VSS.n8707 VSS.n16 9.3005
R10342 VSS.n16 VSS.n8706 9.3005
R10343 VSS.n47 VSS.n16 3.96704
R10344 VSS.n16 VSS.n8702 9.3005
R10345 VSS.n8701 VSS.n15 9.3005
R10346 VSS.t3838 VSS.n8700 9.3005
R10347 VSS.n8699 VSS.n8634 9.3005
R10348 VSS.n8698 VSS.n8697 9.3005
R10349 VSS.n8636 VSS.n8635 9.3005
R10350 VSS.n8690 VSS.n8637 9.3005
R10351 VSS.n8692 VSS.n8691 9.3005
R10352 VSS.n8689 VSS.n8650 9.3005
R10353 VSS.n8688 VSS.n8687 9.3005
R10354 VSS.n8682 VSS.n8651 9.3005
R10355 VSS.n8676 VSS.n8653 9.3005
R10356 VSS.n8678 VSS.n8677 9.3005
R10357 VSS.n8675 VSS.n8674 9.3005
R10358 VSS.n8670 VSS.n8656 9.3005
R10359 VSS.n8669 VSS.n8668 9.3005
R10360 VSS.n8667 VSS.n8666 9.3005
R10361 VSS.n8665 VSS.n8657 9.3005
R10362 VSS.t3873 VSS.n8664 9.3005
R10363 VSS.n8663 VSS.n8658 9.3005
R10364 VSS.n8662 VSS.n8661 9.3005
R10365 VSS.n8660 VSS.n8659 9.3005
R10366 VSS.n2226 VSS.n2225 9.3005
R10367 VSS.n2228 VSS.n2227 9.3005
R10368 VSS.t3401 VSS.n128 9.3005
R10369 VSS.n2238 VSS.n2237 9.3005
R10370 VSS.n2220 VSS.n2219 9.3005
R10371 VSS.n2245 VSS.n2244 9.3005
R10372 VSS.n2247 VSS.n2246 9.3005
R10373 VSS.n2248 VSS.n2217 9.3005
R10374 VSS.n2250 VSS.n2249 9.3005
R10375 VSS.n2215 VSS.n2214 9.3005
R10376 VSS.n2255 VSS.n2213 9.3005
R10377 VSS.n2257 VSS.n2256 9.3005
R10378 VSS.n2258 VSS.n2212 9.3005
R10379 VSS.n2260 VSS.n2259 9.3005
R10380 VSS.n2261 VSS.n2210 9.3005
R10381 VSS.n2268 VSS.n2267 9.3005
R10382 VSS.n2269 VSS.n2208 9.3005
R10383 VSS.n2271 VSS.n2270 9.3005
R10384 VSS.n2272 VSS.n2207 9.3005
R10385 VSS.n178 VSS.n177 0.138245
R10386 VSS.n9405 VSS.n178 3.04638
R10387 VSS.n9405 VSS.n207 9.3005
R10388 VSS.n9408 VSS.n9407 9.3005
R10389 VSS.n9409 VSS.n2206 9.3005
R10390 VSS.n9411 VSS.n9410 9.3005
R10391 VSS.n9412 VSS.n2205 9.3005
R10392 VSS.n9416 VSS.n9415 9.3005
R10393 VSS.n2204 VSS.n2201 9.3005
R10394 VSS.n2197 VSS.n2195 9.3005
R10395 VSS.n9421 VSS.n9420 9.3005
R10396 VSS.n9423 VSS.n9422 9.3005
R10397 VSS.n2194 VSS.n2191 9.3005
R10398 VSS.n9425 VSS.n2189 9.3005
R10399 VSS.n9427 VSS.n9426 9.3005
R10400 VSS.n9428 VSS.n2188 9.3005
R10401 VSS.n9430 VSS.n9429 9.3005
R10402 VSS.n9431 VSS.n2187 9.3005
R10403 VSS.n9433 VSS.n9432 9.3005
R10404 VSS.n9435 VSS.n9434 9.3005
R10405 VSS.n9438 VSS.n2185 9.3005
R10406 VSS.n9440 VSS.n9439 9.3005
R10407 VSS.n9442 VSS.n9441 9.3005
R10408 VSS.n2183 VSS.n2180 9.3005
R10409 VSS.n9448 VSS.n9447 9.3005
R10410 VSS.n9450 VSS.n9449 9.3005
R10411 VSS.n2177 VSS.n2175 9.3005
R10412 VSS.n9457 VSS.n9456 9.3005
R10413 VSS.n9458 VSS.n2174 9.3005
R10414 VSS.n9460 VSS.n9459 9.3005
R10415 VSS.n9461 VSS.n2173 9.3005
R10416 VSS.n9463 VSS.n9462 9.3005
R10417 VSS.n9464 VSS.t3972 9.3005
R10418 VSS.n9466 VSS.n9465 9.3005
R10419 VSS.n9467 VSS.n2172 9.3005
R10420 VSS.n9475 VSS.n9474 9.3005
R10421 VSS.n9477 VSS.n9476 9.3005
R10422 VSS.n2168 VSS.n2165 9.3005
R10423 VSS.n9482 VSS.n2164 9.3005
R10424 VSS.n9484 VSS.n9483 9.3005
R10425 VSS.n9486 VSS.n9485 9.3005
R10426 VSS.n9495 VSS.n9494 9.3005
R10427 VSS.n9496 VSS.n2162 9.3005
R10428 VSS.n9498 VSS.n9497 9.3005
R10429 VSS.n2159 VSS.n2157 9.3005
R10430 VSS.n9505 VSS.n9504 9.3005
R10431 VSS.n9506 VSS.n2156 9.3005
R10432 VSS.n9508 VSS.n9507 9.3005
R10433 VSS.n9509 VSS.n2155 9.3005
R10434 VSS.n9511 VSS.n9510 9.3005
R10435 VSS.t3933 VSS.n9512 9.3005
R10436 VSS.n9513 VSS.n2154 9.3005
R10437 VSS.n9515 VSS.n9514 9.3005
R10438 VSS.n9517 VSS.n9516 9.3005
R10439 VSS.n2153 VSS.n2151 9.3005
R10440 VSS.n2147 VSS.n2145 9.3005
R10441 VSS.n9522 VSS.n9521 9.3005
R10442 VSS.n9524 VSS.n9523 9.3005
R10443 VSS.n2144 VSS.n2141 9.3005
R10444 VSS.n9526 VSS.n2139 9.3005
R10445 VSS.n9528 VSS.n9527 9.3005
R10446 VSS.n9529 VSS.n2138 9.3005
R10447 VSS.n9531 VSS.n9530 9.3005
R10448 VSS.n9532 VSS.n2137 9.3005
R10449 VSS.n9534 VSS.n9533 9.3005
R10450 VSS.n9536 VSS.n9535 9.3005
R10451 VSS.n9539 VSS.n2135 9.3005
R10452 VSS.n9541 VSS.n9540 9.3005
R10453 VSS.n9543 VSS.n9542 9.3005
R10454 VSS.n2133 VSS.n2130 9.3005
R10455 VSS.n9549 VSS.n9548 9.3005
R10456 VSS.n9551 VSS.n9550 9.3005
R10457 VSS.n2127 VSS.n2125 9.3005
R10458 VSS.n9558 VSS.n9557 9.3005
R10459 VSS.n9559 VSS.n2124 9.3005
R10460 VSS.n9561 VSS.n9560 9.3005
R10461 VSS.n9562 VSS.n2123 9.3005
R10462 VSS.n9564 VSS.n9563 9.3005
R10463 VSS.n9565 VSS.t3967 9.3005
R10464 VSS.n9567 VSS.n9566 9.3005
R10465 VSS.n9568 VSS.n2122 9.3005
R10466 VSS.n9576 VSS.n9575 9.3005
R10467 VSS.n9578 VSS.n9577 9.3005
R10468 VSS.n2118 VSS.n2115 9.3005
R10469 VSS.n9583 VSS.n2114 9.3005
R10470 VSS.n9585 VSS.n9584 9.3005
R10471 VSS.n9587 VSS.n9586 9.3005
R10472 VSS.n9596 VSS.n9595 9.3005
R10473 VSS.n9597 VSS.n2112 9.3005
R10474 VSS.n9599 VSS.n9598 9.3005
R10475 VSS.n2109 VSS.n2107 9.3005
R10476 VSS.n9606 VSS.n9605 9.3005
R10477 VSS.n9607 VSS.n2106 9.3005
R10478 VSS.n9609 VSS.n9608 9.3005
R10479 VSS.n9610 VSS.n2105 9.3005
R10480 VSS.n9612 VSS.n9611 9.3005
R10481 VSS.t3928 VSS.n9613 9.3005
R10482 VSS.n9614 VSS.n2104 9.3005
R10483 VSS.n9616 VSS.n9615 9.3005
R10484 VSS.n9618 VSS.n9617 9.3005
R10485 VSS.n2103 VSS.n2101 9.3005
R10486 VSS.n2097 VSS.n2095 9.3005
R10487 VSS.n9623 VSS.n9622 9.3005
R10488 VSS.n9625 VSS.n9624 9.3005
R10489 VSS.n2094 VSS.n2091 9.3005
R10490 VSS.n9627 VSS.n2089 9.3005
R10491 VSS.n9629 VSS.n9628 9.3005
R10492 VSS.n9630 VSS.n2088 9.3005
R10493 VSS.n9632 VSS.n9631 9.3005
R10494 VSS.n9633 VSS.n2087 9.3005
R10495 VSS.n9635 VSS.n9634 9.3005
R10496 VSS.n9637 VSS.n9636 9.3005
R10497 VSS.n9640 VSS.n2085 9.3005
R10498 VSS.n9642 VSS.n9641 9.3005
R10499 VSS.n9644 VSS.n9643 9.3005
R10500 VSS.n2083 VSS.n2080 9.3005
R10501 VSS.n9650 VSS.n9649 9.3005
R10502 VSS.n9652 VSS.n9651 9.3005
R10503 VSS.n2077 VSS.n2075 9.3005
R10504 VSS.n9659 VSS.n9658 9.3005
R10505 VSS.n9660 VSS.n2074 9.3005
R10506 VSS.n9662 VSS.n9661 9.3005
R10507 VSS.n9663 VSS.n2073 9.3005
R10508 VSS.n9665 VSS.n9664 9.3005
R10509 VSS.n9666 VSS.t3962 9.3005
R10510 VSS.n9668 VSS.n9667 9.3005
R10511 VSS.n9669 VSS.n2072 9.3005
R10512 VSS.n9677 VSS.n9676 9.3005
R10513 VSS.n9679 VSS.n9678 9.3005
R10514 VSS.n2068 VSS.n2065 9.3005
R10515 VSS.n9684 VSS.n2064 9.3005
R10516 VSS.n9686 VSS.n9685 9.3005
R10517 VSS.n9688 VSS.n9687 9.3005
R10518 VSS.n9697 VSS.n9696 9.3005
R10519 VSS.n9698 VSS.n2062 9.3005
R10520 VSS.n9700 VSS.n9699 9.3005
R10521 VSS.n2059 VSS.n2057 9.3005
R10522 VSS.n9707 VSS.n9706 9.3005
R10523 VSS.n9708 VSS.n2056 9.3005
R10524 VSS.n9710 VSS.n9709 9.3005
R10525 VSS.n9711 VSS.n2055 9.3005
R10526 VSS.n9713 VSS.n9712 9.3005
R10527 VSS.t3923 VSS.n9714 9.3005
R10528 VSS.n9715 VSS.n2054 9.3005
R10529 VSS.n9717 VSS.n9716 9.3005
R10530 VSS.n9719 VSS.n9718 9.3005
R10531 VSS.n2053 VSS.n2051 9.3005
R10532 VSS.n2047 VSS.n2045 9.3005
R10533 VSS.n9724 VSS.n9723 9.3005
R10534 VSS.n9726 VSS.n9725 9.3005
R10535 VSS.n2044 VSS.n2041 9.3005
R10536 VSS.n9728 VSS.n2039 9.3005
R10537 VSS.n9730 VSS.n9729 9.3005
R10538 VSS.n9731 VSS.n2038 9.3005
R10539 VSS.n9733 VSS.n9732 9.3005
R10540 VSS.n9734 VSS.n2037 9.3005
R10541 VSS.n9736 VSS.n9735 9.3005
R10542 VSS.n9738 VSS.n9737 9.3005
R10543 VSS.n9741 VSS.n2035 9.3005
R10544 VSS.n9743 VSS.n9742 9.3005
R10545 VSS.n9745 VSS.n9744 9.3005
R10546 VSS.n2033 VSS.n2030 9.3005
R10547 VSS.n9751 VSS.n9750 9.3005
R10548 VSS.n9753 VSS.n9752 9.3005
R10549 VSS.n2027 VSS.n2025 9.3005
R10550 VSS.n9760 VSS.n9759 9.3005
R10551 VSS.n9761 VSS.n2024 9.3005
R10552 VSS.n9763 VSS.n9762 9.3005
R10553 VSS.n9764 VSS.n2023 9.3005
R10554 VSS.n9766 VSS.n9765 9.3005
R10555 VSS.n9767 VSS.t3957 9.3005
R10556 VSS.n9769 VSS.n9768 9.3005
R10557 VSS.n9770 VSS.n2022 9.3005
R10558 VSS.n9778 VSS.n9777 9.3005
R10559 VSS.n9780 VSS.n9779 9.3005
R10560 VSS.n2018 VSS.n2015 9.3005
R10561 VSS.n9785 VSS.n2014 9.3005
R10562 VSS.n9787 VSS.n9786 9.3005
R10563 VSS.n9789 VSS.n9788 9.3005
R10564 VSS.n9798 VSS.n9797 9.3005
R10565 VSS.n9799 VSS.n2012 9.3005
R10566 VSS.n9801 VSS.n9800 9.3005
R10567 VSS.n2009 VSS.n2007 9.3005
R10568 VSS.n9808 VSS.n9807 9.3005
R10569 VSS.n9809 VSS.n2006 9.3005
R10570 VSS.n9811 VSS.n9810 9.3005
R10571 VSS.n9812 VSS.n2005 9.3005
R10572 VSS.n9814 VSS.n9813 9.3005
R10573 VSS.t3918 VSS.n9815 9.3005
R10574 VSS.n9816 VSS.n2004 9.3005
R10575 VSS.n9818 VSS.n9817 9.3005
R10576 VSS.n9820 VSS.n9819 9.3005
R10577 VSS.n2003 VSS.n2001 9.3005
R10578 VSS.n1997 VSS.n1995 9.3005
R10579 VSS.n9825 VSS.n9824 9.3005
R10580 VSS.n9827 VSS.n9826 9.3005
R10581 VSS.n1994 VSS.n1991 9.3005
R10582 VSS.n9829 VSS.n1989 9.3005
R10583 VSS.n9831 VSS.n9830 9.3005
R10584 VSS.n9832 VSS.n1988 9.3005
R10585 VSS.n9834 VSS.n9833 9.3005
R10586 VSS.n9835 VSS.n1987 9.3005
R10587 VSS.n9837 VSS.n9836 9.3005
R10588 VSS.n9839 VSS.n9838 9.3005
R10589 VSS.n9842 VSS.n1985 9.3005
R10590 VSS.n9844 VSS.n9843 9.3005
R10591 VSS.n9846 VSS.n9845 9.3005
R10592 VSS.n1983 VSS.n1980 9.3005
R10593 VSS.n9852 VSS.n9851 9.3005
R10594 VSS.n9854 VSS.n9853 9.3005
R10595 VSS.n1977 VSS.n1975 9.3005
R10596 VSS.n9861 VSS.n9860 9.3005
R10597 VSS.n9862 VSS.n1974 9.3005
R10598 VSS.n9864 VSS.n9863 9.3005
R10599 VSS.n9865 VSS.n1973 9.3005
R10600 VSS.n9867 VSS.n9866 9.3005
R10601 VSS.n9868 VSS.t3952 9.3005
R10602 VSS.n9870 VSS.n9869 9.3005
R10603 VSS.n9871 VSS.n1972 9.3005
R10604 VSS.n9879 VSS.n9878 9.3005
R10605 VSS.n9881 VSS.n9880 9.3005
R10606 VSS.n1968 VSS.n1965 9.3005
R10607 VSS.n9886 VSS.n1964 9.3005
R10608 VSS.n9888 VSS.n9887 9.3005
R10609 VSS.n9890 VSS.n9889 9.3005
R10610 VSS.n9899 VSS.n9898 9.3005
R10611 VSS.n9900 VSS.n1962 9.3005
R10612 VSS.n9902 VSS.n9901 9.3005
R10613 VSS.n1959 VSS.n1957 9.3005
R10614 VSS.n9909 VSS.n9908 9.3005
R10615 VSS.n9910 VSS.n1956 9.3005
R10616 VSS.n9912 VSS.n9911 9.3005
R10617 VSS.n9913 VSS.n1955 9.3005
R10618 VSS.n9915 VSS.n9914 9.3005
R10619 VSS.t3913 VSS.n9916 9.3005
R10620 VSS.n9917 VSS.n1954 9.3005
R10621 VSS.n9919 VSS.n9918 9.3005
R10622 VSS.n9921 VSS.n9920 9.3005
R10623 VSS.n1953 VSS.n1951 9.3005
R10624 VSS.n1947 VSS.n1945 9.3005
R10625 VSS.n9926 VSS.n9925 9.3005
R10626 VSS.n9928 VSS.n9927 9.3005
R10627 VSS.n1944 VSS.n1941 9.3005
R10628 VSS.n9930 VSS.n1939 9.3005
R10629 VSS.n9932 VSS.n9931 9.3005
R10630 VSS.n9933 VSS.n1938 9.3005
R10631 VSS.n9935 VSS.n9934 9.3005
R10632 VSS.n9936 VSS.n1937 9.3005
R10633 VSS.n9938 VSS.n9937 9.3005
R10634 VSS.n9940 VSS.n9939 9.3005
R10635 VSS.n9943 VSS.n1935 9.3005
R10636 VSS.n9945 VSS.n9944 9.3005
R10637 VSS.n9947 VSS.n9946 9.3005
R10638 VSS.n1933 VSS.n1930 9.3005
R10639 VSS.n9953 VSS.n9952 9.3005
R10640 VSS.n9955 VSS.n9954 9.3005
R10641 VSS.n1927 VSS.n1925 9.3005
R10642 VSS.n9962 VSS.n9961 9.3005
R10643 VSS.n9963 VSS.n1924 9.3005
R10644 VSS.n9965 VSS.n9964 9.3005
R10645 VSS.n9966 VSS.n1923 9.3005
R10646 VSS.n9968 VSS.n9967 9.3005
R10647 VSS.t3947 VSS.n9969 9.3005
R10648 VSS.n9970 VSS.n1922 9.3005
R10649 VSS.n9972 VSS.n9971 9.3005
R10650 VSS.n9994 VSS.n9993 9.3005
R10651 VSS.n9977 VSS.n9976 9.3005
R10652 VSS.n9987 VSS.n9986 9.3005
R10653 VSS.n9985 VSS.n9984 9.3005
R10654 VSS.n9983 VSS.n9980 9.3005
R10655 VSS.n9982 VSS.n9981 9.3005
R10656 VSS.n94 VSS.n10063 2.25403
R10657 VSS.n94 VSS.n18 0.192834
R10658 VSS.n1912 VSS.n18 9.3005
R10659 VSS.n18 VSS.n77 4.07296
R10660 VSS.n18 VSS.n63 9.3005
R10661 VSS.n18 VSS.n10056 9.3005
R10662 VSS.n46 VSS.n18 3.96704
R10663 VSS.n18 VSS.n10051 9.3005
R10664 VSS.n10050 VSS.n17 9.3005
R10665 VSS.t3908 VSS.n10049 9.3005
R10666 VSS.n10048 VSS.n1916 9.3005
R10667 VSS.n10047 VSS.n10046 9.3005
R10668 VSS.n1918 VSS.n1917 9.3005
R10669 VSS.n10039 VSS.n1919 9.3005
R10670 VSS.n10041 VSS.n10040 9.3005
R10671 VSS.n10038 VSS.n9999 9.3005
R10672 VSS.n10037 VSS.n10036 9.3005
R10673 VSS.n10031 VSS.n10000 9.3005
R10674 VSS.n10025 VSS.n10002 9.3005
R10675 VSS.n10027 VSS.n10026 9.3005
R10676 VSS.n10024 VSS.n10023 9.3005
R10677 VSS.n10019 VSS.n10005 9.3005
R10678 VSS.n10018 VSS.n10017 9.3005
R10679 VSS.n10016 VSS.n10015 9.3005
R10680 VSS.n10014 VSS.n10006 9.3005
R10681 VSS.t3943 VSS.n10013 9.3005
R10682 VSS.n10012 VSS.n10007 9.3005
R10683 VSS.n10011 VSS.n10010 9.3005
R10684 VSS.n10009 VSS.n10008 9.3005
R10685 VSS.n10393 VSS.n10392 9.3005
R10686 VSS.n10395 VSS.n10394 9.3005
R10687 VSS.n10386 VSS.n10383 9.3005
R10688 VSS.n10402 VSS.n10401 9.3005
R10689 VSS.n10403 VSS.n10382 9.3005
R10690 VSS.n10405 VSS.n10404 9.3005
R10691 VSS.n10406 VSS.n10381 9.3005
R10692 VSS.n10408 VSS.n10407 9.3005
R10693 VSS.n10409 VSS.n10380 9.3005
R10694 VSS.n10411 VSS.n10410 9.3005
R10695 VSS.n10412 VSS.n10379 9.3005
R10696 VSS.n10414 VSS.n10413 9.3005
R10697 VSS.n10415 VSS.n10378 9.3005
R10698 VSS.n10417 VSS.n10416 9.3005
R10699 VSS.n10372 VSS.n10369 9.3005
R10700 VSS.n10424 VSS.n10423 9.3005
R10701 VSS.n10425 VSS.n10368 9.3005
R10702 VSS.n10427 VSS.n10426 9.3005
R10703 VSS.n10428 VSS.n10367 9.3005
R10704 VSS.n10430 VSS.n10429 9.3005
R10705 VSS.n10431 VSS.n10366 9.3005
R10706 VSS.n10433 VSS.n10432 9.3005
R10707 VSS.n10434 VSS.n10364 9.3005
R10708 VSS.n10441 VSS.n10440 9.3005
R10709 VSS.n10442 VSS.n10362 9.3005
R10710 VSS.n10444 VSS.n10443 9.3005
R10711 VSS.n10445 VSS.n10361 9.3005
R10712 VSS.n175 VSS.n174 0.138245
R10713 VSS.n10447 VSS.n175 3.04638
R10714 VSS.n10447 VSS.n209 9.3005
R10715 VSS.n10450 VSS.n10449 9.3005
R10716 VSS.n10451 VSS.n10360 9.3005
R10717 VSS.n10453 VSS.n10452 9.3005
R10718 VSS.n10454 VSS.n10359 9.3005
R10719 VSS.n10458 VSS.n10457 9.3005
R10720 VSS.n10358 VSS.n10355 9.3005
R10721 VSS.n10351 VSS.n10349 9.3005
R10722 VSS.n10463 VSS.n10462 9.3005
R10723 VSS.n10465 VSS.n10464 9.3005
R10724 VSS.n10348 VSS.n10345 9.3005
R10725 VSS.n10467 VSS.n10343 9.3005
R10726 VSS.n10469 VSS.n10468 9.3005
R10727 VSS.n10470 VSS.n10342 9.3005
R10728 VSS.n10472 VSS.n10471 9.3005
R10729 VSS.n10473 VSS.n10341 9.3005
R10730 VSS.n10475 VSS.n10474 9.3005
R10731 VSS.n10477 VSS.n10476 9.3005
R10732 VSS.n10480 VSS.n10339 9.3005
R10733 VSS.n10482 VSS.n10481 9.3005
R10734 VSS.n10484 VSS.n10483 9.3005
R10735 VSS.n10337 VSS.n10334 9.3005
R10736 VSS.n10490 VSS.n10489 9.3005
R10737 VSS.n10492 VSS.n10491 9.3005
R10738 VSS.n10331 VSS.n10329 9.3005
R10739 VSS.n10499 VSS.n10498 9.3005
R10740 VSS.n10500 VSS.n10328 9.3005
R10741 VSS.n10502 VSS.n10501 9.3005
R10742 VSS.n10503 VSS.n10327 9.3005
R10743 VSS.n10505 VSS.n10504 9.3005
R10744 VSS.n10506 VSS.t4042 9.3005
R10745 VSS.n10508 VSS.n10507 9.3005
R10746 VSS.n10509 VSS.n10326 9.3005
R10747 VSS.n10517 VSS.n10516 9.3005
R10748 VSS.n10519 VSS.n10518 9.3005
R10749 VSS.n10322 VSS.n10319 9.3005
R10750 VSS.n10524 VSS.n10318 9.3005
R10751 VSS.n10526 VSS.n10525 9.3005
R10752 VSS.n10528 VSS.n10527 9.3005
R10753 VSS.n10537 VSS.n10536 9.3005
R10754 VSS.n10538 VSS.n10316 9.3005
R10755 VSS.n10540 VSS.n10539 9.3005
R10756 VSS.n10313 VSS.n10311 9.3005
R10757 VSS.n10547 VSS.n10546 9.3005
R10758 VSS.n10548 VSS.n10310 9.3005
R10759 VSS.n10550 VSS.n10549 9.3005
R10760 VSS.n10551 VSS.n10309 9.3005
R10761 VSS.n10553 VSS.n10552 9.3005
R10762 VSS.t4003 VSS.n10554 9.3005
R10763 VSS.n10555 VSS.n10308 9.3005
R10764 VSS.n10557 VSS.n10556 9.3005
R10765 VSS.n10559 VSS.n10558 9.3005
R10766 VSS.n10307 VSS.n10305 9.3005
R10767 VSS.n10301 VSS.n10299 9.3005
R10768 VSS.n10564 VSS.n10563 9.3005
R10769 VSS.n10566 VSS.n10565 9.3005
R10770 VSS.n10298 VSS.n10295 9.3005
R10771 VSS.n10568 VSS.n10293 9.3005
R10772 VSS.n10570 VSS.n10569 9.3005
R10773 VSS.n10571 VSS.n10292 9.3005
R10774 VSS.n10573 VSS.n10572 9.3005
R10775 VSS.n10574 VSS.n10291 9.3005
R10776 VSS.n10576 VSS.n10575 9.3005
R10777 VSS.n10578 VSS.n10577 9.3005
R10778 VSS.n10581 VSS.n10289 9.3005
R10779 VSS.n10583 VSS.n10582 9.3005
R10780 VSS.n10585 VSS.n10584 9.3005
R10781 VSS.n10287 VSS.n10284 9.3005
R10782 VSS.n10591 VSS.n10590 9.3005
R10783 VSS.n10593 VSS.n10592 9.3005
R10784 VSS.n10281 VSS.n10279 9.3005
R10785 VSS.n10600 VSS.n10599 9.3005
R10786 VSS.n10601 VSS.n10278 9.3005
R10787 VSS.n10603 VSS.n10602 9.3005
R10788 VSS.n10604 VSS.n10277 9.3005
R10789 VSS.n10606 VSS.n10605 9.3005
R10790 VSS.n10607 VSS.t4037 9.3005
R10791 VSS.n10609 VSS.n10608 9.3005
R10792 VSS.n10610 VSS.n10276 9.3005
R10793 VSS.n10618 VSS.n10617 9.3005
R10794 VSS.n10620 VSS.n10619 9.3005
R10795 VSS.n10272 VSS.n10269 9.3005
R10796 VSS.n10625 VSS.n10268 9.3005
R10797 VSS.n10627 VSS.n10626 9.3005
R10798 VSS.n10629 VSS.n10628 9.3005
R10799 VSS.n10638 VSS.n10637 9.3005
R10800 VSS.n10639 VSS.n10266 9.3005
R10801 VSS.n10641 VSS.n10640 9.3005
R10802 VSS.n10263 VSS.n10261 9.3005
R10803 VSS.n10648 VSS.n10647 9.3005
R10804 VSS.n10649 VSS.n10260 9.3005
R10805 VSS.n10651 VSS.n10650 9.3005
R10806 VSS.n10652 VSS.n10259 9.3005
R10807 VSS.n10654 VSS.n10653 9.3005
R10808 VSS.t3998 VSS.n10655 9.3005
R10809 VSS.n10656 VSS.n10258 9.3005
R10810 VSS.n10658 VSS.n10657 9.3005
R10811 VSS.n10660 VSS.n10659 9.3005
R10812 VSS.n10257 VSS.n10255 9.3005
R10813 VSS.n10251 VSS.n10249 9.3005
R10814 VSS.n10665 VSS.n10664 9.3005
R10815 VSS.n10667 VSS.n10666 9.3005
R10816 VSS.n10248 VSS.n10245 9.3005
R10817 VSS.n10669 VSS.n10243 9.3005
R10818 VSS.n10671 VSS.n10670 9.3005
R10819 VSS.n10672 VSS.n10242 9.3005
R10820 VSS.n10674 VSS.n10673 9.3005
R10821 VSS.n10675 VSS.n10241 9.3005
R10822 VSS.n10677 VSS.n10676 9.3005
R10823 VSS.n10679 VSS.n10678 9.3005
R10824 VSS.n10682 VSS.n10239 9.3005
R10825 VSS.n10684 VSS.n10683 9.3005
R10826 VSS.n10686 VSS.n10685 9.3005
R10827 VSS.n10237 VSS.n10234 9.3005
R10828 VSS.n10692 VSS.n10691 9.3005
R10829 VSS.n10694 VSS.n10693 9.3005
R10830 VSS.n10231 VSS.n10229 9.3005
R10831 VSS.n10701 VSS.n10700 9.3005
R10832 VSS.n10702 VSS.n10228 9.3005
R10833 VSS.n10704 VSS.n10703 9.3005
R10834 VSS.n10705 VSS.n10227 9.3005
R10835 VSS.n10707 VSS.n10706 9.3005
R10836 VSS.n10708 VSS.t4032 9.3005
R10837 VSS.n10710 VSS.n10709 9.3005
R10838 VSS.n10711 VSS.n10226 9.3005
R10839 VSS.n10719 VSS.n10718 9.3005
R10840 VSS.n10721 VSS.n10720 9.3005
R10841 VSS.n10222 VSS.n10219 9.3005
R10842 VSS.n10726 VSS.n10218 9.3005
R10843 VSS.n10728 VSS.n10727 9.3005
R10844 VSS.n10730 VSS.n10729 9.3005
R10845 VSS.n10739 VSS.n10738 9.3005
R10846 VSS.n10740 VSS.n10216 9.3005
R10847 VSS.n10742 VSS.n10741 9.3005
R10848 VSS.n10213 VSS.n10211 9.3005
R10849 VSS.n10749 VSS.n10748 9.3005
R10850 VSS.n10750 VSS.n10210 9.3005
R10851 VSS.n10752 VSS.n10751 9.3005
R10852 VSS.n10753 VSS.n10209 9.3005
R10853 VSS.n10755 VSS.n10754 9.3005
R10854 VSS.t3993 VSS.n10756 9.3005
R10855 VSS.n10757 VSS.n10208 9.3005
R10856 VSS.n10759 VSS.n10758 9.3005
R10857 VSS.n10761 VSS.n10760 9.3005
R10858 VSS.n10207 VSS.n10205 9.3005
R10859 VSS.n10201 VSS.n10199 9.3005
R10860 VSS.n10766 VSS.n10765 9.3005
R10861 VSS.n10768 VSS.n10767 9.3005
R10862 VSS.n10198 VSS.n10195 9.3005
R10863 VSS.n10770 VSS.n10193 9.3005
R10864 VSS.n10772 VSS.n10771 9.3005
R10865 VSS.n10773 VSS.n10192 9.3005
R10866 VSS.n10775 VSS.n10774 9.3005
R10867 VSS.n10776 VSS.n10191 9.3005
R10868 VSS.n10778 VSS.n10777 9.3005
R10869 VSS.n10780 VSS.n10779 9.3005
R10870 VSS.n10783 VSS.n10189 9.3005
R10871 VSS.n10785 VSS.n10784 9.3005
R10872 VSS.n10787 VSS.n10786 9.3005
R10873 VSS.n10187 VSS.n10184 9.3005
R10874 VSS.n10793 VSS.n10792 9.3005
R10875 VSS.n10795 VSS.n10794 9.3005
R10876 VSS.n10181 VSS.n10179 9.3005
R10877 VSS.n10802 VSS.n10801 9.3005
R10878 VSS.n10803 VSS.n10178 9.3005
R10879 VSS.n10805 VSS.n10804 9.3005
R10880 VSS.n10806 VSS.n10177 9.3005
R10881 VSS.n10808 VSS.n10807 9.3005
R10882 VSS.n10809 VSS.t4027 9.3005
R10883 VSS.n10811 VSS.n10810 9.3005
R10884 VSS.n10812 VSS.n10176 9.3005
R10885 VSS.n10820 VSS.n10819 9.3005
R10886 VSS.n10822 VSS.n10821 9.3005
R10887 VSS.n10172 VSS.n10169 9.3005
R10888 VSS.n10827 VSS.n10168 9.3005
R10889 VSS.n10829 VSS.n10828 9.3005
R10890 VSS.n10831 VSS.n10830 9.3005
R10891 VSS.n10840 VSS.n10839 9.3005
R10892 VSS.n10841 VSS.n10166 9.3005
R10893 VSS.n10843 VSS.n10842 9.3005
R10894 VSS.n10163 VSS.n10161 9.3005
R10895 VSS.n10850 VSS.n10849 9.3005
R10896 VSS.n10851 VSS.n10160 9.3005
R10897 VSS.n10853 VSS.n10852 9.3005
R10898 VSS.n10854 VSS.n10159 9.3005
R10899 VSS.n10856 VSS.n10855 9.3005
R10900 VSS.t3988 VSS.n10857 9.3005
R10901 VSS.n10858 VSS.n10158 9.3005
R10902 VSS.n10860 VSS.n10859 9.3005
R10903 VSS.n10862 VSS.n10861 9.3005
R10904 VSS.n10157 VSS.n10155 9.3005
R10905 VSS.n10151 VSS.n10149 9.3005
R10906 VSS.n10867 VSS.n10866 9.3005
R10907 VSS.n10869 VSS.n10868 9.3005
R10908 VSS.n10148 VSS.n10145 9.3005
R10909 VSS.n10871 VSS.n10143 9.3005
R10910 VSS.n10873 VSS.n10872 9.3005
R10911 VSS.n10874 VSS.n10142 9.3005
R10912 VSS.n10876 VSS.n10875 9.3005
R10913 VSS.n10877 VSS.n10141 9.3005
R10914 VSS.n10879 VSS.n10878 9.3005
R10915 VSS.n10881 VSS.n10880 9.3005
R10916 VSS.n10884 VSS.n10139 9.3005
R10917 VSS.n10886 VSS.n10885 9.3005
R10918 VSS.n10888 VSS.n10887 9.3005
R10919 VSS.n10137 VSS.n10134 9.3005
R10920 VSS.n10894 VSS.n10893 9.3005
R10921 VSS.n10896 VSS.n10895 9.3005
R10922 VSS.n10131 VSS.n10129 9.3005
R10923 VSS.n10903 VSS.n10902 9.3005
R10924 VSS.n10904 VSS.n10128 9.3005
R10925 VSS.n10906 VSS.n10905 9.3005
R10926 VSS.n10907 VSS.n10127 9.3005
R10927 VSS.n10909 VSS.n10908 9.3005
R10928 VSS.n10910 VSS.t4022 9.3005
R10929 VSS.n10912 VSS.n10911 9.3005
R10930 VSS.n10913 VSS.n10126 9.3005
R10931 VSS.n10921 VSS.n10920 9.3005
R10932 VSS.n10923 VSS.n10922 9.3005
R10933 VSS.n10122 VSS.n10119 9.3005
R10934 VSS.n10928 VSS.n10118 9.3005
R10935 VSS.n10930 VSS.n10929 9.3005
R10936 VSS.n10932 VSS.n10931 9.3005
R10937 VSS.n10941 VSS.n10940 9.3005
R10938 VSS.n10942 VSS.n10116 9.3005
R10939 VSS.n10944 VSS.n10943 9.3005
R10940 VSS.n10113 VSS.n10111 9.3005
R10941 VSS.n10951 VSS.n10950 9.3005
R10942 VSS.n10952 VSS.n10110 9.3005
R10943 VSS.n10954 VSS.n10953 9.3005
R10944 VSS.n10955 VSS.n10109 9.3005
R10945 VSS.n10957 VSS.n10956 9.3005
R10946 VSS.t3983 VSS.n10958 9.3005
R10947 VSS.n10959 VSS.n10108 9.3005
R10948 VSS.n10961 VSS.n10960 9.3005
R10949 VSS.n10963 VSS.n10962 9.3005
R10950 VSS.n10107 VSS.n10105 9.3005
R10951 VSS.n10101 VSS.n10099 9.3005
R10952 VSS.n10968 VSS.n10967 9.3005
R10953 VSS.n10970 VSS.n10969 9.3005
R10954 VSS.n10098 VSS.n10095 9.3005
R10955 VSS.n10972 VSS.n10093 9.3005
R10956 VSS.n10974 VSS.n10973 9.3005
R10957 VSS.n10975 VSS.n10092 9.3005
R10958 VSS.n10977 VSS.n10976 9.3005
R10959 VSS.n10978 VSS.n10091 9.3005
R10960 VSS.n10980 VSS.n10979 9.3005
R10961 VSS.n10982 VSS.n10981 9.3005
R10962 VSS.n10985 VSS.n10089 9.3005
R10963 VSS.n10987 VSS.n10986 9.3005
R10964 VSS.n10989 VSS.n10988 9.3005
R10965 VSS.n10087 VSS.n10084 9.3005
R10966 VSS.n10995 VSS.n10994 9.3005
R10967 VSS.n10997 VSS.n10996 9.3005
R10968 VSS.n10081 VSS.n10079 9.3005
R10969 VSS.n11004 VSS.n11003 9.3005
R10970 VSS.n11005 VSS.n10078 9.3005
R10971 VSS.n11007 VSS.n11006 9.3005
R10972 VSS.n11008 VSS.n10077 9.3005
R10973 VSS.n11010 VSS.n11009 9.3005
R10974 VSS.t4017 VSS.n11011 9.3005
R10975 VSS.n11012 VSS.n10076 9.3005
R10976 VSS.n11014 VSS.n11013 9.3005
R10977 VSS.n11036 VSS.n11035 9.3005
R10978 VSS.n11019 VSS.n11018 9.3005
R10979 VSS.n11029 VSS.n11028 9.3005
R10980 VSS.n11027 VSS.n11026 9.3005
R10981 VSS.n11025 VSS.n11022 9.3005
R10982 VSS.n11024 VSS.n11023 9.3005
R10983 VSS.n95 VSS.n11105 2.25403
R10984 VSS.n95 VSS.n20 0.192834
R10985 VSS.n10066 VSS.n20 9.3005
R10986 VSS.n20 VSS.n76 4.07296
R10987 VSS.n20 VSS.n64 9.3005
R10988 VSS.n20 VSS.n11098 9.3005
R10989 VSS.n45 VSS.n20 3.96704
R10990 VSS.n20 VSS.n11093 9.3005
R10991 VSS.n11092 VSS.n19 9.3005
R10992 VSS.t3978 VSS.n11091 9.3005
R10993 VSS.n11090 VSS.n10070 9.3005
R10994 VSS.n11089 VSS.n11088 9.3005
R10995 VSS.n10072 VSS.n10071 9.3005
R10996 VSS.n11081 VSS.n10073 9.3005
R10997 VSS.n11083 VSS.n11082 9.3005
R10998 VSS.n11080 VSS.n11041 9.3005
R10999 VSS.n11079 VSS.n11078 9.3005
R11000 VSS.n11073 VSS.n11042 9.3005
R11001 VSS.n11067 VSS.n11044 9.3005
R11002 VSS.n11069 VSS.n11068 9.3005
R11003 VSS.n11066 VSS.n11065 9.3005
R11004 VSS.n11061 VSS.n11047 9.3005
R11005 VSS.n11060 VSS.n11059 9.3005
R11006 VSS.n11058 VSS.n11057 9.3005
R11007 VSS.n11056 VSS.n11048 9.3005
R11008 VSS.t4013 VSS.n11055 9.3005
R11009 VSS.n11054 VSS.n11049 9.3005
R11010 VSS.n11053 VSS.n11052 9.3005
R11011 VSS.n11051 VSS.n11050 9.3005
R11012 VSS.n11829 VSS.n11824 9.3005
R11013 VSS.n11831 VSS.n11830 9.3005
R11014 VSS.n11833 VSS.n11832 9.3005
R11015 VSS.n11823 VSS.n11819 9.3005
R11016 VSS.n11838 VSS.n11817 9.3005
R11017 VSS.n11840 VSS.n11839 9.3005
R11018 VSS.n11841 VSS.n11816 9.3005
R11019 VSS.n11843 VSS.n11842 9.3005
R11020 VSS.n11844 VSS.n11815 9.3005
R11021 VSS.n11846 VSS.n11845 9.3005
R11022 VSS.n11847 VSS.n11814 9.3005
R11023 VSS.n11849 VSS.n11848 9.3005
R11024 VSS.n11852 VSS.n11811 9.3005
R11025 VSS.n11854 VSS.n11853 9.3005
R11026 VSS.n11856 VSS.n11855 9.3005
R11027 VSS.n11810 VSS.n11806 9.3005
R11028 VSS.n11861 VSS.n11804 9.3005
R11029 VSS.n11863 VSS.n11862 9.3005
R11030 VSS.n11864 VSS.n11803 9.3005
R11031 VSS.n11866 VSS.n11865 9.3005
R11032 VSS.n11867 VSS.n11802 9.3005
R11033 VSS.n11869 VSS.n11868 9.3005
R11034 VSS.n11871 VSS.n11870 9.3005
R11035 VSS.n11876 VSS.n1653 9.3005
R11036 VSS.n11878 VSS.n11877 9.3005
R11037 VSS.n11879 VSS.n1652 9.3005
R11038 VSS.n11881 VSS.n11880 9.3005
R11039 VSS.n171 VSS.n172 0.138245
R11040 VSS.n11884 VSS.n172 3.04638
R11041 VSS.n11884 VSS.n210 9.3005
R11042 VSS.n1666 VSS.n1665 9.3005
R11043 VSS.n1667 VSS.n1662 9.3005
R11044 VSS.n1669 VSS.n1668 9.3005
R11045 VSS.n1670 VSS.n1661 9.3005
R11046 VSS.n1674 VSS.n1673 9.3005
R11047 VSS.n11794 VSS.n1658 9.3005
R11048 VSS.n11796 VSS.n11795 9.3005
R11049 VSS.n11798 VSS.n11797 9.3005
R11050 VSS.n1675 VSS.n1657 9.3005
R11051 VSS.n11784 VSS.n153 9.3005
R11052 VSS.n11786 VSS.n11785 9.3005
R11053 VSS.n11783 VSS.n1676 9.3005
R11054 VSS.n11782 VSS.n11781 9.3005
R11055 VSS.n11779 VSS.n1677 9.3005
R11056 VSS.n11778 VSS.n11777 9.3005
R11057 VSS.n11776 VSS.n11775 9.3005
R11058 VSS.n1679 VSS.n1678 9.3005
R11059 VSS.n11773 VSS.n11772 9.3005
R11060 VSS.n11771 VSS.n1680 9.3005
R11061 VSS.n11770 VSS.n11769 9.3005
R11062 VSS.n11761 VSS.n1682 9.3005
R11063 VSS.n11757 VSS.n1684 9.3005
R11064 VSS.n11759 VSS.n11758 9.3005
R11065 VSS.n11756 VSS.n11755 9.3005
R11066 VSS.n1688 VSS.n1687 9.3005
R11067 VSS.n11749 VSS.n11748 9.3005
R11068 VSS.n11747 VSS.n1689 9.3005
R11069 VSS.n11746 VSS.n11745 9.3005
R11070 VSS.n11744 VSS.n1690 9.3005
R11071 VSS.t4112 VSS.n11743 9.3005
R11072 VSS.n11742 VSS.n1691 9.3005
R11073 VSS.n11741 VSS.n11740 9.3005
R11074 VSS.n11736 VSS.n11735 9.3005
R11075 VSS.n1697 VSS.n1696 9.3005
R11076 VSS.n11729 VSS.n11728 9.3005
R11077 VSS.n11727 VSS.n11726 9.3005
R11078 VSS.n11725 VSS.n1700 9.3005
R11079 VSS.n11724 VSS.n11723 9.3005
R11080 VSS.n11721 VSS.n11720 9.3005
R11081 VSS.n1706 VSS.n1702 9.3005
R11082 VSS.n11713 VSS.n11712 9.3005
R11083 VSS.n11711 VSS.n1708 9.3005
R11084 VSS.n11710 VSS.n11709 9.3005
R11085 VSS.n11704 VSS.n1709 9.3005
R11086 VSS.n11703 VSS.n11702 9.3005
R11087 VSS.n11701 VSS.n11700 9.3005
R11088 VSS.n11699 VSS.n1710 9.3005
R11089 VSS.t4073 VSS.n11698 9.3005
R11090 VSS.n11697 VSS.n1711 9.3005
R11091 VSS.n11696 VSS.n11695 9.3005
R11092 VSS.n1713 VSS.n1712 9.3005
R11093 VSS.n11688 VSS.n1714 9.3005
R11094 VSS.n11690 VSS.n11689 9.3005
R11095 VSS.n11687 VSS.n1716 9.3005
R11096 VSS.n11686 VSS.n11685 9.3005
R11097 VSS.n11680 VSS.n1717 9.3005
R11098 VSS.n11679 VSS.n11678 9.3005
R11099 VSS.n11677 VSS.n1718 9.3005
R11100 VSS.n11676 VSS.n11675 9.3005
R11101 VSS.n11673 VSS.n1719 9.3005
R11102 VSS.n11672 VSS.n11671 9.3005
R11103 VSS.n11670 VSS.n11669 9.3005
R11104 VSS.n1721 VSS.n1720 9.3005
R11105 VSS.n11667 VSS.n11666 9.3005
R11106 VSS.n11665 VSS.n1722 9.3005
R11107 VSS.n11664 VSS.n11663 9.3005
R11108 VSS.n11655 VSS.n1724 9.3005
R11109 VSS.n11651 VSS.n1726 9.3005
R11110 VSS.n11653 VSS.n11652 9.3005
R11111 VSS.n11650 VSS.n11649 9.3005
R11112 VSS.n1730 VSS.n1729 9.3005
R11113 VSS.n11643 VSS.n11642 9.3005
R11114 VSS.n11641 VSS.n1731 9.3005
R11115 VSS.n11640 VSS.n11639 9.3005
R11116 VSS.n11638 VSS.n1732 9.3005
R11117 VSS.t4107 VSS.n11637 9.3005
R11118 VSS.n11636 VSS.n1733 9.3005
R11119 VSS.n11635 VSS.n11634 9.3005
R11120 VSS.n11630 VSS.n11629 9.3005
R11121 VSS.n1739 VSS.n1738 9.3005
R11122 VSS.n11623 VSS.n11622 9.3005
R11123 VSS.n11621 VSS.n11620 9.3005
R11124 VSS.n11619 VSS.n1742 9.3005
R11125 VSS.n11618 VSS.n11617 9.3005
R11126 VSS.n11615 VSS.n11614 9.3005
R11127 VSS.n1748 VSS.n1744 9.3005
R11128 VSS.n11607 VSS.n11606 9.3005
R11129 VSS.n11605 VSS.n1750 9.3005
R11130 VSS.n11604 VSS.n11603 9.3005
R11131 VSS.n11598 VSS.n1751 9.3005
R11132 VSS.n11597 VSS.n11596 9.3005
R11133 VSS.n11595 VSS.n11594 9.3005
R11134 VSS.n11593 VSS.n1752 9.3005
R11135 VSS.t4068 VSS.n11592 9.3005
R11136 VSS.n11591 VSS.n1753 9.3005
R11137 VSS.n11590 VSS.n11589 9.3005
R11138 VSS.n1755 VSS.n1754 9.3005
R11139 VSS.n11582 VSS.n1756 9.3005
R11140 VSS.n11584 VSS.n11583 9.3005
R11141 VSS.n11581 VSS.n1758 9.3005
R11142 VSS.n11580 VSS.n11579 9.3005
R11143 VSS.n11574 VSS.n1759 9.3005
R11144 VSS.n11573 VSS.n11572 9.3005
R11145 VSS.n11571 VSS.n1760 9.3005
R11146 VSS.n11570 VSS.n11569 9.3005
R11147 VSS.n11567 VSS.n1761 9.3005
R11148 VSS.n11566 VSS.n11565 9.3005
R11149 VSS.n11564 VSS.n11563 9.3005
R11150 VSS.n1763 VSS.n1762 9.3005
R11151 VSS.n11561 VSS.n11560 9.3005
R11152 VSS.n11559 VSS.n1764 9.3005
R11153 VSS.n11558 VSS.n11557 9.3005
R11154 VSS.n11549 VSS.n1766 9.3005
R11155 VSS.n11545 VSS.n1768 9.3005
R11156 VSS.n11547 VSS.n11546 9.3005
R11157 VSS.n11544 VSS.n11543 9.3005
R11158 VSS.n1772 VSS.n1771 9.3005
R11159 VSS.n11537 VSS.n11536 9.3005
R11160 VSS.n11535 VSS.n1773 9.3005
R11161 VSS.n11534 VSS.n11533 9.3005
R11162 VSS.n11532 VSS.n1774 9.3005
R11163 VSS.t4102 VSS.n11531 9.3005
R11164 VSS.n11530 VSS.n1775 9.3005
R11165 VSS.n11529 VSS.n11528 9.3005
R11166 VSS.n11524 VSS.n11523 9.3005
R11167 VSS.n1781 VSS.n1780 9.3005
R11168 VSS.n11517 VSS.n11516 9.3005
R11169 VSS.n11515 VSS.n11514 9.3005
R11170 VSS.n11513 VSS.n1784 9.3005
R11171 VSS.n11512 VSS.n11511 9.3005
R11172 VSS.n11509 VSS.n11508 9.3005
R11173 VSS.n1790 VSS.n1786 9.3005
R11174 VSS.n11501 VSS.n11500 9.3005
R11175 VSS.n11499 VSS.n1792 9.3005
R11176 VSS.n11498 VSS.n11497 9.3005
R11177 VSS.n11492 VSS.n1793 9.3005
R11178 VSS.n11491 VSS.n11490 9.3005
R11179 VSS.n11489 VSS.n11488 9.3005
R11180 VSS.n11487 VSS.n1794 9.3005
R11181 VSS.t4063 VSS.n11486 9.3005
R11182 VSS.n11485 VSS.n1795 9.3005
R11183 VSS.n11484 VSS.n11483 9.3005
R11184 VSS.n1797 VSS.n1796 9.3005
R11185 VSS.n11476 VSS.n1798 9.3005
R11186 VSS.n11478 VSS.n11477 9.3005
R11187 VSS.n11475 VSS.n1800 9.3005
R11188 VSS.n11474 VSS.n11473 9.3005
R11189 VSS.n11468 VSS.n1801 9.3005
R11190 VSS.n11467 VSS.n11466 9.3005
R11191 VSS.n11465 VSS.n1802 9.3005
R11192 VSS.n11464 VSS.n11463 9.3005
R11193 VSS.n11461 VSS.n1803 9.3005
R11194 VSS.n11460 VSS.n11459 9.3005
R11195 VSS.n11458 VSS.n11457 9.3005
R11196 VSS.n1805 VSS.n1804 9.3005
R11197 VSS.n11455 VSS.n11454 9.3005
R11198 VSS.n11453 VSS.n1806 9.3005
R11199 VSS.n11452 VSS.n11451 9.3005
R11200 VSS.n11443 VSS.n1808 9.3005
R11201 VSS.n11439 VSS.n1810 9.3005
R11202 VSS.n11441 VSS.n11440 9.3005
R11203 VSS.n11438 VSS.n11437 9.3005
R11204 VSS.n1814 VSS.n1813 9.3005
R11205 VSS.n11431 VSS.n11430 9.3005
R11206 VSS.n11429 VSS.n1815 9.3005
R11207 VSS.n11428 VSS.n11427 9.3005
R11208 VSS.n11426 VSS.n1816 9.3005
R11209 VSS.t4097 VSS.n11425 9.3005
R11210 VSS.n11424 VSS.n1817 9.3005
R11211 VSS.n11423 VSS.n11422 9.3005
R11212 VSS.n11418 VSS.n11417 9.3005
R11213 VSS.n1823 VSS.n1822 9.3005
R11214 VSS.n11411 VSS.n11410 9.3005
R11215 VSS.n11409 VSS.n11408 9.3005
R11216 VSS.n11407 VSS.n1826 9.3005
R11217 VSS.n11406 VSS.n11405 9.3005
R11218 VSS.n11403 VSS.n11402 9.3005
R11219 VSS.n1832 VSS.n1828 9.3005
R11220 VSS.n11395 VSS.n11394 9.3005
R11221 VSS.n11393 VSS.n1834 9.3005
R11222 VSS.n11392 VSS.n11391 9.3005
R11223 VSS.n11386 VSS.n1835 9.3005
R11224 VSS.n11385 VSS.n11384 9.3005
R11225 VSS.n11383 VSS.n11382 9.3005
R11226 VSS.n11381 VSS.n1836 9.3005
R11227 VSS.t4058 VSS.n11380 9.3005
R11228 VSS.n11379 VSS.n1837 9.3005
R11229 VSS.n11378 VSS.n11377 9.3005
R11230 VSS.n1839 VSS.n1838 9.3005
R11231 VSS.n11370 VSS.n1840 9.3005
R11232 VSS.n11372 VSS.n11371 9.3005
R11233 VSS.n11369 VSS.n1842 9.3005
R11234 VSS.n11368 VSS.n11367 9.3005
R11235 VSS.n11362 VSS.n1843 9.3005
R11236 VSS.n11361 VSS.n11360 9.3005
R11237 VSS.n11359 VSS.n1844 9.3005
R11238 VSS.n11358 VSS.n11357 9.3005
R11239 VSS.n11355 VSS.n1845 9.3005
R11240 VSS.n11354 VSS.n11353 9.3005
R11241 VSS.n11352 VSS.n11351 9.3005
R11242 VSS.n1847 VSS.n1846 9.3005
R11243 VSS.n11349 VSS.n11348 9.3005
R11244 VSS.n11347 VSS.n1848 9.3005
R11245 VSS.n11346 VSS.n11345 9.3005
R11246 VSS.n11337 VSS.n1850 9.3005
R11247 VSS.n11333 VSS.n1852 9.3005
R11248 VSS.n11335 VSS.n11334 9.3005
R11249 VSS.n11332 VSS.n11331 9.3005
R11250 VSS.n1856 VSS.n1855 9.3005
R11251 VSS.n11325 VSS.n11324 9.3005
R11252 VSS.n11323 VSS.n1857 9.3005
R11253 VSS.n11322 VSS.n11321 9.3005
R11254 VSS.n11320 VSS.n1858 9.3005
R11255 VSS.t4092 VSS.n11319 9.3005
R11256 VSS.n11318 VSS.n1859 9.3005
R11257 VSS.n11317 VSS.n11316 9.3005
R11258 VSS.n11312 VSS.n11311 9.3005
R11259 VSS.n1865 VSS.n1864 9.3005
R11260 VSS.n11305 VSS.n11304 9.3005
R11261 VSS.n11303 VSS.n11302 9.3005
R11262 VSS.n11301 VSS.n1868 9.3005
R11263 VSS.n11300 VSS.n11299 9.3005
R11264 VSS.n11297 VSS.n11296 9.3005
R11265 VSS.n1874 VSS.n1870 9.3005
R11266 VSS.n11289 VSS.n11288 9.3005
R11267 VSS.n11287 VSS.n1876 9.3005
R11268 VSS.n11286 VSS.n11285 9.3005
R11269 VSS.n11280 VSS.n1877 9.3005
R11270 VSS.n11279 VSS.n11278 9.3005
R11271 VSS.n11277 VSS.n11276 9.3005
R11272 VSS.n11275 VSS.n1878 9.3005
R11273 VSS.t4053 VSS.n11274 9.3005
R11274 VSS.n11273 VSS.n1879 9.3005
R11275 VSS.n11272 VSS.n11271 9.3005
R11276 VSS.n1881 VSS.n1880 9.3005
R11277 VSS.n11264 VSS.n1882 9.3005
R11278 VSS.n11266 VSS.n11265 9.3005
R11279 VSS.n11263 VSS.n1884 9.3005
R11280 VSS.n11262 VSS.n11261 9.3005
R11281 VSS.n11256 VSS.n1885 9.3005
R11282 VSS.n11255 VSS.n11254 9.3005
R11283 VSS.n11253 VSS.n1886 9.3005
R11284 VSS.n11252 VSS.n11251 9.3005
R11285 VSS.n11249 VSS.n1887 9.3005
R11286 VSS.n11248 VSS.n11247 9.3005
R11287 VSS.n11246 VSS.n11245 9.3005
R11288 VSS.n1889 VSS.n1888 9.3005
R11289 VSS.n11243 VSS.n11242 9.3005
R11290 VSS.n11241 VSS.n1890 9.3005
R11291 VSS.n11240 VSS.n11239 9.3005
R11292 VSS.n11231 VSS.n1892 9.3005
R11293 VSS.n11227 VSS.n1894 9.3005
R11294 VSS.n11229 VSS.n11228 9.3005
R11295 VSS.n11226 VSS.n11225 9.3005
R11296 VSS.n1898 VSS.n1897 9.3005
R11297 VSS.n11219 VSS.n11218 9.3005
R11298 VSS.n11217 VSS.n1899 9.3005
R11299 VSS.n11216 VSS.n11215 9.3005
R11300 VSS.n11214 VSS.n1900 9.3005
R11301 VSS.t4087 VSS.n11213 9.3005
R11302 VSS.n11212 VSS.n1901 9.3005
R11303 VSS.n11211 VSS.n11210 9.3005
R11304 VSS.n11206 VSS.n11205 9.3005
R11305 VSS.n1907 VSS.n1906 9.3005
R11306 VSS.n11199 VSS.n11198 9.3005
R11307 VSS.n11197 VSS.n11196 9.3005
R11308 VSS.n11195 VSS.n1910 9.3005
R11309 VSS.n11194 VSS.n11193 9.3005
R11310 VSS.n96 VSS.n232 2.25403
R11311 VSS.n22 VSS.n96 0.192834
R11312 VSS.n22 VSS.n11191 9.3005
R11313 VSS.n22 VSS.n75 4.07296
R11314 VSS.n22 VSS.n65 9.3005
R11315 VSS.n22 VSS.n11184 9.3005
R11316 VSS.n44 VSS.n22 3.96704
R11317 VSS.n22 VSS.n11179 9.3005
R11318 VSS.n11178 VSS.n21 9.3005
R11319 VSS.t4048 VSS.n11177 9.3005
R11320 VSS.n11176 VSS.n11111 9.3005
R11321 VSS.n11175 VSS.n11174 9.3005
R11322 VSS.n11113 VSS.n11112 9.3005
R11323 VSS.n11167 VSS.n11114 9.3005
R11324 VSS.n11169 VSS.n11168 9.3005
R11325 VSS.n11166 VSS.n11127 9.3005
R11326 VSS.n11165 VSS.n11164 9.3005
R11327 VSS.n11159 VSS.n11128 9.3005
R11328 VSS.n11153 VSS.n11130 9.3005
R11329 VSS.n11155 VSS.n11154 9.3005
R11330 VSS.n11152 VSS.n11151 9.3005
R11331 VSS.n11147 VSS.n11133 9.3005
R11332 VSS.n11146 VSS.n11145 9.3005
R11333 VSS.n11144 VSS.n11143 9.3005
R11334 VSS.n11142 VSS.n11134 9.3005
R11335 VSS.t4083 VSS.n11141 9.3005
R11336 VSS.n11140 VSS.n11135 9.3005
R11337 VSS.n11139 VSS.n11138 9.3005
R11338 VSS.n11137 VSS.n11136 9.3005
R11339 VSS.n12867 VSS.n12862 9.3005
R11340 VSS.n12869 VSS.n12868 9.3005
R11341 VSS.n12871 VSS.n12870 9.3005
R11342 VSS.n12861 VSS.n12857 9.3005
R11343 VSS.n12876 VSS.n12855 9.3005
R11344 VSS.n12878 VSS.n12877 9.3005
R11345 VSS.n12879 VSS.n12854 9.3005
R11346 VSS.n12881 VSS.n12880 9.3005
R11347 VSS.n12882 VSS.n12853 9.3005
R11348 VSS.n12884 VSS.n12883 9.3005
R11349 VSS.n12885 VSS.n12852 9.3005
R11350 VSS.n12887 VSS.n12886 9.3005
R11351 VSS.n12890 VSS.n12849 9.3005
R11352 VSS.n12892 VSS.n12891 9.3005
R11353 VSS.n12894 VSS.n12893 9.3005
R11354 VSS.n12848 VSS.n12844 9.3005
R11355 VSS.n12899 VSS.n12842 9.3005
R11356 VSS.n12901 VSS.n12900 9.3005
R11357 VSS.n12902 VSS.n12841 9.3005
R11358 VSS.n12904 VSS.n12903 9.3005
R11359 VSS.n12905 VSS.n12840 9.3005
R11360 VSS.n12907 VSS.n12906 9.3005
R11361 VSS.n12909 VSS.n12908 9.3005
R11362 VSS.n12914 VSS.n11887 9.3005
R11363 VSS.n12916 VSS.n12915 9.3005
R11364 VSS.n12917 VSS.n11886 9.3005
R11365 VSS.n12919 VSS.n12918 9.3005
R11366 VSS.n169 VSS.n170 0.138245
R11367 VSS.n12922 VSS.n170 3.04638
R11368 VSS.n12922 VSS.n211 9.3005
R11369 VSS.n11900 VSS.n11899 9.3005
R11370 VSS.n11901 VSS.n11896 9.3005
R11371 VSS.n11903 VSS.n11902 9.3005
R11372 VSS.n11904 VSS.n11895 9.3005
R11373 VSS.n11908 VSS.n11907 9.3005
R11374 VSS.n12832 VSS.n11892 9.3005
R11375 VSS.n12834 VSS.n12833 9.3005
R11376 VSS.n12836 VSS.n12835 9.3005
R11377 VSS.n11909 VSS.n11891 9.3005
R11378 VSS.n12822 VSS.n159 9.3005
R11379 VSS.n12824 VSS.n12823 9.3005
R11380 VSS.n12821 VSS.n11910 9.3005
R11381 VSS.n12820 VSS.n12819 9.3005
R11382 VSS.n12817 VSS.n11911 9.3005
R11383 VSS.n12816 VSS.n12815 9.3005
R11384 VSS.n12814 VSS.n12813 9.3005
R11385 VSS.n11913 VSS.n11912 9.3005
R11386 VSS.n12811 VSS.n12810 9.3005
R11387 VSS.n12809 VSS.n11914 9.3005
R11388 VSS.n12808 VSS.n12807 9.3005
R11389 VSS.n12799 VSS.n11916 9.3005
R11390 VSS.n12795 VSS.n11918 9.3005
R11391 VSS.n12797 VSS.n12796 9.3005
R11392 VSS.n12794 VSS.n12793 9.3005
R11393 VSS.n11922 VSS.n11921 9.3005
R11394 VSS.n12787 VSS.n12786 9.3005
R11395 VSS.n12785 VSS.n11923 9.3005
R11396 VSS.n12784 VSS.n12783 9.3005
R11397 VSS.n12782 VSS.n11924 9.3005
R11398 VSS.t4182 VSS.n12781 9.3005
R11399 VSS.n12780 VSS.n11925 9.3005
R11400 VSS.n12779 VSS.n12778 9.3005
R11401 VSS.n12774 VSS.n12773 9.3005
R11402 VSS.n11931 VSS.n11930 9.3005
R11403 VSS.n12767 VSS.n12766 9.3005
R11404 VSS.n12765 VSS.n12764 9.3005
R11405 VSS.n12763 VSS.n11934 9.3005
R11406 VSS.n12762 VSS.n12761 9.3005
R11407 VSS.n12759 VSS.n12758 9.3005
R11408 VSS.n11940 VSS.n11936 9.3005
R11409 VSS.n12751 VSS.n12750 9.3005
R11410 VSS.n12749 VSS.n11942 9.3005
R11411 VSS.n12748 VSS.n12747 9.3005
R11412 VSS.n12742 VSS.n11943 9.3005
R11413 VSS.n12741 VSS.n12740 9.3005
R11414 VSS.n12739 VSS.n12738 9.3005
R11415 VSS.n12737 VSS.n11944 9.3005
R11416 VSS.t4143 VSS.n12736 9.3005
R11417 VSS.n12735 VSS.n11945 9.3005
R11418 VSS.n12734 VSS.n12733 9.3005
R11419 VSS.n11947 VSS.n11946 9.3005
R11420 VSS.n12726 VSS.n11948 9.3005
R11421 VSS.n12728 VSS.n12727 9.3005
R11422 VSS.n12725 VSS.n11950 9.3005
R11423 VSS.n12724 VSS.n12723 9.3005
R11424 VSS.n12718 VSS.n11951 9.3005
R11425 VSS.n12717 VSS.n12716 9.3005
R11426 VSS.n12715 VSS.n11952 9.3005
R11427 VSS.n12714 VSS.n12713 9.3005
R11428 VSS.n12711 VSS.n11953 9.3005
R11429 VSS.n12710 VSS.n12709 9.3005
R11430 VSS.n12708 VSS.n12707 9.3005
R11431 VSS.n11955 VSS.n11954 9.3005
R11432 VSS.n12705 VSS.n12704 9.3005
R11433 VSS.n12703 VSS.n11956 9.3005
R11434 VSS.n12702 VSS.n12701 9.3005
R11435 VSS.n12693 VSS.n11958 9.3005
R11436 VSS.n12689 VSS.n11960 9.3005
R11437 VSS.n12691 VSS.n12690 9.3005
R11438 VSS.n12688 VSS.n12687 9.3005
R11439 VSS.n11964 VSS.n11963 9.3005
R11440 VSS.n12681 VSS.n12680 9.3005
R11441 VSS.n12679 VSS.n11965 9.3005
R11442 VSS.n12678 VSS.n12677 9.3005
R11443 VSS.n12676 VSS.n11966 9.3005
R11444 VSS.t4177 VSS.n12675 9.3005
R11445 VSS.n12674 VSS.n11967 9.3005
R11446 VSS.n12673 VSS.n12672 9.3005
R11447 VSS.n12668 VSS.n12667 9.3005
R11448 VSS.n11973 VSS.n11972 9.3005
R11449 VSS.n12661 VSS.n12660 9.3005
R11450 VSS.n12659 VSS.n12658 9.3005
R11451 VSS.n12657 VSS.n11976 9.3005
R11452 VSS.n12656 VSS.n12655 9.3005
R11453 VSS.n12653 VSS.n12652 9.3005
R11454 VSS.n11982 VSS.n11978 9.3005
R11455 VSS.n12645 VSS.n12644 9.3005
R11456 VSS.n12643 VSS.n11984 9.3005
R11457 VSS.n12642 VSS.n12641 9.3005
R11458 VSS.n12636 VSS.n11985 9.3005
R11459 VSS.n12635 VSS.n12634 9.3005
R11460 VSS.n12633 VSS.n12632 9.3005
R11461 VSS.n12631 VSS.n11986 9.3005
R11462 VSS.t4138 VSS.n12630 9.3005
R11463 VSS.n12629 VSS.n11987 9.3005
R11464 VSS.n12628 VSS.n12627 9.3005
R11465 VSS.n11989 VSS.n11988 9.3005
R11466 VSS.n12620 VSS.n11990 9.3005
R11467 VSS.n12622 VSS.n12621 9.3005
R11468 VSS.n12619 VSS.n11992 9.3005
R11469 VSS.n12618 VSS.n12617 9.3005
R11470 VSS.n12612 VSS.n11993 9.3005
R11471 VSS.n12611 VSS.n12610 9.3005
R11472 VSS.n12609 VSS.n11994 9.3005
R11473 VSS.n12608 VSS.n12607 9.3005
R11474 VSS.n12605 VSS.n11995 9.3005
R11475 VSS.n12604 VSS.n12603 9.3005
R11476 VSS.n12602 VSS.n12601 9.3005
R11477 VSS.n11997 VSS.n11996 9.3005
R11478 VSS.n12599 VSS.n12598 9.3005
R11479 VSS.n12597 VSS.n11998 9.3005
R11480 VSS.n12596 VSS.n12595 9.3005
R11481 VSS.n12587 VSS.n12000 9.3005
R11482 VSS.n12583 VSS.n12002 9.3005
R11483 VSS.n12585 VSS.n12584 9.3005
R11484 VSS.n12582 VSS.n12581 9.3005
R11485 VSS.n12006 VSS.n12005 9.3005
R11486 VSS.n12575 VSS.n12574 9.3005
R11487 VSS.n12573 VSS.n12007 9.3005
R11488 VSS.n12572 VSS.n12571 9.3005
R11489 VSS.n12570 VSS.n12008 9.3005
R11490 VSS.t4172 VSS.n12569 9.3005
R11491 VSS.n12568 VSS.n12009 9.3005
R11492 VSS.n12567 VSS.n12566 9.3005
R11493 VSS.n12562 VSS.n12561 9.3005
R11494 VSS.n12015 VSS.n12014 9.3005
R11495 VSS.n12555 VSS.n12554 9.3005
R11496 VSS.n12553 VSS.n12552 9.3005
R11497 VSS.n12551 VSS.n12018 9.3005
R11498 VSS.n12550 VSS.n12549 9.3005
R11499 VSS.n12547 VSS.n12546 9.3005
R11500 VSS.n12024 VSS.n12020 9.3005
R11501 VSS.n12539 VSS.n12538 9.3005
R11502 VSS.n12537 VSS.n12026 9.3005
R11503 VSS.n12536 VSS.n12535 9.3005
R11504 VSS.n12530 VSS.n12027 9.3005
R11505 VSS.n12529 VSS.n12528 9.3005
R11506 VSS.n12527 VSS.n12526 9.3005
R11507 VSS.n12525 VSS.n12028 9.3005
R11508 VSS.t4133 VSS.n12524 9.3005
R11509 VSS.n12523 VSS.n12029 9.3005
R11510 VSS.n12522 VSS.n12521 9.3005
R11511 VSS.n12031 VSS.n12030 9.3005
R11512 VSS.n12514 VSS.n12032 9.3005
R11513 VSS.n12516 VSS.n12515 9.3005
R11514 VSS.n12513 VSS.n12034 9.3005
R11515 VSS.n12512 VSS.n12511 9.3005
R11516 VSS.n12506 VSS.n12035 9.3005
R11517 VSS.n12505 VSS.n12504 9.3005
R11518 VSS.n12503 VSS.n12036 9.3005
R11519 VSS.n12502 VSS.n12501 9.3005
R11520 VSS.n12499 VSS.n12037 9.3005
R11521 VSS.n12498 VSS.n12497 9.3005
R11522 VSS.n12496 VSS.n12495 9.3005
R11523 VSS.n12039 VSS.n12038 9.3005
R11524 VSS.n12493 VSS.n12492 9.3005
R11525 VSS.n12491 VSS.n12040 9.3005
R11526 VSS.n12490 VSS.n12489 9.3005
R11527 VSS.n12481 VSS.n12042 9.3005
R11528 VSS.n12477 VSS.n12044 9.3005
R11529 VSS.n12479 VSS.n12478 9.3005
R11530 VSS.n12476 VSS.n12475 9.3005
R11531 VSS.n12048 VSS.n12047 9.3005
R11532 VSS.n12469 VSS.n12468 9.3005
R11533 VSS.n12467 VSS.n12049 9.3005
R11534 VSS.n12466 VSS.n12465 9.3005
R11535 VSS.n12464 VSS.n12050 9.3005
R11536 VSS.t4167 VSS.n12463 9.3005
R11537 VSS.n12462 VSS.n12051 9.3005
R11538 VSS.n12461 VSS.n12460 9.3005
R11539 VSS.n12456 VSS.n12455 9.3005
R11540 VSS.n12057 VSS.n12056 9.3005
R11541 VSS.n12449 VSS.n12448 9.3005
R11542 VSS.n12447 VSS.n12446 9.3005
R11543 VSS.n12445 VSS.n12060 9.3005
R11544 VSS.n12444 VSS.n12443 9.3005
R11545 VSS.n12441 VSS.n12440 9.3005
R11546 VSS.n12066 VSS.n12062 9.3005
R11547 VSS.n12433 VSS.n12432 9.3005
R11548 VSS.n12431 VSS.n12068 9.3005
R11549 VSS.n12430 VSS.n12429 9.3005
R11550 VSS.n12424 VSS.n12069 9.3005
R11551 VSS.n12423 VSS.n12422 9.3005
R11552 VSS.n12421 VSS.n12420 9.3005
R11553 VSS.n12419 VSS.n12070 9.3005
R11554 VSS.t4128 VSS.n12418 9.3005
R11555 VSS.n12417 VSS.n12071 9.3005
R11556 VSS.n12416 VSS.n12415 9.3005
R11557 VSS.n12073 VSS.n12072 9.3005
R11558 VSS.n12408 VSS.n12074 9.3005
R11559 VSS.n12410 VSS.n12409 9.3005
R11560 VSS.n12407 VSS.n12076 9.3005
R11561 VSS.n12406 VSS.n12405 9.3005
R11562 VSS.n12400 VSS.n12077 9.3005
R11563 VSS.n12399 VSS.n12398 9.3005
R11564 VSS.n12397 VSS.n12078 9.3005
R11565 VSS.n12396 VSS.n12395 9.3005
R11566 VSS.n12393 VSS.n12079 9.3005
R11567 VSS.n12392 VSS.n12391 9.3005
R11568 VSS.n12390 VSS.n12389 9.3005
R11569 VSS.n12081 VSS.n12080 9.3005
R11570 VSS.n12387 VSS.n12386 9.3005
R11571 VSS.n12385 VSS.n12082 9.3005
R11572 VSS.n12384 VSS.n12383 9.3005
R11573 VSS.n12375 VSS.n12084 9.3005
R11574 VSS.n12371 VSS.n12086 9.3005
R11575 VSS.n12373 VSS.n12372 9.3005
R11576 VSS.n12370 VSS.n12369 9.3005
R11577 VSS.n12090 VSS.n12089 9.3005
R11578 VSS.n12363 VSS.n12362 9.3005
R11579 VSS.n12361 VSS.n12091 9.3005
R11580 VSS.n12360 VSS.n12359 9.3005
R11581 VSS.n12358 VSS.n12092 9.3005
R11582 VSS.t4162 VSS.n12357 9.3005
R11583 VSS.n12356 VSS.n12093 9.3005
R11584 VSS.n12355 VSS.n12354 9.3005
R11585 VSS.n12350 VSS.n12349 9.3005
R11586 VSS.n12099 VSS.n12098 9.3005
R11587 VSS.n12343 VSS.n12342 9.3005
R11588 VSS.n12341 VSS.n12340 9.3005
R11589 VSS.n12339 VSS.n12102 9.3005
R11590 VSS.n12338 VSS.n12337 9.3005
R11591 VSS.n12335 VSS.n12334 9.3005
R11592 VSS.n12108 VSS.n12104 9.3005
R11593 VSS.n12327 VSS.n12326 9.3005
R11594 VSS.n12325 VSS.n12110 9.3005
R11595 VSS.n12324 VSS.n12323 9.3005
R11596 VSS.n12318 VSS.n12111 9.3005
R11597 VSS.n12317 VSS.n12316 9.3005
R11598 VSS.n12315 VSS.n12314 9.3005
R11599 VSS.n12313 VSS.n12112 9.3005
R11600 VSS.t4123 VSS.n12312 9.3005
R11601 VSS.n12311 VSS.n12113 9.3005
R11602 VSS.n12310 VSS.n12309 9.3005
R11603 VSS.n12115 VSS.n12114 9.3005
R11604 VSS.n12302 VSS.n12116 9.3005
R11605 VSS.n12304 VSS.n12303 9.3005
R11606 VSS.n12301 VSS.n12118 9.3005
R11607 VSS.n12300 VSS.n12299 9.3005
R11608 VSS.n12294 VSS.n12119 9.3005
R11609 VSS.n12293 VSS.n12292 9.3005
R11610 VSS.n12291 VSS.n12120 9.3005
R11611 VSS.n12290 VSS.n12289 9.3005
R11612 VSS.n12287 VSS.n12121 9.3005
R11613 VSS.n12286 VSS.n12285 9.3005
R11614 VSS.n12284 VSS.n12283 9.3005
R11615 VSS.n12123 VSS.n12122 9.3005
R11616 VSS.n12281 VSS.n12280 9.3005
R11617 VSS.n12279 VSS.n12124 9.3005
R11618 VSS.n12278 VSS.n12277 9.3005
R11619 VSS.n12269 VSS.n12126 9.3005
R11620 VSS.n12265 VSS.n12128 9.3005
R11621 VSS.n12267 VSS.n12266 9.3005
R11622 VSS.n12264 VSS.n12263 9.3005
R11623 VSS.n12132 VSS.n12131 9.3005
R11624 VSS.n12257 VSS.n12256 9.3005
R11625 VSS.n12255 VSS.n12133 9.3005
R11626 VSS.n12254 VSS.n12253 9.3005
R11627 VSS.n12252 VSS.n12134 9.3005
R11628 VSS.t4157 VSS.n12251 9.3005
R11629 VSS.n12250 VSS.n12135 9.3005
R11630 VSS.n12249 VSS.n12248 9.3005
R11631 VSS.n12244 VSS.n12243 9.3005
R11632 VSS.n12141 VSS.n12140 9.3005
R11633 VSS.n12237 VSS.n12236 9.3005
R11634 VSS.n12235 VSS.n12234 9.3005
R11635 VSS.n12233 VSS.n12144 9.3005
R11636 VSS.n12232 VSS.n12231 9.3005
R11637 VSS.n97 VSS.n233 2.25403
R11638 VSS.n24 VSS.n97 0.192834
R11639 VSS.n12150 VSS.n24 9.3005
R11640 VSS.n24 VSS.n74 4.07296
R11641 VSS.n12227 VSS.n24 9.3005
R11642 VSS.n24 VSS.n12226 9.3005
R11643 VSS.n43 VSS.n24 3.96704
R11644 VSS.n24 VSS.n12222 9.3005
R11645 VSS.n12221 VSS.n23 9.3005
R11646 VSS.t4118 VSS.n12220 9.3005
R11647 VSS.n12219 VSS.n12154 9.3005
R11648 VSS.n12218 VSS.n12217 9.3005
R11649 VSS.n12156 VSS.n12155 9.3005
R11650 VSS.n12210 VSS.n12157 9.3005
R11651 VSS.n12212 VSS.n12211 9.3005
R11652 VSS.n12209 VSS.n12170 9.3005
R11653 VSS.n12208 VSS.n12207 9.3005
R11654 VSS.n12202 VSS.n12171 9.3005
R11655 VSS.n12196 VSS.n12173 9.3005
R11656 VSS.n12198 VSS.n12197 9.3005
R11657 VSS.n12195 VSS.n12194 9.3005
R11658 VSS.n12190 VSS.n12176 9.3005
R11659 VSS.n12189 VSS.n12188 9.3005
R11660 VSS.n12187 VSS.n12186 9.3005
R11661 VSS.n12185 VSS.n12177 9.3005
R11662 VSS.t4153 VSS.n12184 9.3005
R11663 VSS.n12183 VSS.n12178 9.3005
R11664 VSS.n12182 VSS.n12181 9.3005
R11665 VSS.n12180 VSS.n12179 9.3005
R11666 VSS.n1598 VSS.n1597 9.3005
R11667 VSS.n1600 VSS.n1599 9.3005
R11668 VSS.n1591 VSS.n1588 9.3005
R11669 VSS.n1607 VSS.n1606 9.3005
R11670 VSS.n1608 VSS.n1587 9.3005
R11671 VSS.n1610 VSS.n1609 9.3005
R11672 VSS.n1611 VSS.n1586 9.3005
R11673 VSS.n1613 VSS.n1612 9.3005
R11674 VSS.n1614 VSS.n1585 9.3005
R11675 VSS.n1616 VSS.n1615 9.3005
R11676 VSS.n1617 VSS.n1584 9.3005
R11677 VSS.n1619 VSS.n1618 9.3005
R11678 VSS.n1620 VSS.n1583 9.3005
R11679 VSS.n1622 VSS.n1621 9.3005
R11680 VSS.n1577 VSS.n1574 9.3005
R11681 VSS.n1629 VSS.n1628 9.3005
R11682 VSS.n1630 VSS.n1573 9.3005
R11683 VSS.n1632 VSS.n1631 9.3005
R11684 VSS.n1633 VSS.n1572 9.3005
R11685 VSS.n1635 VSS.n1634 9.3005
R11686 VSS.n1636 VSS.n1571 9.3005
R11687 VSS.n1638 VSS.n1637 9.3005
R11688 VSS.n1639 VSS.n1569 9.3005
R11689 VSS.n1646 VSS.n1645 9.3005
R11690 VSS.n1647 VSS.n1567 9.3005
R11691 VSS.n1649 VSS.n1648 9.3005
R11692 VSS.n1650 VSS.n1566 9.3005
R11693 VSS.n168 VSS.n167 0.138245
R11694 VSS.n12925 VSS.n168 3.04638
R11695 VSS.n12925 VSS.n213 9.3005
R11696 VSS.n12928 VSS.n12927 9.3005
R11697 VSS.n12929 VSS.n1565 9.3005
R11698 VSS.n12931 VSS.n12930 9.3005
R11699 VSS.n12932 VSS.n1564 9.3005
R11700 VSS.n12936 VSS.n12935 9.3005
R11701 VSS.n1563 VSS.n1560 9.3005
R11702 VSS.n1556 VSS.n1554 9.3005
R11703 VSS.n12941 VSS.n12940 9.3005
R11704 VSS.n12943 VSS.n12942 9.3005
R11705 VSS.n1553 VSS.n1550 9.3005
R11706 VSS.n12945 VSS.n1548 9.3005
R11707 VSS.n12947 VSS.n12946 9.3005
R11708 VSS.n12948 VSS.n1547 9.3005
R11709 VSS.n12950 VSS.n12949 9.3005
R11710 VSS.n12951 VSS.n1546 9.3005
R11711 VSS.n12953 VSS.n12952 9.3005
R11712 VSS.n12955 VSS.n12954 9.3005
R11713 VSS.n12958 VSS.n1544 9.3005
R11714 VSS.n12960 VSS.n12959 9.3005
R11715 VSS.n12962 VSS.n12961 9.3005
R11716 VSS.n1542 VSS.n1539 9.3005
R11717 VSS.n12968 VSS.n12967 9.3005
R11718 VSS.n12970 VSS.n12969 9.3005
R11719 VSS.n1536 VSS.n1534 9.3005
R11720 VSS.n12977 VSS.n12976 9.3005
R11721 VSS.n12978 VSS.n1533 9.3005
R11722 VSS.n12980 VSS.n12979 9.3005
R11723 VSS.n12981 VSS.n1532 9.3005
R11724 VSS.n12983 VSS.n12982 9.3005
R11725 VSS.n12984 VSS.t4252 9.3005
R11726 VSS.n12986 VSS.n12985 9.3005
R11727 VSS.n12987 VSS.n1531 9.3005
R11728 VSS.n12995 VSS.n12994 9.3005
R11729 VSS.n12997 VSS.n12996 9.3005
R11730 VSS.n1527 VSS.n1524 9.3005
R11731 VSS.n13002 VSS.n1523 9.3005
R11732 VSS.n13004 VSS.n13003 9.3005
R11733 VSS.n13006 VSS.n13005 9.3005
R11734 VSS.n13015 VSS.n13014 9.3005
R11735 VSS.n13016 VSS.n1521 9.3005
R11736 VSS.n13018 VSS.n13017 9.3005
R11737 VSS.n1518 VSS.n1516 9.3005
R11738 VSS.n13025 VSS.n13024 9.3005
R11739 VSS.n13026 VSS.n1515 9.3005
R11740 VSS.n13028 VSS.n13027 9.3005
R11741 VSS.n13029 VSS.n1514 9.3005
R11742 VSS.n13031 VSS.n13030 9.3005
R11743 VSS.t4213 VSS.n13032 9.3005
R11744 VSS.n13033 VSS.n1513 9.3005
R11745 VSS.n13035 VSS.n13034 9.3005
R11746 VSS.n13037 VSS.n13036 9.3005
R11747 VSS.n1512 VSS.n1510 9.3005
R11748 VSS.n1506 VSS.n1504 9.3005
R11749 VSS.n13042 VSS.n13041 9.3005
R11750 VSS.n13044 VSS.n13043 9.3005
R11751 VSS.n1503 VSS.n1500 9.3005
R11752 VSS.n13046 VSS.n1498 9.3005
R11753 VSS.n13048 VSS.n13047 9.3005
R11754 VSS.n13049 VSS.n1497 9.3005
R11755 VSS.n13051 VSS.n13050 9.3005
R11756 VSS.n13052 VSS.n1496 9.3005
R11757 VSS.n13054 VSS.n13053 9.3005
R11758 VSS.n13056 VSS.n13055 9.3005
R11759 VSS.n13059 VSS.n1494 9.3005
R11760 VSS.n13061 VSS.n13060 9.3005
R11761 VSS.n13063 VSS.n13062 9.3005
R11762 VSS.n1492 VSS.n1489 9.3005
R11763 VSS.n13069 VSS.n13068 9.3005
R11764 VSS.n13071 VSS.n13070 9.3005
R11765 VSS.n1486 VSS.n1484 9.3005
R11766 VSS.n13078 VSS.n13077 9.3005
R11767 VSS.n13079 VSS.n1483 9.3005
R11768 VSS.n13081 VSS.n13080 9.3005
R11769 VSS.n13082 VSS.n1482 9.3005
R11770 VSS.n13084 VSS.n13083 9.3005
R11771 VSS.n13085 VSS.t4247 9.3005
R11772 VSS.n13087 VSS.n13086 9.3005
R11773 VSS.n13088 VSS.n1481 9.3005
R11774 VSS.n13096 VSS.n13095 9.3005
R11775 VSS.n13098 VSS.n13097 9.3005
R11776 VSS.n1477 VSS.n1474 9.3005
R11777 VSS.n13103 VSS.n1473 9.3005
R11778 VSS.n13105 VSS.n13104 9.3005
R11779 VSS.n13107 VSS.n13106 9.3005
R11780 VSS.n13116 VSS.n13115 9.3005
R11781 VSS.n13117 VSS.n1471 9.3005
R11782 VSS.n13119 VSS.n13118 9.3005
R11783 VSS.n1468 VSS.n1466 9.3005
R11784 VSS.n13126 VSS.n13125 9.3005
R11785 VSS.n13127 VSS.n1465 9.3005
R11786 VSS.n13129 VSS.n13128 9.3005
R11787 VSS.n13130 VSS.n1464 9.3005
R11788 VSS.n13132 VSS.n13131 9.3005
R11789 VSS.t4208 VSS.n13133 9.3005
R11790 VSS.n13134 VSS.n1463 9.3005
R11791 VSS.n13136 VSS.n13135 9.3005
R11792 VSS.n13138 VSS.n13137 9.3005
R11793 VSS.n1462 VSS.n1460 9.3005
R11794 VSS.n1456 VSS.n1454 9.3005
R11795 VSS.n13143 VSS.n13142 9.3005
R11796 VSS.n13145 VSS.n13144 9.3005
R11797 VSS.n1453 VSS.n1450 9.3005
R11798 VSS.n13147 VSS.n1448 9.3005
R11799 VSS.n13149 VSS.n13148 9.3005
R11800 VSS.n13150 VSS.n1447 9.3005
R11801 VSS.n13152 VSS.n13151 9.3005
R11802 VSS.n13153 VSS.n1446 9.3005
R11803 VSS.n13155 VSS.n13154 9.3005
R11804 VSS.n13157 VSS.n13156 9.3005
R11805 VSS.n13160 VSS.n1444 9.3005
R11806 VSS.n13162 VSS.n13161 9.3005
R11807 VSS.n13164 VSS.n13163 9.3005
R11808 VSS.n1442 VSS.n1439 9.3005
R11809 VSS.n13170 VSS.n13169 9.3005
R11810 VSS.n13172 VSS.n13171 9.3005
R11811 VSS.n1436 VSS.n1434 9.3005
R11812 VSS.n13179 VSS.n13178 9.3005
R11813 VSS.n13180 VSS.n1433 9.3005
R11814 VSS.n13182 VSS.n13181 9.3005
R11815 VSS.n13183 VSS.n1432 9.3005
R11816 VSS.n13185 VSS.n13184 9.3005
R11817 VSS.n13186 VSS.t4242 9.3005
R11818 VSS.n13188 VSS.n13187 9.3005
R11819 VSS.n13189 VSS.n1431 9.3005
R11820 VSS.n13197 VSS.n13196 9.3005
R11821 VSS.n13199 VSS.n13198 9.3005
R11822 VSS.n1427 VSS.n1424 9.3005
R11823 VSS.n13204 VSS.n1423 9.3005
R11824 VSS.n13206 VSS.n13205 9.3005
R11825 VSS.n13208 VSS.n13207 9.3005
R11826 VSS.n13217 VSS.n13216 9.3005
R11827 VSS.n13218 VSS.n1421 9.3005
R11828 VSS.n13220 VSS.n13219 9.3005
R11829 VSS.n1418 VSS.n1416 9.3005
R11830 VSS.n13227 VSS.n13226 9.3005
R11831 VSS.n13228 VSS.n1415 9.3005
R11832 VSS.n13230 VSS.n13229 9.3005
R11833 VSS.n13231 VSS.n1414 9.3005
R11834 VSS.n13233 VSS.n13232 9.3005
R11835 VSS.t4203 VSS.n13234 9.3005
R11836 VSS.n13235 VSS.n1413 9.3005
R11837 VSS.n13237 VSS.n13236 9.3005
R11838 VSS.n13239 VSS.n13238 9.3005
R11839 VSS.n1412 VSS.n1410 9.3005
R11840 VSS.n1406 VSS.n1404 9.3005
R11841 VSS.n13244 VSS.n13243 9.3005
R11842 VSS.n13246 VSS.n13245 9.3005
R11843 VSS.n1403 VSS.n1400 9.3005
R11844 VSS.n13248 VSS.n1398 9.3005
R11845 VSS.n13250 VSS.n13249 9.3005
R11846 VSS.n13251 VSS.n1397 9.3005
R11847 VSS.n13253 VSS.n13252 9.3005
R11848 VSS.n13254 VSS.n1396 9.3005
R11849 VSS.n13256 VSS.n13255 9.3005
R11850 VSS.n13258 VSS.n13257 9.3005
R11851 VSS.n13261 VSS.n1394 9.3005
R11852 VSS.n13263 VSS.n13262 9.3005
R11853 VSS.n13265 VSS.n13264 9.3005
R11854 VSS.n1392 VSS.n1389 9.3005
R11855 VSS.n13271 VSS.n13270 9.3005
R11856 VSS.n13273 VSS.n13272 9.3005
R11857 VSS.n1386 VSS.n1384 9.3005
R11858 VSS.n13280 VSS.n13279 9.3005
R11859 VSS.n13281 VSS.n1383 9.3005
R11860 VSS.n13283 VSS.n13282 9.3005
R11861 VSS.n13284 VSS.n1382 9.3005
R11862 VSS.n13286 VSS.n13285 9.3005
R11863 VSS.n13287 VSS.t4237 9.3005
R11864 VSS.n13289 VSS.n13288 9.3005
R11865 VSS.n13290 VSS.n1381 9.3005
R11866 VSS.n13298 VSS.n13297 9.3005
R11867 VSS.n13300 VSS.n13299 9.3005
R11868 VSS.n1377 VSS.n1374 9.3005
R11869 VSS.n13305 VSS.n1373 9.3005
R11870 VSS.n13307 VSS.n13306 9.3005
R11871 VSS.n13309 VSS.n13308 9.3005
R11872 VSS.n13318 VSS.n13317 9.3005
R11873 VSS.n13319 VSS.n1371 9.3005
R11874 VSS.n13321 VSS.n13320 9.3005
R11875 VSS.n1368 VSS.n1366 9.3005
R11876 VSS.n13328 VSS.n13327 9.3005
R11877 VSS.n13329 VSS.n1365 9.3005
R11878 VSS.n13331 VSS.n13330 9.3005
R11879 VSS.n13332 VSS.n1364 9.3005
R11880 VSS.n13334 VSS.n13333 9.3005
R11881 VSS.t4198 VSS.n13335 9.3005
R11882 VSS.n13336 VSS.n1363 9.3005
R11883 VSS.n13338 VSS.n13337 9.3005
R11884 VSS.n13340 VSS.n13339 9.3005
R11885 VSS.n1362 VSS.n1360 9.3005
R11886 VSS.n1356 VSS.n1354 9.3005
R11887 VSS.n13345 VSS.n13344 9.3005
R11888 VSS.n13347 VSS.n13346 9.3005
R11889 VSS.n1353 VSS.n1350 9.3005
R11890 VSS.n13349 VSS.n1348 9.3005
R11891 VSS.n13351 VSS.n13350 9.3005
R11892 VSS.n13352 VSS.n1347 9.3005
R11893 VSS.n13354 VSS.n13353 9.3005
R11894 VSS.n13355 VSS.n1346 9.3005
R11895 VSS.n13357 VSS.n13356 9.3005
R11896 VSS.n13359 VSS.n13358 9.3005
R11897 VSS.n13362 VSS.n1344 9.3005
R11898 VSS.n13364 VSS.n13363 9.3005
R11899 VSS.n13366 VSS.n13365 9.3005
R11900 VSS.n1342 VSS.n1339 9.3005
R11901 VSS.n13372 VSS.n13371 9.3005
R11902 VSS.n13374 VSS.n13373 9.3005
R11903 VSS.n1336 VSS.n1334 9.3005
R11904 VSS.n13381 VSS.n13380 9.3005
R11905 VSS.n13382 VSS.n1333 9.3005
R11906 VSS.n13384 VSS.n13383 9.3005
R11907 VSS.n13385 VSS.n1332 9.3005
R11908 VSS.n13387 VSS.n13386 9.3005
R11909 VSS.n13388 VSS.t4232 9.3005
R11910 VSS.n13390 VSS.n13389 9.3005
R11911 VSS.n13391 VSS.n1331 9.3005
R11912 VSS.n13399 VSS.n13398 9.3005
R11913 VSS.n13401 VSS.n13400 9.3005
R11914 VSS.n1327 VSS.n1324 9.3005
R11915 VSS.n13406 VSS.n1323 9.3005
R11916 VSS.n13408 VSS.n13407 9.3005
R11917 VSS.n13410 VSS.n13409 9.3005
R11918 VSS.n13419 VSS.n13418 9.3005
R11919 VSS.n13420 VSS.n1321 9.3005
R11920 VSS.n13422 VSS.n13421 9.3005
R11921 VSS.n1318 VSS.n1316 9.3005
R11922 VSS.n13429 VSS.n13428 9.3005
R11923 VSS.n13430 VSS.n1315 9.3005
R11924 VSS.n13432 VSS.n13431 9.3005
R11925 VSS.n13433 VSS.n1314 9.3005
R11926 VSS.n13435 VSS.n13434 9.3005
R11927 VSS.t4193 VSS.n13436 9.3005
R11928 VSS.n13437 VSS.n1313 9.3005
R11929 VSS.n13439 VSS.n13438 9.3005
R11930 VSS.n13441 VSS.n13440 9.3005
R11931 VSS.n1312 VSS.n1310 9.3005
R11932 VSS.n1306 VSS.n1304 9.3005
R11933 VSS.n13446 VSS.n13445 9.3005
R11934 VSS.n13448 VSS.n13447 9.3005
R11935 VSS.n1303 VSS.n1300 9.3005
R11936 VSS.n13450 VSS.n1298 9.3005
R11937 VSS.n13452 VSS.n13451 9.3005
R11938 VSS.n13453 VSS.n1297 9.3005
R11939 VSS.n13455 VSS.n13454 9.3005
R11940 VSS.n13456 VSS.n1296 9.3005
R11941 VSS.n13458 VSS.n13457 9.3005
R11942 VSS.n13460 VSS.n13459 9.3005
R11943 VSS.n13463 VSS.n1294 9.3005
R11944 VSS.n13465 VSS.n13464 9.3005
R11945 VSS.n13467 VSS.n13466 9.3005
R11946 VSS.n1292 VSS.n1289 9.3005
R11947 VSS.n13473 VSS.n13472 9.3005
R11948 VSS.n13475 VSS.n13474 9.3005
R11949 VSS.n1286 VSS.n1284 9.3005
R11950 VSS.n13482 VSS.n13481 9.3005
R11951 VSS.n13483 VSS.n1283 9.3005
R11952 VSS.n13485 VSS.n13484 9.3005
R11953 VSS.n13486 VSS.n1282 9.3005
R11954 VSS.n13488 VSS.n13487 9.3005
R11955 VSS.t4227 VSS.n13489 9.3005
R11956 VSS.n13490 VSS.n1281 9.3005
R11957 VSS.n13492 VSS.n13491 9.3005
R11958 VSS.n13514 VSS.n13513 9.3005
R11959 VSS.n13497 VSS.n13496 9.3005
R11960 VSS.n13507 VSS.n13506 9.3005
R11961 VSS.n13505 VSS.n13504 9.3005
R11962 VSS.n13503 VSS.n13500 9.3005
R11963 VSS.n13502 VSS.n13501 9.3005
R11964 VSS.n98 VSS.n13583 2.25403
R11965 VSS.n98 VSS.n26 0.192834
R11966 VSS.n1271 VSS.n26 9.3005
R11967 VSS.n26 VSS.n73 4.07296
R11968 VSS.n26 VSS.n66 9.3005
R11969 VSS.n26 VSS.n13576 9.3005
R11970 VSS.n42 VSS.n26 3.96704
R11971 VSS.n26 VSS.n13571 9.3005
R11972 VSS.n13570 VSS.n25 9.3005
R11973 VSS.t4188 VSS.n13569 9.3005
R11974 VSS.n13568 VSS.n1275 9.3005
R11975 VSS.n13567 VSS.n13566 9.3005
R11976 VSS.n1277 VSS.n1276 9.3005
R11977 VSS.n13559 VSS.n1278 9.3005
R11978 VSS.n13561 VSS.n13560 9.3005
R11979 VSS.n13558 VSS.n13519 9.3005
R11980 VSS.n13557 VSS.n13556 9.3005
R11981 VSS.n13551 VSS.n13520 9.3005
R11982 VSS.n13545 VSS.n13522 9.3005
R11983 VSS.n13547 VSS.n13546 9.3005
R11984 VSS.n13544 VSS.n13543 9.3005
R11985 VSS.n13539 VSS.n13525 9.3005
R11986 VSS.n13538 VSS.n13537 9.3005
R11987 VSS.n13536 VSS.n13535 9.3005
R11988 VSS.n13534 VSS.n13526 9.3005
R11989 VSS.t4223 VSS.n13533 9.3005
R11990 VSS.n13532 VSS.n13527 9.3005
R11991 VSS.n13531 VSS.n13530 9.3005
R11992 VSS.n13529 VSS.n13528 9.3005
R11993 VSS.n13880 VSS.n13879 9.3005
R11994 VSS.n13882 VSS.n13881 9.3005
R11995 VSS.n13873 VSS.n13870 9.3005
R11996 VSS.n13889 VSS.n13888 9.3005
R11997 VSS.n13890 VSS.n13869 9.3005
R11998 VSS.n13892 VSS.n13891 9.3005
R11999 VSS.n13893 VSS.n13868 9.3005
R12000 VSS.n13895 VSS.n13894 9.3005
R12001 VSS.n13896 VSS.n13867 9.3005
R12002 VSS.n13898 VSS.n13897 9.3005
R12003 VSS.n13899 VSS.n13866 9.3005
R12004 VSS.n13901 VSS.n13900 9.3005
R12005 VSS.n13902 VSS.n13865 9.3005
R12006 VSS.n13904 VSS.n13903 9.3005
R12007 VSS.n13859 VSS.n13856 9.3005
R12008 VSS.n13911 VSS.n13910 9.3005
R12009 VSS.n13912 VSS.n13855 9.3005
R12010 VSS.n13914 VSS.n13913 9.3005
R12011 VSS.n13915 VSS.n13854 9.3005
R12012 VSS.n13917 VSS.n13916 9.3005
R12013 VSS.n13918 VSS.n13853 9.3005
R12014 VSS.n13920 VSS.n13919 9.3005
R12015 VSS.n13921 VSS.n13851 9.3005
R12016 VSS.n13928 VSS.n13927 9.3005
R12017 VSS.n13929 VSS.n13849 9.3005
R12018 VSS.n13931 VSS.n13930 9.3005
R12019 VSS.n13932 VSS.n13848 9.3005
R12020 VSS.n165 VSS.n164 0.138245
R12021 VSS.n13934 VSS.n165 3.04638
R12022 VSS.n13934 VSS.n215 9.3005
R12023 VSS.n13937 VSS.n13936 9.3005
R12024 VSS.n13938 VSS.n13847 9.3005
R12025 VSS.n13940 VSS.n13939 9.3005
R12026 VSS.n13941 VSS.n13846 9.3005
R12027 VSS.n13945 VSS.n13944 9.3005
R12028 VSS.n13845 VSS.n13842 9.3005
R12029 VSS.n13838 VSS.n13836 9.3005
R12030 VSS.n13950 VSS.n13949 9.3005
R12031 VSS.n13952 VSS.n13951 9.3005
R12032 VSS.n13835 VSS.n13832 9.3005
R12033 VSS.n13954 VSS.n13830 9.3005
R12034 VSS.n13956 VSS.n13955 9.3005
R12035 VSS.n13957 VSS.n13829 9.3005
R12036 VSS.n13959 VSS.n13958 9.3005
R12037 VSS.n13960 VSS.n13828 9.3005
R12038 VSS.n13962 VSS.n13961 9.3005
R12039 VSS.n13964 VSS.n13963 9.3005
R12040 VSS.n13967 VSS.n13826 9.3005
R12041 VSS.n13969 VSS.n13968 9.3005
R12042 VSS.n13971 VSS.n13970 9.3005
R12043 VSS.n13824 VSS.n13821 9.3005
R12044 VSS.n13977 VSS.n13976 9.3005
R12045 VSS.n13979 VSS.n13978 9.3005
R12046 VSS.n13818 VSS.n13816 9.3005
R12047 VSS.n13986 VSS.n13985 9.3005
R12048 VSS.n13987 VSS.n13815 9.3005
R12049 VSS.n13989 VSS.n13988 9.3005
R12050 VSS.n13990 VSS.n13814 9.3005
R12051 VSS.n13992 VSS.n13991 9.3005
R12052 VSS.n13993 VSS.t4316 9.3005
R12053 VSS.n13995 VSS.n13994 9.3005
R12054 VSS.n13996 VSS.n13813 9.3005
R12055 VSS.n14004 VSS.n14003 9.3005
R12056 VSS.n14006 VSS.n14005 9.3005
R12057 VSS.n13809 VSS.n13806 9.3005
R12058 VSS.n14011 VSS.n13805 9.3005
R12059 VSS.n14013 VSS.n14012 9.3005
R12060 VSS.n14015 VSS.n14014 9.3005
R12061 VSS.n14024 VSS.n14023 9.3005
R12062 VSS.n14025 VSS.n13803 9.3005
R12063 VSS.n14027 VSS.n14026 9.3005
R12064 VSS.n13800 VSS.n13798 9.3005
R12065 VSS.n14034 VSS.n14033 9.3005
R12066 VSS.n14035 VSS.n13797 9.3005
R12067 VSS.n14037 VSS.n14036 9.3005
R12068 VSS.n14038 VSS.n13796 9.3005
R12069 VSS.n14040 VSS.n14039 9.3005
R12070 VSS.t4282 VSS.n14041 9.3005
R12071 VSS.n14042 VSS.n13795 9.3005
R12072 VSS.n14044 VSS.n14043 9.3005
R12073 VSS.n14046 VSS.n14045 9.3005
R12074 VSS.n13794 VSS.n13792 9.3005
R12075 VSS.n13788 VSS.n13786 9.3005
R12076 VSS.n14051 VSS.n14050 9.3005
R12077 VSS.n14053 VSS.n14052 9.3005
R12078 VSS.n13785 VSS.n13782 9.3005
R12079 VSS.n14055 VSS.n13780 9.3005
R12080 VSS.n14057 VSS.n14056 9.3005
R12081 VSS.n14058 VSS.n13779 9.3005
R12082 VSS.n14060 VSS.n14059 9.3005
R12083 VSS.n14061 VSS.n13778 9.3005
R12084 VSS.n14063 VSS.n14062 9.3005
R12085 VSS.n14065 VSS.n14064 9.3005
R12086 VSS.n14068 VSS.n13776 9.3005
R12087 VSS.n14070 VSS.n14069 9.3005
R12088 VSS.n14072 VSS.n14071 9.3005
R12089 VSS.n13774 VSS.n13771 9.3005
R12090 VSS.n14078 VSS.n14077 9.3005
R12091 VSS.n14080 VSS.n14079 9.3005
R12092 VSS.n13768 VSS.n13766 9.3005
R12093 VSS.n14087 VSS.n14086 9.3005
R12094 VSS.n14088 VSS.n13765 9.3005
R12095 VSS.n14090 VSS.n14089 9.3005
R12096 VSS.n14091 VSS.n13764 9.3005
R12097 VSS.n14093 VSS.n14092 9.3005
R12098 VSS.n14094 VSS.t4311 9.3005
R12099 VSS.n14096 VSS.n14095 9.3005
R12100 VSS.n14097 VSS.n13763 9.3005
R12101 VSS.n14105 VSS.n14104 9.3005
R12102 VSS.n14107 VSS.n14106 9.3005
R12103 VSS.n13759 VSS.n13756 9.3005
R12104 VSS.n14112 VSS.n13755 9.3005
R12105 VSS.n14114 VSS.n14113 9.3005
R12106 VSS.n14116 VSS.n14115 9.3005
R12107 VSS.n14125 VSS.n14124 9.3005
R12108 VSS.n14126 VSS.n13753 9.3005
R12109 VSS.n14128 VSS.n14127 9.3005
R12110 VSS.n13750 VSS.n13748 9.3005
R12111 VSS.n14135 VSS.n14134 9.3005
R12112 VSS.n14136 VSS.n13747 9.3005
R12113 VSS.n14138 VSS.n14137 9.3005
R12114 VSS.n14139 VSS.n13746 9.3005
R12115 VSS.n14141 VSS.n14140 9.3005
R12116 VSS.t4277 VSS.n14142 9.3005
R12117 VSS.n14143 VSS.n13745 9.3005
R12118 VSS.n14145 VSS.n14144 9.3005
R12119 VSS.n14147 VSS.n14146 9.3005
R12120 VSS.n14210 VSS.n13743 9.3005
R12121 VSS.n14212 VSS.n14211 9.3005
R12122 VSS.n14214 VSS.n14213 9.3005
R12123 VSS.n14202 VSS.n13742 9.3005
R12124 VSS.n14198 VSS.n14148 9.3005
R12125 VSS.n14200 VSS.n14199 9.3005
R12126 VSS.n14197 VSS.n14196 9.3005
R12127 VSS.n14152 VSS.n14151 9.3005
R12128 VSS.n14190 VSS.n14189 9.3005
R12129 VSS.n14188 VSS.n14153 9.3005
R12130 VSS.n14187 VSS.n14186 9.3005
R12131 VSS.n14185 VSS.n14154 9.3005
R12132 VSS.t4307 VSS.n14184 9.3005
R12133 VSS.n14183 VSS.n14155 9.3005
R12134 VSS.n14182 VSS.n14181 9.3005
R12135 VSS.n14178 VSS.n14177 9.3005
R12136 VSS.n14176 VSS.n14175 9.3005
R12137 VSS.t109 VSS.n129 9.3005
R12138 VSS.n14169 VSS.n14168 9.3005
R12139 VSS.n14167 VSS.t84 9.3005
R12140 VSS.n14166 VSS.n14165 9.3005
R12141 VSS.n14164 VSS.n14159 9.3005
R12142 VSS.n14217 VSS.n13738 9.3005
R12143 VSS.n14221 VSS.n14220 9.3005
R12144 VSS.n13735 VSS.n13733 9.3005
R12145 VSS.n14228 VSS.n14227 9.3005
R12146 VSS.n14229 VSS.n13732 9.3005
R12147 VSS.n14231 VSS.n14230 9.3005
R12148 VSS.n14232 VSS.n13731 9.3005
R12149 VSS.n14234 VSS.n14233 9.3005
R12150 VSS.n14235 VSS.n13730 9.3005
R12151 VSS.n14237 VSS.n14236 9.3005
R12152 VSS.n14238 VSS.n13729 9.3005
R12153 VSS.n14240 VSS.n14239 9.3005
R12154 VSS.n14242 VSS.n14241 9.3005
R12155 VSS.n14243 VSS.n13728 9.3005
R12156 VSS.n14245 VSS.n14244 9.3005
R12157 VSS.n14247 VSS.n14246 9.3005
R12158 VSS.n14248 VSS.n13727 9.3005
R12159 VSS.n14250 VSS.n14249 9.3005
R12160 VSS.n14252 VSS.n14251 9.3005
R12161 VSS.n13726 VSS.n13724 9.3005
R12162 VSS.n14256 VSS.n13723 9.3005
R12163 VSS.n14258 VSS.n14257 9.3005
R12164 VSS.n14259 VSS.n13722 9.3005
R12165 VSS.n14261 VSS.n14260 9.3005
R12166 VSS.n14262 VSS.n13721 9.3005
R12167 VSS.n14263 VSS.t266 9.3005
R12168 VSS.n14264 VSS.n13720 9.3005
R12169 VSS.n14266 VSS.n14265 9.3005
R12170 VSS.t4304 VSS.n13719 9.3005
R12171 VSS.n14270 VSS.n14269 9.3005
R12172 VSS.n14272 VSS.n14271 9.3005
R12173 VSS.n13718 VSS.n13715 9.3005
R12174 VSS.n13714 VSS.n13713 9.3005
R12175 VSS.n14277 VSS.n14276 9.3005
R12176 VSS.n14278 VSS.n13712 9.3005
R12177 VSS.n14280 VSS.n14279 9.3005
R12178 VSS.n14281 VSS.n13711 9.3005
R12179 VSS.n14283 VSS.n14282 9.3005
R12180 VSS.n14284 VSS.n13710 9.3005
R12181 VSS.t197 VSS.n14285 9.3005
R12182 VSS.n14286 VSS.n13709 9.3005
R12183 VSS.n14288 VSS.n14287 9.3005
R12184 VSS.n14289 VSS.n13708 9.3005
R12185 VSS.t227 VSS.n14290 9.3005
R12186 VSS.n14291 VSS.n13707 9.3005
R12187 VSS.n14293 VSS.n14292 9.3005
R12188 VSS.n14295 VSS.n14294 9.3005
R12189 VSS.n14298 VSS.n13706 9.3005
R12190 VSS.n14300 VSS.n14299 9.3005
R12191 VSS.n14302 VSS.n14301 9.3005
R12192 VSS.n13705 VSS.n13702 9.3005
R12193 VSS.n14307 VSS.n13701 9.3005
R12194 VSS.n14309 VSS.n14308 9.3005
R12195 VSS.n14310 VSS.n13668 9.3005
R12196 VSS.n14312 VSS.n14311 9.3005
R12197 VSS.n13694 VSS.n13693 9.3005
R12198 VSS.n13692 VSS.n13691 9.3005
R12199 VSS.n13690 VSS.n13671 9.3005
R12200 VSS.n13684 VSS.n13675 9.3005
R12201 VSS.n13683 VSS.n13682 9.3005
R12202 VSS.n13681 VSS.n13676 9.3005
R12203 VSS.n13680 VSS.n13679 9.3005
R12204 VSS.n13678 VSS.n13677 9.3005
R12205 VSS.n13667 VSS.n13666 9.3005
R12206 VSS.n14316 VSS.n14315 9.3005
R12207 VSS.n217 VSS.n14317 9.3005
R12208 VSS.n14320 VSS.n13665 9.3005
R12209 VSS.n14322 VSS.n14321 9.3005
R12210 VSS.n14324 VSS.n14323 9.3005
R12211 VSS.n13664 VSS.n13661 9.3005
R12212 VSS.n14329 VSS.n13660 9.3005
R12213 VSS.n14331 VSS.n14330 9.3005
R12214 VSS.n14332 VSS.n13659 9.3005
R12215 VSS.n14334 VSS.n14333 9.3005
R12216 VSS.n14335 VSS.n13658 9.3005
R12217 VSS.n14337 VSS.n14336 9.3005
R12218 VSS.n14338 VSS.n13657 9.3005
R12219 VSS.n14340 VSS.n14339 9.3005
R12220 VSS.t232 VSS.n13654 9.3005
R12221 VSS.n14343 VSS.n14342 9.3005
R12222 VSS.n13651 VSS.n13649 9.3005
R12223 VSS.n14351 VSS.n14350 9.3005
R12224 VSS.n14352 VSS.n13648 9.3005
R12225 VSS.n14354 VSS.n14353 9.3005
R12226 VSS.n14355 VSS.n13647 9.3005
R12227 VSS.n14357 VSS.n14356 9.3005
R12228 VSS.n14360 VSS.n14359 9.3005
R12229 VSS.n14364 VSS.n14363 9.3005
R12230 VSS.n14366 VSS.n14365 9.3005
R12231 VSS.n13642 VSS.n13639 9.3005
R12232 VSS.n14371 VSS.n13638 9.3005
R12233 VSS.n14373 VSS.n14372 9.3005
R12234 VSS.n14375 VSS.n14374 9.3005
R12235 VSS.n14384 VSS.n14383 9.3005
R12236 VSS.n14385 VSS.n13636 9.3005
R12237 VSS.n14387 VSS.n14386 9.3005
R12238 VSS.n13633 VSS.n13631 9.3005
R12239 VSS.n14394 VSS.n14393 9.3005
R12240 VSS.n14395 VSS.n13630 9.3005
R12241 VSS.n14397 VSS.n14396 9.3005
R12242 VSS.n14398 VSS.n13629 9.3005
R12243 VSS.n14400 VSS.n14399 9.3005
R12244 VSS.t4263 VSS.n14401 9.3005
R12245 VSS.n14402 VSS.n13628 9.3005
R12246 VSS.n14404 VSS.n14403 9.3005
R12247 VSS.n14406 VSS.n14405 9.3005
R12248 VSS.n13627 VSS.n13625 9.3005
R12249 VSS.n13621 VSS.n13619 9.3005
R12250 VSS.n14411 VSS.n14410 9.3005
R12251 VSS.n14413 VSS.n14412 9.3005
R12252 VSS.n13618 VSS.n13615 9.3005
R12253 VSS.n14415 VSS.n13613 9.3005
R12254 VSS.n14417 VSS.n14416 9.3005
R12255 VSS.n14418 VSS.n13612 9.3005
R12256 VSS.n14420 VSS.n14419 9.3005
R12257 VSS.n14421 VSS.n13611 9.3005
R12258 VSS.n14423 VSS.n14422 9.3005
R12259 VSS.n14425 VSS.n14424 9.3005
R12260 VSS.n14428 VSS.n13609 9.3005
R12261 VSS.n14430 VSS.n14429 9.3005
R12262 VSS.n14432 VSS.n14431 9.3005
R12263 VSS.n13607 VSS.n13604 9.3005
R12264 VSS.n14438 VSS.n14437 9.3005
R12265 VSS.n14440 VSS.n14439 9.3005
R12266 VSS.n13601 VSS.n13599 9.3005
R12267 VSS.n14447 VSS.n14446 9.3005
R12268 VSS.n14448 VSS.n13598 9.3005
R12269 VSS.n14450 VSS.n14449 9.3005
R12270 VSS.n14451 VSS.n13597 9.3005
R12271 VSS.n14453 VSS.n14452 9.3005
R12272 VSS.t4296 VSS.n14454 9.3005
R12273 VSS.n14455 VSS.n13596 9.3005
R12274 VSS.n14457 VSS.n14456 9.3005
R12275 VSS.n14479 VSS.n14478 9.3005
R12276 VSS.n14462 VSS.n14461 9.3005
R12277 VSS.n14472 VSS.n14471 9.3005
R12278 VSS.n14470 VSS.n14469 9.3005
R12279 VSS.n14468 VSS.n14465 9.3005
R12280 VSS.n14467 VSS.n14466 9.3005
R12281 VSS.n99 VSS.n14548 2.25403
R12282 VSS.n99 VSS.n28 0.192834
R12283 VSS.n13586 VSS.n28 9.3005
R12284 VSS.n28 VSS.n72 4.07296
R12285 VSS.n28 VSS.n67 9.3005
R12286 VSS.n28 VSS.n14541 9.3005
R12287 VSS.n41 VSS.n28 3.96704
R12288 VSS.n28 VSS.n14536 9.3005
R12289 VSS.n14535 VSS.n27 9.3005
R12290 VSS.t4258 VSS.n14534 9.3005
R12291 VSS.n14533 VSS.n13590 9.3005
R12292 VSS.n14532 VSS.n14531 9.3005
R12293 VSS.n13592 VSS.n13591 9.3005
R12294 VSS.n14524 VSS.n13593 9.3005
R12295 VSS.n14526 VSS.n14525 9.3005
R12296 VSS.n14523 VSS.n14484 9.3005
R12297 VSS.n14522 VSS.n14521 9.3005
R12298 VSS.n14516 VSS.n14485 9.3005
R12299 VSS.n14510 VSS.n14487 9.3005
R12300 VSS.n14512 VSS.n14511 9.3005
R12301 VSS.n14509 VSS.n14508 9.3005
R12302 VSS.n14504 VSS.n14490 9.3005
R12303 VSS.n14503 VSS.n14502 9.3005
R12304 VSS.n14501 VSS.n14500 9.3005
R12305 VSS.n14499 VSS.n14491 9.3005
R12306 VSS.t4292 VSS.n14498 9.3005
R12307 VSS.n14497 VSS.n14492 9.3005
R12308 VSS.n14496 VSS.n14495 9.3005
R12309 VSS.n14494 VSS.n14493 9.3005
R12310 VSS.n15176 VSS.n15175 9.3005
R12311 VSS.n15178 VSS.n15177 9.3005
R12312 VSS.n15169 VSS.n15166 9.3005
R12313 VSS.n15185 VSS.n15184 9.3005
R12314 VSS.n15186 VSS.n15165 9.3005
R12315 VSS.n15188 VSS.n15187 9.3005
R12316 VSS.n15189 VSS.n15164 9.3005
R12317 VSS.n15191 VSS.n15190 9.3005
R12318 VSS.n15192 VSS.n15163 9.3005
R12319 VSS.n15194 VSS.n15193 9.3005
R12320 VSS.n15195 VSS.n15162 9.3005
R12321 VSS.n15197 VSS.n15196 9.3005
R12322 VSS.n15198 VSS.n15161 9.3005
R12323 VSS.n15200 VSS.n15199 9.3005
R12324 VSS.n15155 VSS.n15152 9.3005
R12325 VSS.n15207 VSS.n15206 9.3005
R12326 VSS.n15208 VSS.n15151 9.3005
R12327 VSS.n15210 VSS.n15209 9.3005
R12328 VSS.n15211 VSS.n15150 9.3005
R12329 VSS.n15213 VSS.n15212 9.3005
R12330 VSS.n15214 VSS.n15149 9.3005
R12331 VSS.n15216 VSS.n15215 9.3005
R12332 VSS.n15217 VSS.n15148 9.3005
R12333 VSS.n15219 VSS.n15218 9.3005
R12334 VSS.n15221 VSS.n15220 9.3005
R12335 VSS.n15147 VSS.n15137 9.3005
R12336 VSS.n15146 VSS.n15145 9.3005
R12337 VSS.t147 VSS.n15138 9.3005
R12338 VSS.n15144 VSS.n15143 9.3005
R12339 VSS.n15142 VSS.n15139 9.3005
R12340 VSS.n4 VSS.n15141 9.3005
R12341 VSS.t3380 VSS.n39 7.33237
R12342 VSS.n4 VSS.n39 0.293843
R12343 VSS.n4 VSS.n58 2.12024
R12344 VSS.n15140 VSS.n4 9.3005
R12345 VSS.n4 VSS.n15239 9.3005
R12346 VSS.n15235 VSS.n4 9.3005
R12347 VSS.n15234 VSS.n4 9.3005
R12348 VSS.n4 VSS.n216 9.3005
R12349 VSS.n15229 VSS.n4 9.3005
R12350 VSS.n34 VSS.n4 0.304772
R12351 VSS.n15228 VSS.n33 9.3005
R12352 VSS.n15225 VSS.n15224 9.3005
R12353 VSS.n304 VSS.n303 9.3005
R12354 VSS.n15095 VSS.n15094 9.3005
R12355 VSS.n15097 VSS.n15096 9.3005
R12356 VSS.n15098 VSS.n15093 9.3005
R12357 VSS.n15100 VSS.n15099 9.3005
R12358 VSS.n15101 VSS.n15092 9.3005
R12359 VSS.n15102 VSS.t193 9.3005
R12360 VSS.n15103 VSS.t48 9.3005
R12361 VSS.t3366 VSS.n15104 9.3005
R12362 VSS.n15105 VSS.n15091 9.3005
R12363 VSS.n15107 VSS.n15106 9.3005
R12364 VSS.n15108 VSS.n15090 9.3005
R12365 VSS.t484 VSS.n15109 9.3005
R12366 VSS.n15112 VSS.n15089 9.3005
R12367 VSS.n15114 VSS.n15113 9.3005
R12368 VSS.n15116 VSS.n15115 9.3005
R12369 VSS.n15088 VSS.n15086 9.3005
R12370 VSS.n15120 VSS.n15084 9.3005
R12371 VSS.n15122 VSS.n15121 9.3005
R12372 VSS.n15123 VSS.n15083 9.3005
R12373 VSS.n15125 VSS.n15124 9.3005
R12374 VSS.n15126 VSS.n15082 9.3005
R12375 VSS.n15128 VSS.n15127 9.3005
R12376 VSS.n15081 VSS.n15129 9.3005
R12377 VSS.n15130 VSS.n15080 9.3005
R12378 VSS.n15132 VSS.n15131 9.3005
R12379 VSS.n15134 VSS.n15133 9.3005
R12380 VSS.n15135 VSS.n15079 9.3005
R12381 VSS.n15078 VSS.n305 9.3005
R12382 VSS.n15077 VSS.n15076 9.3005
R12383 VSS.n15075 VSS.n306 9.3005
R12384 VSS.t487 VSS.n15074 9.3005
R12385 VSS.n15073 VSS.n307 9.3005
R12386 VSS.n15072 VSS.n15071 9.3005
R12387 VSS.n15070 VSS.n308 9.3005
R12388 VSS.n15069 VSS.n15068 9.3005
R12389 VSS.n15067 VSS.n15066 9.3005
R12390 VSS.n15065 VSS.n309 9.3005
R12391 VSS.t52 VSS.n15064 9.3005
R12392 VSS.n15063 VSS.n310 9.3005
R12393 VSS.n15062 VSS.n15061 9.3005
R12394 VSS.n15060 VSS.n311 9.3005
R12395 VSS.n15054 VSS.n312 9.3005
R12396 VSS.n15056 VSS.n15055 9.3005
R12397 VSS.n15053 VSS.n15052 9.3005
R12398 VSS.n15051 VSS.n314 9.3005
R12399 VSS.n15050 VSS.n15049 9.3005
R12400 VSS.n15048 VSS.n315 9.3005
R12401 VSS.n15047 VSS.n15046 9.3005
R12402 VSS.n15045 VSS.n316 9.3005
R12403 VSS.n15042 VSS.t125 9.3005
R12404 VSS.n15041 VSS.n318 9.3005
R12405 VSS.n15009 VSS.t154 9.3005
R12406 VSS.t191 VSS.n15010 9.3005
R12407 VSS.t151 VSS.n15008 9.3005
R12408 VSS.n15011 VSS.t3403 9.3005
R12409 VSS.n15012 VSS.t220 9.3005
R12410 VSS.n15014 VSS.n15013 9.3005
R12411 VSS.t217 VSS.n15007 9.3005
R12412 VSS.n15016 VSS.n15015 9.3005
R12413 VSS.n15017 VSS.n15006 9.3005
R12414 VSS.n15019 VSS.n15018 9.3005
R12415 VSS.n15020 VSS.n15005 9.3005
R12416 VSS.n15022 VSS.n15021 9.3005
R12417 VSS.t59 VSS.n15023 9.3005
R12418 VSS.t116 VSS.n15004 9.3005
R12419 VSS.n15025 VSS.n15024 9.3005
R12420 VSS.n15026 VSS.t3303 9.3005
R12421 VSS.n15029 VSS.n15028 9.3005
R12422 VSS.n15030 VSS.n15002 9.3005
R12423 VSS.n15032 VSS.n15031 9.3005
R12424 VSS.n15033 VSS.n15001 9.3005
R12425 VSS.n15035 VSS.n15034 9.3005
R12426 VSS.n15036 VSS.n195 9.3005
R12427 VSS.n15038 VSS.n15037 9.3005
R12428 VSS.n15000 VSS.n14999 9.3005
R12429 VSS.n320 VSS.n319 9.3005
R12430 VSS.n14995 VSS.n14994 9.3005
R12431 VSS.n14993 VSS.n14992 9.3005
R12432 VSS.n14985 VSS.n324 9.3005
R12433 VSS.n14984 VSS.n14983 9.3005
R12434 VSS.n14982 VSS.n325 9.3005
R12435 VSS.n14981 VSS.n14980 9.3005
R12436 VSS.n14979 VSS.n326 9.3005
R12437 VSS.n14978 VSS.n14977 9.3005
R12438 VSS.n14976 VSS.n14975 9.3005
R12439 VSS.n14974 VSS.n327 9.3005
R12440 VSS.n14968 VSS.n328 9.3005
R12441 VSS.n14970 VSS.n14969 9.3005
R12442 VSS.n14967 VSS.n331 9.3005
R12443 VSS.n14966 VSS.n14965 9.3005
R12444 VSS.n14957 VSS.n332 9.3005
R12445 VSS.n14956 VSS.n14955 9.3005
R12446 VSS.n14954 VSS.n333 9.3005
R12447 VSS.n14953 VSS.n14952 9.3005
R12448 VSS.n14951 VSS.n334 9.3005
R12449 VSS.n14950 VSS.n14949 9.3005
R12450 VSS.n14948 VSS.n14947 9.3005
R12451 VSS.n14946 VSS.n335 9.3005
R12452 VSS.n14940 VSS.t499 9.3005
R12453 VSS.n14942 VSS.n14941 9.3005
R12454 VSS.n14939 VSS.n337 9.3005
R12455 VSS.n14938 VSS.t3358 9.3005
R12456 VSS.n14933 VSS.n338 9.3005
R12457 VSS.n14932 VSS.n14931 9.3005
R12458 VSS.n14930 VSS.n339 9.3005
R12459 VSS.n14929 VSS.n14928 9.3005
R12460 VSS.n14927 VSS.n340 9.3005
R12461 VSS.n14926 VSS.n14925 9.3005
R12462 VSS.n14924 VSS.n14923 9.3005
R12463 VSS.n14922 VSS.n341 9.3005
R12464 VSS.n14921 VSS.n14920 9.3005
R12465 VSS.n14919 VSS.n14918 9.3005
R12466 VSS.t79 VSS.n342 9.3005
R12467 VSS.t189 VSS.n343 9.3005
R12468 VSS.t76 VSS.n344 9.3005
R12469 VSS.t54 VSS.n345 9.3005
R12470 VSS.t74 VSS.n346 9.3005
R12471 VSS.n14917 VSS.n14916 9.3005
R12472 VSS.n14915 VSS.t3257 9.3005
R12473 VSS.n14914 VSS.n14913 9.3005
R12474 VSS.n14912 VSS.n347 9.3005
R12475 VSS.n14911 VSS.n14910 9.3005
R12476 VSS.n14909 VSS.n348 9.3005
R12477 VSS.n14908 VSS.t30 9.3005
R12478 VSS.t3440 VSS.n349 9.3005
R12479 VSS.t3326 VSS.n350 9.3005
R12480 VSS.n14907 VSS.n14906 9.3005
R12481 VSS.n14905 VSS.n14904 9.3005
R12482 VSS.n352 VSS.n351 9.3005
R12483 VSS.n14897 VSS.n14896 9.3005
R12484 VSS.n14895 VSS.n354 9.3005
R12485 VSS.n14894 VSS.n14893 9.3005
R12486 VSS.n14892 VSS.n355 9.3005
R12487 VSS.n14891 VSS.n14890 9.3005
R12488 VSS.t207 VSS.n356 9.3005
R12489 VSS.n14889 VSS.n14888 9.3005
R12490 VSS.n14887 VSS.n14886 9.3005
R12491 VSS.n14885 VSS.n357 9.3005
R12492 VSS.n14884 VSS.n14883 9.3005
R12493 VSS.n14882 VSS.t44 9.3005
R12494 VSS.n14881 VSS.n14880 9.3005
R12495 VSS.n14879 VSS.n358 9.3005
R12496 VSS.n14878 VSS.n14877 9.3005
R12497 VSS.n14876 VSS.n359 9.3005
R12498 VSS.n14875 VSS.n14874 9.3005
R12499 VSS.n361 VSS.n360 9.3005
R12500 VSS.t234 VSS.n14870 9.3005
R12501 VSS.n14869 VSS.n14868 9.3005
R12502 VSS.n14867 VSS.n363 9.3005
R12503 VSS.n14866 VSS.n14865 9.3005
R12504 VSS.n14864 VSS.n14863 9.3005
R12505 VSS.n14862 VSS.n364 9.3005
R12506 VSS.n14861 VSS.n14860 9.3005
R12507 VSS.n14859 VSS.n194 9.3005
R12508 VSS.n14858 VSS.t3300 9.3005
R12509 VSS.n14857 VSS.n365 9.3005
R12510 VSS.t3308 VSS.n14856 9.3005
R12511 VSS.n14855 VSS.t138 9.3005
R12512 VSS.n14854 VSS.t176 9.3005
R12513 VSS.n14853 VSS.n366 9.3005
R12514 VSS.n14852 VSS.n14851 9.3005
R12515 VSS.n14850 VSS.n367 9.3005
R12516 VSS.n14849 VSS.n14848 9.3005
R12517 VSS.n14847 VSS.n368 9.3005
R12518 VSS.n14846 VSS.n14845 9.3005
R12519 VSS.n14844 VSS.n369 9.3005
R12520 VSS.n14843 VSS.n14842 9.3005
R12521 VSS.t3405 VSS.n370 9.3005
R12522 VSS.n14841 VSS.n14840 9.3005
R12523 VSS.n14839 VSS.t214 9.3005
R12524 VSS.n14838 VSS.n14837 9.3005
R12525 VSS.n14836 VSS.n371 9.3005
R12526 VSS.n14835 VSS.n14834 9.3005
R12527 VSS.n14833 VSS.t236 9.3005
R12528 VSS.n14832 VSS.n372 9.3005
R12529 VSS.n14830 VSS.n373 9.3005
R12530 VSS.n14829 VSS.n14828 9.3005
R12531 VSS.n14827 VSS.n374 9.3005
R12532 VSS.n14826 VSS.n14825 9.3005
R12533 VSS.n14824 VSS.n14823 9.3005
R12534 VSS.n14822 VSS.n375 9.3005
R12535 VSS.t22 VSS.n14821 9.3005
R12536 VSS.n14820 VSS.n376 9.3005
R12537 VSS.n14819 VSS.n14818 9.3005
R12538 VSS.n14817 VSS.n377 9.3005
R12539 VSS.n14816 VSS.n14815 9.3005
R12540 VSS.n14814 VSS.n14813 9.3005
R12541 VSS.t3286 VSS.n378 9.3005
R12542 VSS.t149 VSS.n379 9.3005
R12543 VSS.n14812 VSS.n14811 9.3005
R12544 VSS.n14810 VSS.n14809 9.3005
R12545 VSS.n14808 VSS.n380 9.3005
R12546 VSS.n14807 VSS.n14806 9.3005
R12547 VSS.n14805 VSS.n14804 9.3005
R12548 VSS.n14803 VSS.n381 9.3005
R12549 VSS.n14802 VSS.n14801 9.3005
R12550 VSS.n14800 VSS.n382 9.3005
R12551 VSS.n14799 VSS.n14798 9.3005
R12552 VSS.n14797 VSS.n383 9.3005
R12553 VSS.n14794 VSS.n14793 9.3005
R12554 VSS.n14791 VSS.t104 9.3005
R12555 VSS.n14790 VSS.n14789 9.3005
R12556 VSS.t514 VSS.n384 9.3005
R12557 VSS.n14788 VSS.n14787 9.3005
R12558 VSS.n14786 VSS.n14785 9.3005
R12559 VSS.n14784 VSS.n385 9.3005
R12560 VSS.n14783 VSS.n14782 9.3005
R12561 VSS.n14781 VSS.n14780 9.3005
R12562 VSS.n14779 VSS.n386 9.3005
R12563 VSS.n14778 VSS.n14777 9.3005
R12564 VSS.n14776 VSS.t516 9.3005
R12565 VSS.n14775 VSS.n14774 9.3005
R12566 VSS.n14773 VSS.n387 9.3005
R12567 VSS.n14772 VSS.n14771 9.3005
R12568 VSS.n14770 VSS.n14769 9.3005
R12569 VSS.t136 VSS.n388 9.3005
R12570 VSS.n14768 VSS.n14767 9.3005
R12571 VSS.n14766 VSS.n389 9.3005
R12572 VSS.n14765 VSS.n14764 9.3005
R12573 VSS.n14763 VSS.n390 9.3005
R12574 VSS.n14762 VSS.n14761 9.3005
R12575 VSS.n14760 VSS.n391 9.3005
R12576 VSS.n14759 VSS.n14758 9.3005
R12577 VSS.n14757 VSS.n392 9.3005
R12578 VSS.n14756 VSS.n14755 9.3005
R12579 VSS.n14754 VSS.n14753 9.3005
R12580 VSS.n14752 VSS.n393 9.3005
R12581 VSS.n14751 VSS.n14750 9.3005
R12582 VSS.n14749 VSS.n394 9.3005
R12583 VSS.n14748 VSS.n14747 9.3005
R12584 VSS.t519 VSS.n220 9.3005
R12585 VSS.n14743 VSS.n14742 9.3005
R12586 VSS.n14741 VSS.n396 9.3005
R12587 VSS.n14740 VSS.n221 9.3005
R12588 VSS.n402 VSS.n397 9.3005
R12589 VSS.n14739 VSS.n14738 9.3005
R12590 VSS.n14737 VSS.n14736 9.3005
R12591 VSS.n14735 VSS.n409 9.3005
R12592 VSS.n14734 VSS.n14733 9.3005
R12593 VSS.n14732 VSS.n410 9.3005
R12594 VSS.n14731 VSS.n14730 9.3005
R12595 VSS.n412 VSS.n411 9.3005
R12596 VSS.n14723 VSS.t522 9.3005
R12597 VSS.n14725 VSS.n14724 9.3005
R12598 VSS.n14722 VSS.n414 9.3005
R12599 VSS.n14721 VSS.n219 9.3005
R12600 VSS.n420 VSS.n415 9.3005
R12601 VSS.n14720 VSS.n14719 9.3005
R12602 VSS.n14718 VSS.n14717 9.3005
R12603 VSS.n14716 VSS.n427 9.3005
R12604 VSS.n14715 VSS.n14714 9.3005
R12605 VSS.n14713 VSS.n428 9.3005
R12606 VSS.n14712 VSS.n14711 9.3005
R12607 VSS.n430 VSS.n429 9.3005
R12608 VSS.n14704 VSS.t525 9.3005
R12609 VSS.n14706 VSS.n14705 9.3005
R12610 VSS.n14703 VSS.n432 9.3005
R12611 VSS.n14702 VSS.n14701 9.3005
R12612 VSS.n14696 VSS.n433 9.3005
R12613 VSS.n14695 VSS.n14694 9.3005
R12614 VSS.n14693 VSS.n434 9.3005
R12615 VSS.n14692 VSS.n14691 9.3005
R12616 VSS.n14689 VSS.n435 9.3005
R12617 VSS.n14688 VSS.n14687 9.3005
R12618 VSS.n14686 VSS.n14685 9.3005
R12619 VSS.n437 VSS.n436 9.3005
R12620 VSS.n14683 VSS.n14682 9.3005
R12621 VSS.n14681 VSS.n438 9.3005
R12622 VSS.n14680 VSS.n14679 9.3005
R12623 VSS.n14671 VSS.n440 9.3005
R12624 VSS.n14667 VSS.n442 9.3005
R12625 VSS.n14669 VSS.n14668 9.3005
R12626 VSS.n14666 VSS.n14665 9.3005
R12627 VSS.n446 VSS.n445 9.3005
R12628 VSS.n14659 VSS.n14658 9.3005
R12629 VSS.n14657 VSS.n447 9.3005
R12630 VSS.n14656 VSS.n14655 9.3005
R12631 VSS.n14654 VSS.n448 9.3005
R12632 VSS.t4349 VSS.n14653 9.3005
R12633 VSS.n14652 VSS.n449 9.3005
R12634 VSS.n14651 VSS.n14650 9.3005
R12635 VSS.n14646 VSS.n14645 9.3005
R12636 VSS.n455 VSS.n454 9.3005
R12637 VSS.n14639 VSS.n14638 9.3005
R12638 VSS.n14637 VSS.n14636 9.3005
R12639 VSS.n14635 VSS.n458 9.3005
R12640 VSS.n14634 VSS.n14633 9.3005
R12641 VSS.n100 VSS.n234 2.25403
R12642 VSS.n30 VSS.n100 0.192834
R12643 VSS.n30 VSS.n14631 9.3005
R12644 VSS.n30 VSS.n71 4.07296
R12645 VSS.n30 VSS.n68 9.3005
R12646 VSS.n30 VSS.n14624 9.3005
R12647 VSS.n40 VSS.n30 3.96704
R12648 VSS.n30 VSS.n14619 9.3005
R12649 VSS.n14618 VSS.n29 9.3005
R12650 VSS.t4322 VSS.n14617 9.3005
R12651 VSS.n14616 VSS.n14554 9.3005
R12652 VSS.n14615 VSS.n14614 9.3005
R12653 VSS.n14556 VSS.n14555 9.3005
R12654 VSS.n14607 VSS.n14557 9.3005
R12655 VSS.n14609 VSS.n14608 9.3005
R12656 VSS.n14606 VSS.n14567 9.3005
R12657 VSS.n14605 VSS.n14604 9.3005
R12658 VSS.n14599 VSS.n14568 9.3005
R12659 VSS.n14593 VSS.n14570 9.3005
R12660 VSS.n14595 VSS.n14594 9.3005
R12661 VSS.n14592 VSS.n14591 9.3005
R12662 VSS.n14587 VSS.n14573 9.3005
R12663 VSS.n14586 VSS.n14585 9.3005
R12664 VSS.n14584 VSS.n14583 9.3005
R12665 VSS.n14582 VSS.n14574 9.3005
R12666 VSS.t4345 VSS.n14581 9.3005
R12667 VSS.n14580 VSS.n14575 9.3005
R12668 VSS.n14579 VSS.n14578 9.3005
R12669 VSS.n14577 VSS.n14576 9.3005
R12670 VSS.n4460 VSS.n4459 9.10819
R12671 VSS.n4295 VSS.n4294 9.10819
R12672 VSS.n4194 VSS.n4193 9.10819
R12673 VSS.n4093 VSS.n4092 9.10819
R12674 VSS.n3992 VSS.n3991 9.10819
R12675 VSS.n3891 VSS.n3890 9.10819
R12676 VSS.n5111 VSS.n5106 9.10819
R12677 VSS.n5292 VSS.n5291 9.10819
R12678 VSS.n5398 VSS.n5397 9.10819
R12679 VSS.n5504 VSS.n5503 9.10819
R12680 VSS.n5610 VSS.n5609 9.10819
R12681 VSS.n5716 VSS.n5715 9.10819
R12682 VSS.n6541 VSS.n6540 9.10819
R12683 VSS.n6376 VSS.n6375 9.10819
R12684 VSS.n6275 VSS.n6274 9.10819
R12685 VSS.n6174 VSS.n6173 9.10819
R12686 VSS.n6073 VSS.n6072 9.10819
R12687 VSS.n5972 VSS.n5971 9.10819
R12688 VSS.n7583 VSS.n7582 9.10819
R12689 VSS.n7418 VSS.n7417 9.10819
R12690 VSS.n7317 VSS.n7316 9.10819
R12691 VSS.n7216 VSS.n7215 9.10819
R12692 VSS.n7115 VSS.n7114 9.10819
R12693 VSS.n7014 VSS.n7013 9.10819
R12694 VSS.n7669 VSS.n7668 9.10819
R12695 VSS.n7774 VSS.n7773 9.10819
R12696 VSS.n7880 VSS.n7879 9.10819
R12697 VSS.n7986 VSS.n7985 9.10819
R12698 VSS.n8092 VSS.n8091 9.10819
R12699 VSS.n8198 VSS.n8197 9.10819
R12700 VSS.n8631 VSS.n8626 9.10819
R12701 VSS.n8812 VSS.n8811 9.10819
R12702 VSS.n8918 VSS.n8917 9.10819
R12703 VSS.n9024 VSS.n9023 9.10819
R12704 VSS.n9130 VSS.n9129 9.10819
R12705 VSS.n9236 VSS.n9235 9.10819
R12706 VSS.n10061 VSS.n10060 9.10819
R12707 VSS.n9896 VSS.n9895 9.10819
R12708 VSS.n9795 VSS.n9794 9.10819
R12709 VSS.n9694 VSS.n9693 9.10819
R12710 VSS.n9593 VSS.n9592 9.10819
R12711 VSS.n9492 VSS.n9491 9.10819
R12712 VSS.n11103 VSS.n11102 9.10819
R12713 VSS.n10938 VSS.n10937 9.10819
R12714 VSS.n10837 VSS.n10836 9.10819
R12715 VSS.n10736 VSS.n10735 9.10819
R12716 VSS.n10635 VSS.n10634 9.10819
R12717 VSS.n10534 VSS.n10533 9.10819
R12718 VSS.n11189 VSS.n11188 9.10819
R12719 VSS.n11294 VSS.n11293 9.10819
R12720 VSS.n11400 VSS.n11399 9.10819
R12721 VSS.n11506 VSS.n11505 9.10819
R12722 VSS.n11612 VSS.n11611 9.10819
R12723 VSS.n11718 VSS.n11717 9.10819
R12724 VSS.n12151 VSS.n12146 9.10819
R12725 VSS.n12332 VSS.n12331 9.10819
R12726 VSS.n12438 VSS.n12437 9.10819
R12727 VSS.n12544 VSS.n12543 9.10819
R12728 VSS.n12650 VSS.n12649 9.10819
R12729 VSS.n12756 VSS.n12755 9.10819
R12730 VSS.n13581 VSS.n13580 9.10819
R12731 VSS.n13416 VSS.n13415 9.10819
R12732 VSS.n13315 VSS.n13314 9.10819
R12733 VSS.n13214 VSS.n13213 9.10819
R12734 VSS.n13113 VSS.n13112 9.10819
R12735 VSS.n13012 VSS.n13011 9.10819
R12736 VSS.n14546 VSS.n14545 9.10819
R12737 VSS.n14381 VSS.n14380 9.10819
R12738 VSS.n14122 VSS.n14121 9.10819
R12739 VSS.n14021 VSS.n14020 9.10819
R12740 VSS.n14629 VSS.n14628 9.10819
R12741 VSS.t3408 VSS.n369 9.03579
R12742 VSS.t76 VSS.t54 9.03579
R12743 VSS.n15020 VSS.t140 9.03579
R12744 VSS.n14884 VSS.t44 8.75144
R12745 VSS.n14764 VSS.t3328 8.65932
R12746 VSS.t169 VSS.t429 8.42962
R12747 VSS.n14842 VSS.t46 8.28285
R12748 VSS.t2899 VSS.n3783 8.21672
R12749 VSS.t1606 VSS.n2253 8.21672
R12750 VSS.n3803 VSS.t3012 8.16157
R12751 VSS.t2794 VSS.n5881 8.16157
R12752 VSS.n4845 VSS.t2579 8.16157
R12753 VSS.n6926 VSS.t2364 8.16157
R12754 VSS.t2149 VSS.n8363 8.16157
R12755 VSS.t1934 VSS.n9401 8.16157
R12756 VSS.n2273 VSS.t1719 8.16157
R12757 VSS.n10446 VSS.t1501 8.16157
R12758 VSS.t1286 VSS.n11883 8.16157
R12759 VSS.t1071 VSS.n12921 8.16157
R12760 VSS.n1651 VSS.t856 8.16157
R12761 VSS.n13933 VSS.t646 8.16157
R12762 VSS.t3099 VSS.n4373 8.10717
R12763 VSS.n4271 VSS.t3084 8.10717
R12764 VSS.n4170 VSS.t3069 8.10717
R12765 VSS.n4069 VSS.t3054 8.10717
R12766 VSS.n3968 VSS.t3039 8.10717
R12767 VSS.n3867 VSS.t3024 8.10717
R12768 VSS.n5207 VSS.t2881 8.10717
R12769 VSS.n5313 VSS.t2866 8.10717
R12770 VSS.n5419 VSS.t2851 8.10717
R12771 VSS.n5525 VSS.t2836 8.10717
R12772 VSS.n5631 VSS.t2821 8.10717
R12773 VSS.n5737 VSS.t2806 8.10717
R12774 VSS.t2666 VSS.n6454 8.10717
R12775 VSS.n6352 VSS.t2651 8.10717
R12776 VSS.n6251 VSS.t2636 8.10717
R12777 VSS.n6150 VSS.t2621 8.10717
R12778 VSS.n6049 VSS.t2606 8.10717
R12779 VSS.n5948 VSS.t2591 8.10717
R12780 VSS.t2451 VSS.n7496 8.10717
R12781 VSS.n7394 VSS.t2436 8.10717
R12782 VSS.n7293 VSS.t2421 8.10717
R12783 VSS.n7192 VSS.t2406 8.10717
R12784 VSS.n7091 VSS.t2391 8.10717
R12785 VSS.n6990 VSS.t2376 8.10717
R12786 VSS.n7689 VSS.t2236 8.10717
R12787 VSS.n7795 VSS.t2221 8.10717
R12788 VSS.n7901 VSS.t2206 8.10717
R12789 VSS.n8007 VSS.t2191 8.10717
R12790 VSS.n8113 VSS.t2176 8.10717
R12791 VSS.n8219 VSS.t2161 8.10717
R12792 VSS.n8727 VSS.t2021 8.10717
R12793 VSS.n8833 VSS.t2006 8.10717
R12794 VSS.n8939 VSS.t1991 8.10717
R12795 VSS.n9045 VSS.t1976 8.10717
R12796 VSS.n9151 VSS.t1961 8.10717
R12797 VSS.n9257 VSS.t1946 8.10717
R12798 VSS.t1806 VSS.n9974 8.10717
R12799 VSS.n9872 VSS.t1791 8.10717
R12800 VSS.n9771 VSS.t1776 8.10717
R12801 VSS.n9670 VSS.t1761 8.10717
R12802 VSS.n9569 VSS.t1746 8.10717
R12803 VSS.n9468 VSS.t1731 8.10717
R12804 VSS.t1588 VSS.n11016 8.10717
R12805 VSS.n10914 VSS.t1573 8.10717
R12806 VSS.n10813 VSS.t1558 8.10717
R12807 VSS.n10712 VSS.t1543 8.10717
R12808 VSS.n10611 VSS.t1528 8.10717
R12809 VSS.n10510 VSS.t1513 8.10717
R12810 VSS.n11209 VSS.t1373 8.10717
R12811 VSS.n11315 VSS.t1358 8.10717
R12812 VSS.n11421 VSS.t1343 8.10717
R12813 VSS.n11527 VSS.t1328 8.10717
R12814 VSS.n11633 VSS.t1313 8.10717
R12815 VSS.n11739 VSS.t1298 8.10717
R12816 VSS.n12247 VSS.t1158 8.10717
R12817 VSS.n12353 VSS.t1143 8.10717
R12818 VSS.n12459 VSS.t1128 8.10717
R12819 VSS.n12565 VSS.t1113 8.10717
R12820 VSS.n12671 VSS.t1098 8.10717
R12821 VSS.n12777 VSS.t1083 8.10717
R12822 VSS.t943 VSS.n13494 8.10717
R12823 VSS.n13392 VSS.t928 8.10717
R12824 VSS.n13291 VSS.t913 8.10717
R12825 VSS.n13190 VSS.t898 8.10717
R12826 VSS.n13089 VSS.t883 8.10717
R12827 VSS.n12988 VSS.t868 8.10717
R12828 VSS.t728 VSS.n14459 8.10717
R12829 VSS.n218 VSS.t268 7.50769
R12830 VSS.n14180 VSS.t685 8.10717
R12831 VSS.n14098 VSS.t673 8.10717
R12832 VSS.n13997 VSS.t658 8.10717
R12833 VSS.n14649 VSS.t533 8.10717
R12834 VSS.t3492 VSS.n3470 7.68028
R12835 VSS.t3497 VSS.n3520 7.68028
R12836 VSS.t3502 VSS.n3570 7.68028
R12837 VSS.t3507 VSS.n3620 7.68028
R12838 VSS.t3512 VSS.n3670 7.68028
R12839 VSS.t3517 VSS.n3720 7.68028
R12840 VSS.n5248 VSS.t3562 7.68028
R12841 VSS.n5354 VSS.t3567 7.68028
R12842 VSS.n5460 VSS.t3572 7.68028
R12843 VSS.n5566 VSS.t3577 7.68028
R12844 VSS.n5672 VSS.t3582 7.68028
R12845 VSS.n5778 VSS.t3587 7.68028
R12846 VSS.t3632 VSS.n4493 7.68028
R12847 VSS.t3637 VSS.n4543 7.68028
R12848 VSS.t3642 VSS.n4593 7.68028
R12849 VSS.t3647 VSS.n4643 7.68028
R12850 VSS.t3652 VSS.n4693 7.68028
R12851 VSS.t3657 VSS.n4743 7.68028
R12852 VSS.t3702 VSS.n6574 7.68028
R12853 VSS.t3707 VSS.n6624 7.68028
R12854 VSS.t3712 VSS.n6674 7.68028
R12855 VSS.t3717 VSS.n6724 7.68028
R12856 VSS.t3722 VSS.n6774 7.68028
R12857 VSS.t3727 VSS.n6824 7.68028
R12858 VSS.n7730 VSS.t3772 7.68028
R12859 VSS.n7836 VSS.t3777 7.68028
R12860 VSS.n7942 VSS.t3782 7.68028
R12861 VSS.n8048 VSS.t3787 7.68028
R12862 VSS.n8154 VSS.t3792 7.68028
R12863 VSS.n8260 VSS.t3797 7.68028
R12864 VSS.n8768 VSS.t3842 7.68028
R12865 VSS.n8874 VSS.t3847 7.68028
R12866 VSS.n8980 VSS.t3852 7.68028
R12867 VSS.n9086 VSS.t3857 7.68028
R12868 VSS.n9192 VSS.t3862 7.68028
R12869 VSS.n9298 VSS.t3867 7.68028
R12870 VSS.t3912 VSS.n1940 7.68028
R12871 VSS.t3917 VSS.n1990 7.68028
R12872 VSS.t3922 VSS.n2040 7.68028
R12873 VSS.t3927 VSS.n2090 7.68028
R12874 VSS.t3932 VSS.n2140 7.68028
R12875 VSS.t3937 VSS.n2190 7.68028
R12876 VSS.t3982 VSS.n10094 7.68028
R12877 VSS.t3987 VSS.n10144 7.68028
R12878 VSS.t3992 VSS.n10194 7.68028
R12879 VSS.t3997 VSS.n10244 7.68028
R12880 VSS.t4002 VSS.n10294 7.68028
R12881 VSS.t4007 VSS.n10344 7.68028
R12882 VSS.n11250 VSS.t4052 7.68028
R12883 VSS.n11356 VSS.t4057 7.68028
R12884 VSS.n11462 VSS.t4062 7.68028
R12885 VSS.n11568 VSS.t4067 7.68028
R12886 VSS.n11674 VSS.t4072 7.68028
R12887 VSS.n11780 VSS.t4077 7.68028
R12888 VSS.n12288 VSS.t4122 7.68028
R12889 VSS.n12394 VSS.t4127 7.68028
R12890 VSS.n12500 VSS.t4132 7.68028
R12891 VSS.n12606 VSS.t4137 7.68028
R12892 VSS.n12712 VSS.t4142 7.68028
R12893 VSS.n12818 VSS.t4147 7.68028
R12894 VSS.t4192 VSS.n1299 7.68028
R12895 VSS.t4197 VSS.n1349 7.68028
R12896 VSS.t4202 VSS.n1399 7.68028
R12897 VSS.t4207 VSS.n1449 7.68028
R12898 VSS.t4212 VSS.n1499 7.68028
R12899 VSS.t4217 VSS.n1549 7.68028
R12900 VSS.t4262 VSS.n13614 7.68028
R12901 VSS.t4281 VSS.n13781 7.68028
R12902 VSS.t4286 VSS.n13831 7.68028
R12903 VSS.n14690 VSS.t4326 7.68028
R12904 VSS.n4396 VSS.t3490 7.57481
R12905 VSS.t3495 VSS.n4274 7.57481
R12906 VSS.t3500 VSS.n4173 7.57481
R12907 VSS.t3505 VSS.n4072 7.57481
R12908 VSS.t3510 VSS.n3971 7.57481
R12909 VSS.t3515 VSS.n3870 7.57481
R12910 VSS.t3560 VSS.n5097 7.57481
R12911 VSS.t3565 VSS.n5055 7.57481
R12912 VSS.t3570 VSS.n5013 7.57481
R12913 VSS.t3575 VSS.n4971 7.57481
R12914 VSS.t3580 VSS.n4929 7.57481
R12915 VSS.t3585 VSS.n4887 7.57481
R12916 VSS.n6477 VSS.t3630 7.57481
R12917 VSS.t3635 VSS.n6355 7.57481
R12918 VSS.t3640 VSS.n6254 7.57481
R12919 VSS.t3645 VSS.n6153 7.57481
R12920 VSS.t3650 VSS.n6052 7.57481
R12921 VSS.t3655 VSS.n5951 7.57481
R12922 VSS.n7519 VSS.t3700 7.57481
R12923 VSS.t3705 VSS.n7397 7.57481
R12924 VSS.t3710 VSS.n7296 7.57481
R12925 VSS.t3715 VSS.n7195 7.57481
R12926 VSS.t3720 VSS.n7094 7.57481
R12927 VSS.t3725 VSS.n6993 7.57481
R12928 VSS.t3770 VSS.n2525 7.57481
R12929 VSS.t3775 VSS.n2483 7.57481
R12930 VSS.t3780 VSS.n2441 7.57481
R12931 VSS.t3785 VSS.n2399 7.57481
R12932 VSS.t3790 VSS.n2357 7.57481
R12933 VSS.t3795 VSS.n2315 7.57481
R12934 VSS.t3840 VSS.n8617 7.57481
R12935 VSS.t3845 VSS.n8575 7.57481
R12936 VSS.t3850 VSS.n8533 7.57481
R12937 VSS.t3855 VSS.n8491 7.57481
R12938 VSS.t3860 VSS.n8449 7.57481
R12939 VSS.t3865 VSS.n8407 7.57481
R12940 VSS.n9997 VSS.t3910 7.57481
R12941 VSS.t3915 VSS.n9875 7.57481
R12942 VSS.t3920 VSS.n9774 7.57481
R12943 VSS.t3925 VSS.n9673 7.57481
R12944 VSS.t3930 VSS.n9572 7.57481
R12945 VSS.t3935 VSS.n9471 7.57481
R12946 VSS.n11039 VSS.t3980 7.57481
R12947 VSS.t3985 VSS.n10917 7.57481
R12948 VSS.t3990 VSS.n10816 7.57481
R12949 VSS.t3995 VSS.n10715 7.57481
R12950 VSS.t4000 VSS.n10614 7.57481
R12951 VSS.t4005 VSS.n10513 7.57481
R12952 VSS.t4050 VSS.n1903 7.57481
R12953 VSS.t4055 VSS.n1861 7.57481
R12954 VSS.t4060 VSS.n1819 7.57481
R12955 VSS.t4065 VSS.n1777 7.57481
R12956 VSS.t4070 VSS.n1735 7.57481
R12957 VSS.t4075 VSS.n1693 7.57481
R12958 VSS.t4120 VSS.n12137 7.57481
R12959 VSS.t4125 VSS.n12095 7.57481
R12960 VSS.t4130 VSS.n12053 7.57481
R12961 VSS.t4135 VSS.n12011 7.57481
R12962 VSS.t4140 VSS.n11969 7.57481
R12963 VSS.t4145 VSS.n11927 7.57481
R12964 VSS.n13517 VSS.t4190 7.57481
R12965 VSS.t4195 VSS.n13395 7.57481
R12966 VSS.t4200 VSS.n13294 7.57481
R12967 VSS.t4205 VSS.n13193 7.57481
R12968 VSS.t4210 VSS.n13092 7.57481
R12969 VSS.t4215 VSS.n12991 7.57481
R12970 VSS.n14482 VSS.t4260 7.57481
R12971 VSS.t4279 VSS.n14101 7.57481
R12972 VSS.t4284 VSS.n14000 7.57481
R12973 VSS.t4324 VSS.n451 7.57481
R12974 VSS.n14772 VSS.t3336 7.52991
R12975 VSS.t191 VSS.t154 7.52991
R12976 VSS.n13685 VSS.t4268 7.39606
R12977 VSS.t4269 VSS.n13695 7.39606
R12978 VSS.n353 VSS.t4358 7.39606
R12979 VSS.t236 VSS.t209 7.15344
R12980 VSS.t30 VSS.t3440 7.15344
R12981 VSS.t3255 VSS.n14912 7.15344
R12982 VSS.n14345 VSS.n13653 6.8805
R12983 VSS.n14900 VSS.n14899 6.8805
R12984 VSS.n422 VSS.t524 6.82717
R12985 VSS.n404 VSS.t521 6.82717
R12986 VSS.t4358 VSS.t424 6.82717
R12987 VSS.n14244 VSS.t3350 6.77697
R12988 VSS.n14795 VSS.n14794 6.77697
R12989 VSS.n14809 VSS.t3294 6.77697
R12990 VSS.t3108 VSS.n4400 6.74645
R12991 VSS.n3461 VSS.t3096 6.74645
R12992 VSS.n3511 VSS.t3081 6.74645
R12993 VSS.n3561 VSS.t3066 6.74645
R12994 VSS.n3611 VSS.t3051 6.74645
R12995 VSS.n3661 VSS.t3036 6.74645
R12996 VSS.n3711 VSS.t3021 6.74645
R12997 VSS.t2890 VSS.n5132 6.74645
R12998 VSS.n5230 VSS.t2878 6.74645
R12999 VSS.n5336 VSS.t2863 6.74645
R13000 VSS.n5442 VSS.t2848 6.74645
R13001 VSS.n5548 VSS.t2833 6.74645
R13002 VSS.n5654 VSS.t2818 6.74645
R13003 VSS.n5760 VSS.t2803 6.74645
R13004 VSS.t2675 VSS.n6481 6.74645
R13005 VSS.n4484 VSS.t2663 6.74645
R13006 VSS.n4534 VSS.t2648 6.74645
R13007 VSS.n4584 VSS.t2633 6.74645
R13008 VSS.n4634 VSS.t2618 6.74645
R13009 VSS.n4684 VSS.t2603 6.74645
R13010 VSS.n4734 VSS.t2588 6.74645
R13011 VSS.t2460 VSS.n7523 6.74645
R13012 VSS.n6565 VSS.t2448 6.74645
R13013 VSS.n6615 VSS.t2433 6.74645
R13014 VSS.n6665 VSS.t2418 6.74645
R13015 VSS.n6715 VSS.t2403 6.74645
R13016 VSS.n6765 VSS.t2388 6.74645
R13017 VSS.n6815 VSS.t2373 6.74645
R13018 VSS.t2245 VSS.n7609 6.74645
R13019 VSS.n7712 VSS.t2233 6.74645
R13020 VSS.n7818 VSS.t2218 6.74645
R13021 VSS.n7924 VSS.t2203 6.74645
R13022 VSS.n8030 VSS.t2188 6.74645
R13023 VSS.n8136 VSS.t2173 6.74645
R13024 VSS.n8242 VSS.t2158 6.74645
R13025 VSS.t2030 VSS.n8652 6.74645
R13026 VSS.n8750 VSS.t2018 6.74645
R13027 VSS.n8856 VSS.t2003 6.74645
R13028 VSS.n8962 VSS.t1988 6.74645
R13029 VSS.n9068 VSS.t1973 6.74645
R13030 VSS.n9174 VSS.t1958 6.74645
R13031 VSS.n9280 VSS.t1943 6.74645
R13032 VSS.t1815 VSS.n10001 6.74645
R13033 VSS.n1931 VSS.t1803 6.74645
R13034 VSS.n1981 VSS.t1788 6.74645
R13035 VSS.n2031 VSS.t1773 6.74645
R13036 VSS.n2081 VSS.t1758 6.74645
R13037 VSS.n2131 VSS.t1743 6.74645
R13038 VSS.n2181 VSS.t1728 6.74645
R13039 VSS.t1597 VSS.n11043 6.74645
R13040 VSS.n10085 VSS.t1585 6.74645
R13041 VSS.n10135 VSS.t1570 6.74645
R13042 VSS.n10185 VSS.t1555 6.74645
R13043 VSS.n10235 VSS.t1540 6.74645
R13044 VSS.n10285 VSS.t1525 6.74645
R13045 VSS.n10335 VSS.t1510 6.74645
R13046 VSS.t1382 VSS.n11129 6.74645
R13047 VSS.n11232 VSS.t1370 6.74645
R13048 VSS.n11338 VSS.t1355 6.74645
R13049 VSS.n11444 VSS.t1340 6.74645
R13050 VSS.n11550 VSS.t1325 6.74645
R13051 VSS.n11656 VSS.t1310 6.74645
R13052 VSS.n11762 VSS.t1295 6.74645
R13053 VSS.t1167 VSS.n12172 6.74645
R13054 VSS.n12270 VSS.t1155 6.74645
R13055 VSS.n12376 VSS.t1140 6.74645
R13056 VSS.n12482 VSS.t1125 6.74645
R13057 VSS.n12588 VSS.t1110 6.74645
R13058 VSS.n12694 VSS.t1095 6.74645
R13059 VSS.n12800 VSS.t1080 6.74645
R13060 VSS.t952 VSS.n13521 6.74645
R13061 VSS.n1290 VSS.t940 6.74645
R13062 VSS.n1340 VSS.t925 6.74645
R13063 VSS.n1390 VSS.t910 6.74645
R13064 VSS.n1440 VSS.t895 6.74645
R13065 VSS.n1490 VSS.t880 6.74645
R13066 VSS.n1540 VSS.t865 6.74645
R13067 VSS.t737 VSS.n14486 6.74645
R13068 VSS.n13605 VSS.t725 6.74645
R13069 VSS.n14203 VSS.t682 6.74645
R13070 VSS.n13772 VSS.t670 6.74645
R13071 VSS.n13822 VSS.t655 6.74645
R13072 VSS.t542 VSS.n14569 6.74645
R13073 VSS.n14672 VSS.t530 6.74645
R13074 VSS.t3093 VSS.n4328 6.65996
R13075 VSS.t3078 VSS.n4227 6.65996
R13076 VSS.t3063 VSS.n4126 6.65996
R13077 VSS.t3048 VSS.n4025 6.65996
R13078 VSS.t3033 VSS.n3924 6.65996
R13079 VSS.t3018 VSS.n3823 6.65996
R13080 VSS.t2875 VSS.n130 6.65996
R13081 VSS.t2860 VSS.n131 6.65996
R13082 VSS.t2845 VSS.n132 6.65996
R13083 VSS.t2830 VSS.n133 6.65996
R13084 VSS.t2815 VSS.n134 6.65996
R13085 VSS.n5785 VSS.t2800 6.65996
R13086 VSS.t2660 VSS.n6409 6.65996
R13087 VSS.t2645 VSS.n6308 6.65996
R13088 VSS.t2630 VSS.n6207 6.65996
R13089 VSS.t2615 VSS.n6106 6.65996
R13090 VSS.t2600 VSS.n6005 6.65996
R13091 VSS.t2585 VSS.n5904 6.65996
R13092 VSS.t2445 VSS.n7451 6.65996
R13093 VSS.t2430 VSS.n7350 6.65996
R13094 VSS.t2415 VSS.n7249 6.65996
R13095 VSS.t2400 VSS.n7148 6.65996
R13096 VSS.t2385 VSS.n7047 6.65996
R13097 VSS.t2370 VSS.n6946 6.65996
R13098 VSS.t2230 VSS.n136 6.65996
R13099 VSS.t2215 VSS.n137 6.65996
R13100 VSS.t2200 VSS.n138 6.65996
R13101 VSS.t2185 VSS.n139 6.65996
R13102 VSS.t2170 VSS.n140 6.65996
R13103 VSS.n8267 VSS.t2155 6.65996
R13104 VSS.t2015 VSS.n142 6.65996
R13105 VSS.t2000 VSS.n143 6.65996
R13106 VSS.t1985 VSS.n144 6.65996
R13107 VSS.t1970 VSS.n145 6.65996
R13108 VSS.t1955 VSS.n146 6.65996
R13109 VSS.n9305 VSS.t1940 6.65996
R13110 VSS.t1800 VSS.n9929 6.65996
R13111 VSS.t1785 VSS.n9828 6.65996
R13112 VSS.t1770 VSS.n9727 6.65996
R13113 VSS.t1755 VSS.n9626 6.65996
R13114 VSS.t1740 VSS.n9525 6.65996
R13115 VSS.t1725 VSS.n9424 6.65996
R13116 VSS.t1582 VSS.n10971 6.65996
R13117 VSS.t1567 VSS.n10870 6.65996
R13118 VSS.t1552 VSS.n10769 6.65996
R13119 VSS.t1537 VSS.n10668 6.65996
R13120 VSS.t1522 VSS.n10567 6.65996
R13121 VSS.t1507 VSS.n10466 6.65996
R13122 VSS.t1367 VSS.n148 6.65996
R13123 VSS.t1352 VSS.n149 6.65996
R13124 VSS.t1337 VSS.n150 6.65996
R13125 VSS.t1322 VSS.n151 6.65996
R13126 VSS.t1307 VSS.n152 6.65996
R13127 VSS.n11787 VSS.t1292 6.65996
R13128 VSS.t1152 VSS.n154 6.65996
R13129 VSS.t1137 VSS.n155 6.65996
R13130 VSS.t1122 VSS.n156 6.65996
R13131 VSS.t1107 VSS.n157 6.65996
R13132 VSS.t1092 VSS.n158 6.65996
R13133 VSS.n12825 VSS.t1077 6.65996
R13134 VSS.t937 VSS.n13449 6.65996
R13135 VSS.t922 VSS.n13348 6.65996
R13136 VSS.t907 VSS.n13247 6.65996
R13137 VSS.t892 VSS.n13146 6.65996
R13138 VSS.t877 VSS.n13045 6.65996
R13139 VSS.t862 VSS.n12944 6.65996
R13140 VSS.t722 VSS.n14414 6.65996
R13141 VSS.t667 VSS.n14054 6.65996
R13142 VSS.t652 VSS.n13953 6.65996
R13143 VSS.t527 VSS.n160 6.65996
R13144 VSS.n3812 VSS.n3733 6.61527
R13145 VSS.n3812 VSS.t2905 6.61527
R13146 VSS.n3803 VSS.t2902 6.61527
R13147 VSS.n4865 VSS.n4854 6.61527
R13148 VSS.n4865 VSS.t2690 6.61527
R13149 VSS.n5881 VSS.t2687 6.61527
R13150 VSS.n5893 VSS.n4756 6.61527
R13151 VSS.n5893 VSS.t2475 6.61527
R13152 VSS.n4845 VSS.t2472 6.61527
R13153 VSS.n6935 VSS.n6837 6.61527
R13154 VSS.n6935 VSS.t2260 6.61527
R13155 VSS.n6926 VSS.t2257 6.61527
R13156 VSS.n2293 VSS.n2282 6.61527
R13157 VSS.n2293 VSS.t2045 6.61527
R13158 VSS.n8363 VSS.t2042 6.61527
R13159 VSS.n8385 VSS.n8374 6.61527
R13160 VSS.n8385 VSS.t1830 6.61527
R13161 VSS.n9401 VSS.t1827 6.61527
R13162 VSS.n9413 VSS.n2203 6.61527
R13163 VSS.n9413 VSS.t1612 6.61527
R13164 VSS.n2273 VSS.t1609 6.61527
R13165 VSS.n10455 VSS.n10357 6.61527
R13166 VSS.n10455 VSS.t1397 6.61527
R13167 VSS.n10446 VSS.t1394 6.61527
R13168 VSS.n1671 VSS.n1660 6.61527
R13169 VSS.n1671 VSS.t1182 6.61527
R13170 VSS.n11883 VSS.t1179 6.61527
R13171 VSS.n11905 VSS.n11894 6.61527
R13172 VSS.n11905 VSS.t967 6.61527
R13173 VSS.n12921 VSS.t964 6.61527
R13174 VSS.n12933 VSS.n1562 6.61527
R13175 VSS.n12933 VSS.t752 6.61527
R13176 VSS.n1651 VSS.t749 6.61527
R13177 VSS.n13942 VSS.n13844 6.61527
R13178 VSS.n13942 VSS.t557 6.61527
R13179 VSS.n13933 VSS.t554 6.61527
R13180 VSS.n3792 VSS.t3010 6.6092
R13181 VSS.t2792 VSS.n5870 6.6092
R13182 VSS.n4834 VSS.t2577 6.6092
R13183 VSS.n6915 VSS.t2362 6.6092
R13184 VSS.t2147 VSS.n8352 6.6092
R13185 VSS.t1932 VSS.n9390 6.6092
R13186 VSS.n2262 VSS.t1717 6.6092
R13187 VSS.n10435 VSS.t1499 6.6092
R13188 VSS.t1284 VSS.n11872 6.6092
R13189 VSS.t1069 VSS.n12910 6.6092
R13190 VSS.n1640 VSS.t854 6.6092
R13191 VSS.n13922 VSS.t644 6.6092
R13192 VSS.t494 VSS.t3306 6.6092
R13193 VSS.n4373 VSS.t2989 6.57117
R13194 VSS.n4271 VSS.t2974 6.57117
R13195 VSS.n4170 VSS.t2959 6.57117
R13196 VSS.n4069 VSS.t2944 6.57117
R13197 VSS.n3968 VSS.t2929 6.57117
R13198 VSS.n3867 VSS.t2914 6.57117
R13199 VSS.t2774 VSS.n5207 6.57117
R13200 VSS.t2759 VSS.n5313 6.57117
R13201 VSS.t2744 VSS.n5419 6.57117
R13202 VSS.t2729 VSS.n5525 6.57117
R13203 VSS.t2714 VSS.n5631 6.57117
R13204 VSS.t2699 VSS.n5737 6.57117
R13205 VSS.n6454 VSS.t2559 6.57117
R13206 VSS.n6352 VSS.t2544 6.57117
R13207 VSS.n6251 VSS.t2529 6.57117
R13208 VSS.n6150 VSS.t2514 6.57117
R13209 VSS.n6049 VSS.t2499 6.57117
R13210 VSS.n5948 VSS.t2484 6.57117
R13211 VSS.n7496 VSS.t2344 6.57117
R13212 VSS.n7394 VSS.t2329 6.57117
R13213 VSS.n7293 VSS.t2314 6.57117
R13214 VSS.n7192 VSS.t2299 6.57117
R13215 VSS.n7091 VSS.t2284 6.57117
R13216 VSS.n6990 VSS.t2269 6.57117
R13217 VSS.t2129 VSS.n7689 6.57117
R13218 VSS.t2114 VSS.n7795 6.57117
R13219 VSS.t2099 VSS.n7901 6.57117
R13220 VSS.t2084 VSS.n8007 6.57117
R13221 VSS.t2069 VSS.n8113 6.57117
R13222 VSS.t2054 VSS.n8219 6.57117
R13223 VSS.t1914 VSS.n8727 6.57117
R13224 VSS.t1899 VSS.n8833 6.57117
R13225 VSS.t1884 VSS.n8939 6.57117
R13226 VSS.t1869 VSS.n9045 6.57117
R13227 VSS.t1854 VSS.n9151 6.57117
R13228 VSS.t1839 VSS.n9257 6.57117
R13229 VSS.n9974 VSS.t1696 6.57117
R13230 VSS.n9872 VSS.t1681 6.57117
R13231 VSS.n9771 VSS.t1666 6.57117
R13232 VSS.n9670 VSS.t1651 6.57117
R13233 VSS.n9569 VSS.t1636 6.57117
R13234 VSS.n9468 VSS.t1621 6.57117
R13235 VSS.n11016 VSS.t1481 6.57117
R13236 VSS.n10914 VSS.t1466 6.57117
R13237 VSS.n10813 VSS.t1451 6.57117
R13238 VSS.n10712 VSS.t1436 6.57117
R13239 VSS.n10611 VSS.t1421 6.57117
R13240 VSS.n10510 VSS.t1406 6.57117
R13241 VSS.t1266 VSS.n11209 6.57117
R13242 VSS.t1251 VSS.n11315 6.57117
R13243 VSS.t1236 VSS.n11421 6.57117
R13244 VSS.t1221 VSS.n11527 6.57117
R13245 VSS.t1206 VSS.n11633 6.57117
R13246 VSS.t1191 VSS.n11739 6.57117
R13247 VSS.t1051 VSS.n12247 6.57117
R13248 VSS.t1036 VSS.n12353 6.57117
R13249 VSS.t1021 VSS.n12459 6.57117
R13250 VSS.t1006 VSS.n12565 6.57117
R13251 VSS.t991 VSS.n12671 6.57117
R13252 VSS.t976 VSS.n12777 6.57117
R13253 VSS.n13494 VSS.t836 6.57117
R13254 VSS.n13392 VSS.t821 6.57117
R13255 VSS.n13291 VSS.t806 6.57117
R13256 VSS.n13190 VSS.t791 6.57117
R13257 VSS.n13089 VSS.t776 6.57117
R13258 VSS.n12988 VSS.t761 6.57117
R13259 VSS.n14459 VSS.t626 6.57117
R13260 VSS.t593 VSS.n14180 6.57117
R13261 VSS.n14098 VSS.t581 6.57117
R13262 VSS.n13997 VSS.t566 6.57117
R13263 VSS.t479 VSS.n15227 6.57117
R13264 VSS.t456 VSS.n14649 6.57117
R13265 VSS.n317 VSS.t407 6.57117
R13266 VSS.t3284 VSS.n910 6.4005
R13267 VSS.n15227 VSS.t405 6.4005
R13268 VSS.n14756 VSS.t518 6.4005
R13269 VSS.t493 VSS.n317 6.4005
R13270 VSS.n15311 VSS.n15310 6.26433
R13271 VSS.n15312 VSS.n15311 6.26433
R13272 VSS.n15312 VSS.n15283 6.26433
R13273 VSS.n15316 VSS.n15283 6.26433
R13274 VSS.n15333 VSS.n15332 6.26433
R13275 VSS.n15334 VSS.n15333 6.26433
R13276 VSS.n15334 VSS.n15273 6.26433
R13277 VSS.n15338 VSS.n15273 6.26433
R13278 VSS.n484 VSS.n483 6.26433
R13279 VSS.n483 VSS.n474 6.26433
R13280 VSS.n38 VSS.n503 8.41958
R13281 VSS.n515 VSS.n503 6.26433
R13282 VSS.n516 VSS.n515 6.26433
R13283 VSS.n517 VSS.n516 6.26433
R13284 VSS.t384 VSS.n56 10.8378
R13285 VSS.n1218 VSS.n1212 6.26433
R13286 VSS.n1229 VSS.n1209 6.26433
R13287 VSS.n1225 VSS.n1209 6.26433
R13288 VSS.n1225 VSS.n1224 6.26433
R13289 VSS.n1224 VSS.n1223 6.26433
R13290 VSS.n1251 VSS.n1250 6.26433
R13291 VSS.n1185 VSS.n530 6.26433
R13292 VSS.n1189 VSS.n530 6.26433
R13293 VSS.n1190 VSS.n1189 6.26433
R13294 VSS.n1191 VSS.n1190 6.26433
R13295 VSS.n1162 VSS.n539 6.26433
R13296 VSS.n1166 VSS.n539 6.26433
R13297 VSS.n1167 VSS.n1166 6.26433
R13298 VSS.n1168 VSS.n1167 6.26433
R13299 VSS.n1144 VSS.n1143 6.26433
R13300 VSS.n1124 VSS.n1123 6.26433
R13301 VSS.n1063 VSS.n1047 6.26433
R13302 VSS.n1059 VSS.n1047 6.26433
R13303 VSS.n1059 VSS.n1058 6.26433
R13304 VSS.n1058 VSS.n1057 6.26433
R13305 VSS.n1088 VSS.n1040 6.26433
R13306 VSS.n1084 VSS.n1040 6.26433
R13307 VSS.n1084 VSS.n1083 6.26433
R13308 VSS.n1083 VSS.n1082 6.26433
R13309 VSS.n1025 VSS.n562 6.26433
R13310 VSS.n1029 VSS.n562 6.26433
R13311 VSS.n1030 VSS.n1029 6.26433
R13312 VSS.n1031 VSS.n1030 6.26433
R13313 VSS.n997 VSS.n996 6.26433
R13314 VSS.n948 VSS.n933 6.26433
R13315 VSS.n944 VSS.n933 6.26433
R13316 VSS.n944 VSS.n943 6.26433
R13317 VSS.n943 VSS.n942 6.26433
R13318 VSS.n973 VSS.n926 6.26433
R13319 VSS.n969 VSS.n926 6.26433
R13320 VSS.n969 VSS.n968 6.26433
R13321 VSS.n968 VSS.n967 6.26433
R13322 VSS.n917 VSS.n916 6.26433
R13323 VSS.n892 VSS.n586 6.26433
R13324 VSS.n893 VSS.n892 6.26433
R13325 VSS.n836 VSS.n820 6.26433
R13326 VSS.n832 VSS.n820 6.26433
R13327 VSS.n832 VSS.n831 6.26433
R13328 VSS.n831 VSS.n830 6.26433
R13329 VSS.n861 VSS.n813 6.26433
R13330 VSS.n857 VSS.n813 6.26433
R13331 VSS.n857 VSS.n856 6.26433
R13332 VSS.n856 VSS.n855 6.26433
R13333 VSS.n798 VSS.n797 6.26433
R13334 VSS.n799 VSS.n798 6.26433
R13335 VSS.n775 VSS.n603 6.26433
R13336 VSS.n779 VSS.n603 6.26433
R13337 VSS.n780 VSS.n779 6.26433
R13338 VSS.n781 VSS.n780 6.26433
R13339 VSS.n746 VSS.n614 6.26433
R13340 VSS.n750 VSS.n614 6.26433
R13341 VSS.n751 VSS.n750 6.26433
R13342 VSS.n752 VSS.n751 6.26433
R13343 VSS.n723 VSS.n623 6.26433
R13344 VSS.n727 VSS.n623 6.26433
R13345 VSS.n728 VSS.n727 6.26433
R13346 VSS.n729 VSS.n728 6.26433
R13347 VSS.n700 VSS.n632 6.26433
R13348 VSS.n704 VSS.n632 6.26433
R13349 VSS.n683 VSS.n682 6.26433
R13350 VSS.n31 VSS.n53 5.11572
R13351 VSS.n655 VSS.n31 11.0743
R13352 VSS.n3 VSS.t285 10.8378
R13353 VSS.n292 VSS.n291 6.26433
R13354 VSS.n14334 VSS.n13659 6.26433
R13355 VSS.n14335 VSS.n14334 6.26433
R13356 VSS.n14336 VSS.n14335 6.26433
R13357 VSS.n13683 VSS.n13676 6.26433
R13358 VSS.n13679 VSS.n13678 6.26433
R13359 VSS.n13691 VSS.n13690 6.26433
R13360 VSS.n14308 VSS.n13668 6.26433
R13361 VSS.n14312 VSS.n13668 6.26433
R13362 VSS.n14280 VSS.n13712 6.26433
R13363 VSS.n14281 VSS.n14280 6.26433
R13364 VSS.n14282 VSS.n14281 6.26433
R13365 VSS.n14257 VSS.n13722 6.26433
R13366 VSS.n14261 VSS.n13722 6.26433
R13367 VSS.n14165 VSS.t84 6.26433
R13368 VSS.n14165 VSS.n14164 6.26433
R13369 VSS.n15221 VSS.n15137 6.26433
R13370 VSS.t10 VSS.n34 6.66192
R13371 VSS.n14822 VSS.t22 6.26433
R13372 VSS.t22 VSS.n376 6.26433
R13373 VSS.n14861 VSS.n194 6.26433
R13374 VSS.t3300 VSS.n194 6.26433
R13375 VSS.n14886 VSS.n14885 6.26433
R13376 VSS.n14932 VSS.n339 6.26433
R13377 VSS.n14928 VSS.n14927 6.26433
R13378 VSS.n15135 VSS.n15134 6.26433
R13379 VSS.n15135 VSS.n305 6.26433
R13380 VSS.n15076 VSS.n15075 6.26433
R13381 VSS.n15051 VSS.n15050 6.26433
R13382 VSS.n15050 VSS.n315 6.26433
R13383 VSS.n15125 VSS.n15083 6.26433
R13384 VSS.n15126 VSS.n15125 6.26433
R13385 VSS.n15127 VSS.n15126 6.26433
R13386 VSS.n15096 VSS.n15095 6.26433
R13387 VSS.n271 VSS.n246 6.26433
R13388 VSS.n275 VSS.n246 6.26433
R13389 VSS.n276 VSS.n275 6.26433
R13390 VSS.n277 VSS.n276 6.26433
R13391 VSS.t3120 VSS.n1 10.8378
R13392 VSS.n2896 VSS.n32 5.11572
R13393 VSS.n2897 VSS.n32 11.0743
R13394 VSS.n2566 VSS.n2547 6.26433
R13395 VSS.n2562 VSS.n2547 6.26433
R13396 VSS.n2562 VSS.n2561 6.26433
R13397 VSS.n2561 VSS.n2560 6.26433
R13398 VSS.n36 VSS.n2583 8.41958
R13399 VSS.n2595 VSS.n2583 6.26433
R13400 VSS.n2596 VSS.n2595 6.26433
R13401 VSS.n2597 VSS.n2596 6.26433
R13402 VSS.t3229 VSS.n57 10.8378
R13403 VSS.n2637 VSS.n2621 6.26433
R13404 VSS.n2633 VSS.n2621 6.26433
R13405 VSS.n2633 VSS.n2632 6.26433
R13406 VSS.n2632 VSS.n2631 6.26433
R13407 VSS.n2662 VSS.n2614 6.26433
R13408 VSS.n2658 VSS.n2614 6.26433
R13409 VSS.n2658 VSS.n2657 6.26433
R13410 VSS.n2657 VSS.n2656 6.26433
R13411 VSS.n3411 VSS.n2679 6.26433
R13412 VSS.n3415 VSS.n2679 6.26433
R13413 VSS.n3416 VSS.n3415 6.26433
R13414 VSS.n3417 VSS.n3416 6.26433
R13415 VSS.n3388 VSS.n2688 6.26433
R13416 VSS.n3392 VSS.n2688 6.26433
R13417 VSS.n3393 VSS.n3392 6.26433
R13418 VSS.n3394 VSS.n3393 6.26433
R13419 VSS.n3359 VSS.n2699 6.26433
R13420 VSS.n3363 VSS.n2699 6.26433
R13421 VSS.n3364 VSS.n3363 6.26433
R13422 VSS.n3365 VSS.n3364 6.26433
R13423 VSS.n3336 VSS.n2708 6.26433
R13424 VSS.n3340 VSS.n2708 6.26433
R13425 VSS.n3341 VSS.n3340 6.26433
R13426 VSS.n3342 VSS.n3341 6.26433
R13427 VSS.n3307 VSS.n2719 6.26433
R13428 VSS.n3311 VSS.n2719 6.26433
R13429 VSS.n3312 VSS.n3311 6.26433
R13430 VSS.n3313 VSS.n3312 6.26433
R13431 VSS.n3284 VSS.n2728 6.26433
R13432 VSS.n3288 VSS.n2728 6.26433
R13433 VSS.n3289 VSS.n3288 6.26433
R13434 VSS.n3290 VSS.n3289 6.26433
R13435 VSS.n3255 VSS.n2739 6.26433
R13436 VSS.n3259 VSS.n2739 6.26433
R13437 VSS.n3260 VSS.n3259 6.26433
R13438 VSS.n3261 VSS.n3260 6.26433
R13439 VSS.n3232 VSS.n2748 6.26433
R13440 VSS.n3236 VSS.n2748 6.26433
R13441 VSS.n3237 VSS.n3236 6.26433
R13442 VSS.n3238 VSS.n3237 6.26433
R13443 VSS.n3203 VSS.n2759 6.26433
R13444 VSS.n3207 VSS.n2759 6.26433
R13445 VSS.n3208 VSS.n3207 6.26433
R13446 VSS.n3209 VSS.n3208 6.26433
R13447 VSS.n3180 VSS.n2768 6.26433
R13448 VSS.n3184 VSS.n2768 6.26433
R13449 VSS.n3185 VSS.n3184 6.26433
R13450 VSS.n3186 VSS.n3185 6.26433
R13451 VSS.n3151 VSS.n2779 6.26433
R13452 VSS.n3155 VSS.n2779 6.26433
R13453 VSS.n3156 VSS.n3155 6.26433
R13454 VSS.n3157 VSS.n3156 6.26433
R13455 VSS.n3128 VSS.n2788 6.26433
R13456 VSS.n3132 VSS.n2788 6.26433
R13457 VSS.n3133 VSS.n3132 6.26433
R13458 VSS.n3134 VSS.n3133 6.26433
R13459 VSS.n3099 VSS.n2799 6.26433
R13460 VSS.n3103 VSS.n2799 6.26433
R13461 VSS.n3104 VSS.n3103 6.26433
R13462 VSS.n3105 VSS.n3104 6.26433
R13463 VSS.n3076 VSS.n2808 6.26433
R13464 VSS.n3080 VSS.n2808 6.26433
R13465 VSS.n3081 VSS.n3080 6.26433
R13466 VSS.n3082 VSS.n3081 6.26433
R13467 VSS.n3047 VSS.n2819 6.26433
R13468 VSS.n3051 VSS.n2819 6.26433
R13469 VSS.n3052 VSS.n3051 6.26433
R13470 VSS.n3053 VSS.n3052 6.26433
R13471 VSS.n3024 VSS.n2828 6.26433
R13472 VSS.n3028 VSS.n2828 6.26433
R13473 VSS.n3029 VSS.n3028 6.26433
R13474 VSS.n3030 VSS.n3029 6.26433
R13475 VSS.n2995 VSS.n2839 6.26433
R13476 VSS.n2999 VSS.n2839 6.26433
R13477 VSS.n3000 VSS.n2999 6.26433
R13478 VSS.n3001 VSS.n3000 6.26433
R13479 VSS.n2972 VSS.n2848 6.26433
R13480 VSS.n2976 VSS.n2848 6.26433
R13481 VSS.n2977 VSS.n2976 6.26433
R13482 VSS.n2978 VSS.n2977 6.26433
R13483 VSS.n2943 VSS.n2859 6.26433
R13484 VSS.n2947 VSS.n2859 6.26433
R13485 VSS.n2948 VSS.n2947 6.26433
R13486 VSS.n2949 VSS.n2948 6.26433
R13487 VSS.n2920 VSS.n2868 6.26433
R13488 VSS.n2924 VSS.n2868 6.26433
R13489 VSS.n2925 VSS.n2924 6.26433
R13490 VSS.n2926 VSS.n2925 6.26433
R13491 VSS.t3016 VSS.n3732 6.23427
R13492 VSS.t2798 VSS.n4853 6.23427
R13493 VSS.t2583 VSS.n4755 6.23427
R13494 VSS.t2368 VSS.n6836 6.23427
R13495 VSS.t2153 VSS.n2281 6.23427
R13496 VSS.t1938 VSS.n8373 6.23427
R13497 VSS.t1723 VSS.n2202 6.23427
R13498 VSS.t1505 VSS.n10356 6.23427
R13499 VSS.t1290 VSS.n1659 6.23427
R13500 VSS.t1075 VSS.n11893 6.23427
R13501 VSS.t860 VSS.n1561 6.23427
R13502 VSS.t650 VSS.n13843 6.23427
R13503 VSS.n3733 VSS.n3732 6.21764
R13504 VSS.n4854 VSS.n4853 6.21764
R13505 VSS.n4756 VSS.n4755 6.21764
R13506 VSS.n6837 VSS.n6836 6.21764
R13507 VSS.n2282 VSS.n2281 6.21764
R13508 VSS.n8374 VSS.n8373 6.21764
R13509 VSS.n2203 VSS.n2202 6.21764
R13510 VSS.n10357 VSS.n10356 6.21764
R13511 VSS.n1660 VSS.n1659 6.21764
R13512 VSS.n11894 VSS.n11893 6.21764
R13513 VSS.n1562 VSS.n1561 6.21764
R13514 VSS.n13844 VSS.n13843 6.21764
R13515 VSS.t223 VSS.n13712 6.12816
R13516 VSS.t24 VSS.n305 6.12816
R13517 VSS.t140 VSS.n15019 6.02403
R13518 VSS.t3111 VSS.n15294 5.98311
R13519 VSS.t395 VSS.n477 5.98311
R13520 VSS.n522 VSS.t389 5.98311
R13521 VSS.n1196 VSS.t371 5.98311
R13522 VSS.n1052 VSS.t356 5.98311
R13523 VSS.n937 VSS.t341 5.98311
R13524 VSS.n825 VSS.t326 5.98311
R13525 VSS.n804 VSS.t317 5.98311
R13526 VSS.t308 VSS.n757 5.98311
R13527 VSS.t293 VSS.n671 5.98311
R13528 VSS.n660 VSS.t290 5.98311
R13529 VSS.n14848 VSS.t430 5.98311
R13530 VSS.n254 VSS.t275 5.98311
R13531 VSS.t3126 VSS.n2902 5.98311
R13532 VSS.n2551 VSS.t3240 5.98311
R13533 VSS.n2602 VSS.t3234 5.98311
R13534 VSS.n2626 VSS.t3225 5.98311
R13535 VSS.n3422 VSS.t3216 5.98311
R13536 VSS.t3207 VSS.n3370 5.98311
R13537 VSS.t3198 VSS.n3318 5.98311
R13538 VSS.t3189 VSS.n3266 5.98311
R13539 VSS.t3180 VSS.n3214 5.98311
R13540 VSS.t3171 VSS.n3162 5.98311
R13541 VSS.t3162 VSS.n3110 5.98311
R13542 VSS.t3153 VSS.n3058 5.98311
R13543 VSS.t3144 VSS.n3006 5.98311
R13544 VSS.t3135 VSS.n2954 5.98311
R13545 VSS.n13691 VSS.t201 5.9239
R13546 VSS.t3114 VSS.n15316 5.85582
R13547 VSS.t3117 VSS.n15338 5.85582
R13548 VSS.t393 VSS.n474 5.85582
R13549 VSS.n517 VSS.t387 5.85582
R13550 VSS.t381 VSS.n1212 5.85582
R13551 VSS.n1223 VSS.t378 5.85582
R13552 VSS.n1250 VSS.t374 5.85582
R13553 VSS.n1191 VSS.t369 5.85582
R13554 VSS.n1168 VSS.t366 5.85582
R13555 VSS.t362 VSS.n1144 5.85582
R13556 VSS.n1124 VSS.t359 5.85582
R13557 VSS.n1057 VSS.t354 5.85582
R13558 VSS.n1082 VSS.t351 5.85582
R13559 VSS.n1031 VSS.t348 5.85582
R13560 VSS.t345 VSS.n997 5.85582
R13561 VSS.n942 VSS.t339 5.85582
R13562 VSS.n967 VSS.t336 5.85582
R13563 VSS.n917 VSS.t333 5.85582
R13564 VSS.t330 VSS.n893 5.85582
R13565 VSS.n830 VSS.t324 5.85582
R13566 VSS.n855 VSS.t321 5.85582
R13567 VSS.n799 VSS.t315 5.85582
R13568 VSS.n781 VSS.t312 5.85582
R13569 VSS.n752 VSS.t306 5.85582
R13570 VSS.n729 VSS.t303 5.85582
R13571 VSS.t300 VSS.n704 5.85582
R13572 VSS.n683 VSS.t296 5.85582
R13573 VSS.n655 VSS.t288 5.85582
R13574 VSS.t282 VSS.n292 5.85582
R13575 VSS.n4408 VSS.t2999 5.85582
R13576 VSS.n5140 VSS.t2784 5.85582
R13577 VSS.n6489 VSS.t2569 5.85582
R13578 VSS.n7531 VSS.t2354 5.85582
R13579 VSS.n7617 VSS.t2139 5.85582
R13580 VSS.n8660 VSS.t1924 5.85582
R13581 VSS.n10009 VSS.t1706 5.85582
R13582 VSS.n11051 VSS.t1491 5.85582
R13583 VSS.n11137 VSS.t1276 5.85582
R13584 VSS.n12180 VSS.t1061 5.85582
R13585 VSS.n13529 VSS.t846 5.85582
R13586 VSS.n14494 VSS.t636 5.85582
R13587 VSS.n14282 VSS.t696 5.85582
R13588 VSS.n14577 VSS.t466 5.85582
R13589 VSS.n14885 VSS.t504 5.85582
R13590 VSS.n14926 VSS.t419 5.85582
R13591 VSS.n15034 VSS.t495 5.85582
R13592 VSS.n15131 VSS.t488 5.85582
R13593 VSS.n15121 VSS.t102 5.85582
R13594 VSS.n15127 VSS.t485 5.85582
R13595 VSS.n277 VSS.t279 5.85582
R13596 VSS.n2897 VSS.t3123 5.85582
R13597 VSS.n2560 VSS.t3238 5.85582
R13598 VSS.n2597 VSS.t3232 5.85582
R13599 VSS.n2631 VSS.t3223 5.85582
R13600 VSS.n2656 VSS.t3220 5.85582
R13601 VSS.n3417 VSS.t3214 5.85582
R13602 VSS.n3394 VSS.t3211 5.85582
R13603 VSS.n3365 VSS.t3205 5.85582
R13604 VSS.n3342 VSS.t3202 5.85582
R13605 VSS.n3313 VSS.t3196 5.85582
R13606 VSS.n3290 VSS.t3193 5.85582
R13607 VSS.n3261 VSS.t3187 5.85582
R13608 VSS.n3238 VSS.t3184 5.85582
R13609 VSS.n3209 VSS.t3178 5.85582
R13610 VSS.n3186 VSS.t3175 5.85582
R13611 VSS.n3157 VSS.t3169 5.85582
R13612 VSS.n3134 VSS.t3166 5.85582
R13613 VSS.n3105 VSS.t3160 5.85582
R13614 VSS.n3082 VSS.t3157 5.85582
R13615 VSS.n3053 VSS.t3151 5.85582
R13616 VSS.n3030 VSS.t3148 5.85582
R13617 VSS.n3001 VSS.t3142 5.85582
R13618 VSS.n2978 VSS.t3139 5.85582
R13619 VSS.n2949 VSS.t3133 5.85582
R13620 VSS.n2926 VSS.t3130 5.85582
R13621 VSS.t3300 VSS.t428 5.85582
R13622 VSS.n485 VSS.n484 5.65809
R13623 VSS.n888 VSS.n586 5.65809
R13624 VSS.n797 VSS.n595 5.65809
R13625 VSS.n700 VSS.n699 5.65809
R13626 VSS.n14257 VSS.n14256 5.65809
R13627 VSS.n15052 VSS.n15051 5.65809
R13628 VSS.n13684 VSS.t67 5.65156
R13629 VSS.n15310 VSS.n15285 5.60959
R13630 VSS.n15332 VSS.n15275 5.60959
R13631 VSS.n1230 VSS.n1229 5.60959
R13632 VSS.n1185 VSS.n1184 5.60959
R13633 VSS.n1162 VSS.n1161 5.60959
R13634 VSS.n1064 VSS.n1063 5.60959
R13635 VSS.n1089 VSS.n1088 5.60959
R13636 VSS.n1025 VSS.n1024 5.60959
R13637 VSS.n949 VSS.n948 5.60959
R13638 VSS.n974 VSS.n973 5.60959
R13639 VSS.n837 VSS.n836 5.60959
R13640 VSS.n862 VSS.n861 5.60959
R13641 VSS.n775 VSS.n774 5.60959
R13642 VSS.n746 VSS.n745 5.60959
R13643 VSS.n723 VSS.n722 5.60959
R13644 VSS.n14330 VSS.n14329 5.60959
R13645 VSS.n14169 VSS.t84 5.60959
R13646 VSS.n15121 VSS.n15120 5.60959
R13647 VSS.n271 VSS.n270 5.60959
R13648 VSS.n2567 VSS.n2566 5.60959
R13649 VSS.n2638 VSS.n2637 5.60959
R13650 VSS.n2663 VSS.n2662 5.60959
R13651 VSS.n3411 VSS.n3410 5.60959
R13652 VSS.n3388 VSS.n3387 5.60959
R13653 VSS.n3359 VSS.n3358 5.60959
R13654 VSS.n3336 VSS.n3335 5.60959
R13655 VSS.n3307 VSS.n3306 5.60959
R13656 VSS.n3284 VSS.n3283 5.60959
R13657 VSS.n3255 VSS.n3254 5.60959
R13658 VSS.n3232 VSS.n3231 5.60959
R13659 VSS.n3203 VSS.n3202 5.60959
R13660 VSS.n3180 VSS.n3179 5.60959
R13661 VSS.n3151 VSS.n3150 5.60959
R13662 VSS.n3128 VSS.n3127 5.60959
R13663 VSS.n3099 VSS.n3098 5.60959
R13664 VSS.n3076 VSS.n3075 5.60959
R13665 VSS.n3047 VSS.n3046 5.60959
R13666 VSS.n3024 VSS.n3023 5.60959
R13667 VSS.n2995 VSS.n2994 5.60959
R13668 VSS.n2972 VSS.n2971 5.60959
R13669 VSS.n2943 VSS.n2942 5.60959
R13670 VSS.n2920 VSS.n2919 5.60959
R13671 VSS.t436 VSS.n376 5.51539
R13672 VSS.n14336 VSS.t708 5.44731
R13673 VSS.t694 VSS.t3313 5.44731
R13674 VSS.t239 VSS.t476 5.44731
R13675 VSS.t2999 VSS.t3001 5.43139
R13676 VSS.t2784 VSS.t2786 5.43139
R13677 VSS.t2569 VSS.t2571 5.43139
R13678 VSS.t2354 VSS.t2356 5.43139
R13679 VSS.t2139 VSS.t2141 5.43139
R13680 VSS.t1924 VSS.t1926 5.43139
R13681 VSS.t1706 VSS.t1708 5.43139
R13682 VSS.t1491 VSS.t1493 5.43139
R13683 VSS.t1276 VSS.t1278 5.43139
R13684 VSS.t1061 VSS.t1063 5.43139
R13685 VSS.t846 VSS.t848 5.43139
R13686 VSS.t636 VSS.t638 5.43139
R13687 VSS.t466 VSS.t468 5.43139
R13688 VSS.n4409 VSS.n4408 5.4059
R13689 VSS.n5141 VSS.n5140 5.4059
R13690 VSS.n6490 VSS.n6489 5.4059
R13691 VSS.n7532 VSS.n7531 5.4059
R13692 VSS.n7618 VSS.n7617 5.4059
R13693 VSS.n8661 VSS.n8660 5.4059
R13694 VSS.n10010 VSS.n10009 5.4059
R13695 VSS.n11052 VSS.n11051 5.4059
R13696 VSS.n11138 VSS.n11137 5.4059
R13697 VSS.n12181 VSS.n12180 5.4059
R13698 VSS.n13530 VSS.n13529 5.4059
R13699 VSS.n14495 VSS.n14494 5.4059
R13700 VSS.n14578 VSS.n14577 5.4059
R13701 VSS.n14823 VSS.n14822 5.4059
R13702 VSS.n14828 VSS.n373 5.37524
R13703 VSS.n14862 VSS.n14861 5.37524
R13704 VSS.n15034 VSS.n15033 5.37524
R13705 VSS.t187 VSS.t479 5.35702
R13706 VSS.t3290 VSS.t407 5.35702
R13707 VSS.n3784 VSS.t3555 5.28221
R13708 VSS.n2254 VSS.t3975 5.28221
R13709 VSS.n3804 VSS.t3519 5.27829
R13710 VSS.n5882 VSS.t3589 5.27829
R13711 VSS.n5885 VSS.t3659 5.27829
R13712 VSS.n6927 VSS.t3729 5.27829
R13713 VSS.n8364 VSS.t3799 5.27829
R13714 VSS.n9402 VSS.t3869 5.27829
R13715 VSS.n9405 VSS.t3939 5.27829
R13716 VSS.n10447 VSS.t4009 5.27829
R13717 VSS.n11884 VSS.t4079 5.27829
R13718 VSS.n12922 VSS.t4149 5.27829
R13719 VSS.n12925 VSS.t4219 5.27829
R13720 VSS.n13934 VSS.t4288 5.27829
R13721 VSS.t125 VSS.n15041 5.27109
R13722 VSS.t185 VSS.n14307 5.20108
R13723 VSS.n14933 VSS.t3360 5.20108
R13724 VSS.t2893 VSS.t3005 5.17299
R13725 VSS.t1600 VSS.t1712 5.17299
R13726 VSS.n14899 VSS.t424 5.06717
R13727 VSS.n13646 VSS.t713 5.04614
R13728 VSS.n13689 VSS.t607 5.04614
R13729 VSS.n13699 VSS.t604 5.04614
R13730 VSS.n14163 VSS.t595 5.04614
R13731 VSS.t69 VSS.n13676 5.0388
R13732 VSS.t168 VSS.n339 5.0388
R13733 VSS.n15075 VSS.t1 5.0388
R13734 VSS.n14160 VSS.t688 5.02529
R13735 VSS.n3795 VSS.t3520 4.97399
R13736 VSS.n5871 VSS.t3590 4.97399
R13737 VSS.n4837 VSS.t3660 4.97399
R13738 VSS.n6918 VSS.t3730 4.97399
R13739 VSS.n8353 VSS.t3800 4.97399
R13740 VSS.n9391 VSS.t3870 4.97399
R13741 VSS.n2265 VSS.t3940 4.97399
R13742 VSS.n10438 VSS.t4010 4.97399
R13743 VSS.n11873 VSS.t4080 4.97399
R13744 VSS.n12911 VSS.t4150 4.97399
R13745 VSS.n1643 VSS.t4220 4.97399
R13746 VSS.n13925 VSS.t4289 4.97399
R13747 VSS.t409 VSS.t4336 4.97399
R13748 VSS.t2681 VSS.t2678 4.94914
R13749 VSS.t2463 VSS.t2466 4.94914
R13750 VSS.t2248 VSS.t2251 4.94914
R13751 VSS.t2036 VSS.t2033 4.94914
R13752 VSS.t1821 VSS.t1818 4.94914
R13753 VSS.t1385 VSS.t1388 4.94914
R13754 VSS.t1173 VSS.t1170 4.94914
R13755 VSS.t958 VSS.t955 4.94914
R13756 VSS.t740 VSS.t743 4.94914
R13757 VSS.t545 VSS.t548 4.94914
R13758 VSS.t397 VSS.t400 4.94914
R13759 VSS.t473 VSS.t157 4.90263
R13760 VSS.n490 VSS.t4366 4.85762
R13761 VSS.t4394 VSS.n697 4.85762
R13762 VSS.n791 VSS.t4389 4.85762
R13763 VSS.t4384 VSS.n886 4.85762
R13764 VSS.t4272 VSS.n14254 4.85762
R13765 VSS.n14872 VSS.t4331 4.85762
R13766 VSS.n15058 VSS.t4337 4.85762
R13767 VSS.n15294 VSS.t3486 4.8005
R13768 VSS.n477 VSS.t4365 4.8005
R13769 VSS.n522 VSS.t4367 4.8005
R13770 VSS.n1196 VSS.t4372 4.8005
R13771 VSS.t4377 VSS.n1052 4.8005
R13772 VSS.t4381 VSS.n937 4.8005
R13773 VSS.t4385 VSS.n825 4.8005
R13774 VSS.n804 VSS.t4388 4.8005
R13775 VSS.n757 VSS.t4391 4.8005
R13776 VSS.n671 VSS.t4396 4.8005
R13777 VSS.n660 VSS.t4397 4.8005
R13778 VSS.t4359 VSS.n14921 4.8005
R13779 VSS.n254 VSS.t4401 4.8005
R13780 VSS.n2902 VSS.t3481 4.8005
R13781 VSS.n2551 VSS.t3443 4.8005
R13782 VSS.n2602 VSS.t3445 4.8005
R13783 VSS.t3448 VSS.n2626 4.8005
R13784 VSS.n3422 VSS.t3451 4.8005
R13785 VSS.n3370 VSS.t3454 4.8005
R13786 VSS.n3318 VSS.t3457 4.8005
R13787 VSS.n3266 VSS.t3460 4.8005
R13788 VSS.n3214 VSS.t3463 4.8005
R13789 VSS.n3162 VSS.t3466 4.8005
R13790 VSS.n3110 VSS.t3469 4.8005
R13791 VSS.n3058 VSS.t3472 4.8005
R13792 VSS.n3006 VSS.t3475 4.8005
R13793 VSS.n2954 VSS.t3478 4.8005
R13794 VSS.n14868 VSS.n14867 4.76901
R13795 VSS.t510 VSS.t4330 4.73093
R13796 VSS.n3793 VSS.n3792 4.62124
R13797 VSS.n3796 VSS.n3739 4.62124
R13798 VSS.n3805 VSS.n197 4.62124
R13799 VSS.n5870 VSS.n5799 4.62124
R13800 VSS.n5873 VSS.n5872 4.62124
R13801 VSS.n4858 VSS.n4857 4.62124
R13802 VSS.n4835 VSS.n4834 4.62124
R13803 VSS.n4838 VSS.n4762 4.62124
R13804 VSS.n5886 VSS.n200 4.62124
R13805 VSS.n6916 VSS.n6915 4.62124
R13806 VSS.n6919 VSS.n6843 4.62124
R13807 VSS.n6928 VSS.n202 4.62124
R13808 VSS.n8352 VSS.n8281 4.62124
R13809 VSS.n8355 VSS.n8354 4.62124
R13810 VSS.n2286 VSS.n2285 4.62124
R13811 VSS.n9390 VSS.n9319 4.62124
R13812 VSS.n9393 VSS.n9392 4.62124
R13813 VSS.n8378 VSS.n8377 4.62124
R13814 VSS.n2263 VSS.n2262 4.62124
R13815 VSS.n2266 VSS.n2209 4.62124
R13816 VSS.n9406 VSS.n206 4.62124
R13817 VSS.n10436 VSS.n10435 4.62124
R13818 VSS.n10439 VSS.n10363 4.62124
R13819 VSS.n10448 VSS.n208 4.62124
R13820 VSS.n11872 VSS.n11801 4.62124
R13821 VSS.n11875 VSS.n11874 4.62124
R13822 VSS.n1664 VSS.n1663 4.62124
R13823 VSS.n12910 VSS.n12839 4.62124
R13824 VSS.n12913 VSS.n12912 4.62124
R13825 VSS.n11898 VSS.n11897 4.62124
R13826 VSS.n1641 VSS.n1640 4.62124
R13827 VSS.n1644 VSS.n1568 4.62124
R13828 VSS.n12926 VSS.n212 4.62124
R13829 VSS.n13923 VSS.n13922 4.62124
R13830 VSS.n13926 VSS.n13850 4.62124
R13831 VSS.n13935 VSS.n214 4.62124
R13832 VSS.n3766 VSS.n3765 4.62124
R13833 VSS.n3783 VSS.n3746 4.62124
R13834 VSS.n191 VSS.n3803 4.62124
R13835 VSS.n3813 VSS.n3812 4.62124
R13836 VSS.n3868 VSS.n3867 4.62124
R13837 VSS.n3870 VSS.n3869 4.62124
R13838 VSS.n3871 VSS.n3699 4.62124
R13839 VSS.n3969 VSS.n3968 4.62124
R13840 VSS.n3971 VSS.n3970 4.62124
R13841 VSS.n3972 VSS.n3649 4.62124
R13842 VSS.n4070 VSS.n4069 4.62124
R13843 VSS.n4072 VSS.n4071 4.62124
R13844 VSS.n4073 VSS.n3599 4.62124
R13845 VSS.n4171 VSS.n4170 4.62124
R13846 VSS.n4173 VSS.n4172 4.62124
R13847 VSS.n4174 VSS.n3549 4.62124
R13848 VSS.n4272 VSS.n4271 4.62124
R13849 VSS.n4274 VSS.n4273 4.62124
R13850 VSS.n4275 VSS.n3499 4.62124
R13851 VSS.n4373 VSS.n4372 4.62124
R13852 VSS.n4396 VSS.n3451 4.62124
R13853 VSS.n4395 VSS.n4394 4.62124
R13854 VSS.n5881 VSS.n5880 4.62124
R13855 VSS.n4866 VSS.n4865 4.62124
R13856 VSS.n5737 VSS.n4886 4.62124
R13857 VSS.n4889 VSS.n4887 4.62124
R13858 VSS.n5736 VSS.n5735 4.62124
R13859 VSS.n5631 VSS.n4928 4.62124
R13860 VSS.n4931 VSS.n4929 4.62124
R13861 VSS.n5630 VSS.n5629 4.62124
R13862 VSS.n5525 VSS.n4970 4.62124
R13863 VSS.n4973 VSS.n4971 4.62124
R13864 VSS.n5524 VSS.n5523 4.62124
R13865 VSS.n5419 VSS.n5012 4.62124
R13866 VSS.n5015 VSS.n5013 4.62124
R13867 VSS.n5418 VSS.n5417 4.62124
R13868 VSS.n5313 VSS.n5054 4.62124
R13869 VSS.n5057 VSS.n5055 4.62124
R13870 VSS.n5312 VSS.n5311 4.62124
R13871 VSS.n5207 VSS.n5096 4.62124
R13872 VSS.n5099 VSS.n5097 4.62124
R13873 VSS.n5206 VSS.n5205 4.62124
R13874 VSS.n186 VSS.n4845 4.62124
R13875 VSS.n5894 VSS.n5893 4.62124
R13876 VSS.n5949 VSS.n5948 4.62124
R13877 VSS.n5951 VSS.n5950 4.62124
R13878 VSS.n5952 VSS.n4722 4.62124
R13879 VSS.n6050 VSS.n6049 4.62124
R13880 VSS.n6052 VSS.n6051 4.62124
R13881 VSS.n6053 VSS.n4672 4.62124
R13882 VSS.n6151 VSS.n6150 4.62124
R13883 VSS.n6153 VSS.n6152 4.62124
R13884 VSS.n6154 VSS.n4622 4.62124
R13885 VSS.n6252 VSS.n6251 4.62124
R13886 VSS.n6254 VSS.n6253 4.62124
R13887 VSS.n6255 VSS.n4572 4.62124
R13888 VSS.n6353 VSS.n6352 4.62124
R13889 VSS.n6355 VSS.n6354 4.62124
R13890 VSS.n6356 VSS.n4522 4.62124
R13891 VSS.n6454 VSS.n6453 4.62124
R13892 VSS.n6477 VSS.n4474 4.62124
R13893 VSS.n6476 VSS.n6475 4.62124
R13894 VSS.n183 VSS.n6926 4.62124
R13895 VSS.n6936 VSS.n6935 4.62124
R13896 VSS.n6991 VSS.n6990 4.62124
R13897 VSS.n6993 VSS.n6992 4.62124
R13898 VSS.n6994 VSS.n6803 4.62124
R13899 VSS.n7092 VSS.n7091 4.62124
R13900 VSS.n7094 VSS.n7093 4.62124
R13901 VSS.n7095 VSS.n6753 4.62124
R13902 VSS.n7193 VSS.n7192 4.62124
R13903 VSS.n7195 VSS.n7194 4.62124
R13904 VSS.n7196 VSS.n6703 4.62124
R13905 VSS.n7294 VSS.n7293 4.62124
R13906 VSS.n7296 VSS.n7295 4.62124
R13907 VSS.n7297 VSS.n6653 4.62124
R13908 VSS.n7395 VSS.n7394 4.62124
R13909 VSS.n7397 VSS.n7396 4.62124
R13910 VSS.n7398 VSS.n6603 4.62124
R13911 VSS.n7496 VSS.n7495 4.62124
R13912 VSS.n7519 VSS.n6555 4.62124
R13913 VSS.n7518 VSS.n7517 4.62124
R13914 VSS.n8363 VSS.n8362 4.62124
R13915 VSS.n2294 VSS.n2293 4.62124
R13916 VSS.n8219 VSS.n2314 4.62124
R13917 VSS.n2317 VSS.n2315 4.62124
R13918 VSS.n8218 VSS.n8217 4.62124
R13919 VSS.n8113 VSS.n2356 4.62124
R13920 VSS.n2359 VSS.n2357 4.62124
R13921 VSS.n8112 VSS.n8111 4.62124
R13922 VSS.n8007 VSS.n2398 4.62124
R13923 VSS.n2401 VSS.n2399 4.62124
R13924 VSS.n8006 VSS.n8005 4.62124
R13925 VSS.n7901 VSS.n2440 4.62124
R13926 VSS.n2443 VSS.n2441 4.62124
R13927 VSS.n7900 VSS.n7899 4.62124
R13928 VSS.n7795 VSS.n2482 4.62124
R13929 VSS.n2485 VSS.n2483 4.62124
R13930 VSS.n7794 VSS.n7793 4.62124
R13931 VSS.n7689 VSS.n2524 4.62124
R13932 VSS.n2527 VSS.n2525 4.62124
R13933 VSS.n7688 VSS.n7687 4.62124
R13934 VSS.n9401 VSS.n9400 4.62124
R13935 VSS.n8386 VSS.n8385 4.62124
R13936 VSS.n9257 VSS.n8406 4.62124
R13937 VSS.n8409 VSS.n8407 4.62124
R13938 VSS.n9256 VSS.n9255 4.62124
R13939 VSS.n9151 VSS.n8448 4.62124
R13940 VSS.n8451 VSS.n8449 4.62124
R13941 VSS.n9150 VSS.n9149 4.62124
R13942 VSS.n9045 VSS.n8490 4.62124
R13943 VSS.n8493 VSS.n8491 4.62124
R13944 VSS.n9044 VSS.n9043 4.62124
R13945 VSS.n8939 VSS.n8532 4.62124
R13946 VSS.n8535 VSS.n8533 4.62124
R13947 VSS.n8938 VSS.n8937 4.62124
R13948 VSS.n8833 VSS.n8574 4.62124
R13949 VSS.n8577 VSS.n8575 4.62124
R13950 VSS.n8832 VSS.n8831 4.62124
R13951 VSS.n8727 VSS.n8616 4.62124
R13952 VSS.n8619 VSS.n8617 4.62124
R13953 VSS.n8726 VSS.n8725 4.62124
R13954 VSS.n2236 VSS.n2235 4.62124
R13955 VSS.n2253 VSS.n2216 4.62124
R13956 VSS.n176 VSS.n2273 4.62124
R13957 VSS.n9414 VSS.n9413 4.62124
R13958 VSS.n9469 VSS.n9468 4.62124
R13959 VSS.n9471 VSS.n9470 4.62124
R13960 VSS.n9472 VSS.n2169 4.62124
R13961 VSS.n9570 VSS.n9569 4.62124
R13962 VSS.n9572 VSS.n9571 4.62124
R13963 VSS.n9573 VSS.n2119 4.62124
R13964 VSS.n9671 VSS.n9670 4.62124
R13965 VSS.n9673 VSS.n9672 4.62124
R13966 VSS.n9674 VSS.n2069 4.62124
R13967 VSS.n9772 VSS.n9771 4.62124
R13968 VSS.n9774 VSS.n9773 4.62124
R13969 VSS.n9775 VSS.n2019 4.62124
R13970 VSS.n9873 VSS.n9872 4.62124
R13971 VSS.n9875 VSS.n9874 4.62124
R13972 VSS.n9876 VSS.n1969 4.62124
R13973 VSS.n9974 VSS.n9973 4.62124
R13974 VSS.n9997 VSS.n1921 4.62124
R13975 VSS.n9996 VSS.n9995 4.62124
R13976 VSS.n173 VSS.n10446 4.62124
R13977 VSS.n10456 VSS.n10455 4.62124
R13978 VSS.n10511 VSS.n10510 4.62124
R13979 VSS.n10513 VSS.n10512 4.62124
R13980 VSS.n10514 VSS.n10323 4.62124
R13981 VSS.n10612 VSS.n10611 4.62124
R13982 VSS.n10614 VSS.n10613 4.62124
R13983 VSS.n10615 VSS.n10273 4.62124
R13984 VSS.n10713 VSS.n10712 4.62124
R13985 VSS.n10715 VSS.n10714 4.62124
R13986 VSS.n10716 VSS.n10223 4.62124
R13987 VSS.n10814 VSS.n10813 4.62124
R13988 VSS.n10816 VSS.n10815 4.62124
R13989 VSS.n10817 VSS.n10173 4.62124
R13990 VSS.n10915 VSS.n10914 4.62124
R13991 VSS.n10917 VSS.n10916 4.62124
R13992 VSS.n10918 VSS.n10123 4.62124
R13993 VSS.n11016 VSS.n11015 4.62124
R13994 VSS.n11039 VSS.n10075 4.62124
R13995 VSS.n11038 VSS.n11037 4.62124
R13996 VSS.n11883 VSS.n11882 4.62124
R13997 VSS.n1672 VSS.n1671 4.62124
R13998 VSS.n11739 VSS.n1692 4.62124
R13999 VSS.n1695 VSS.n1693 4.62124
R14000 VSS.n11738 VSS.n11737 4.62124
R14001 VSS.n11633 VSS.n1734 4.62124
R14002 VSS.n1737 VSS.n1735 4.62124
R14003 VSS.n11632 VSS.n11631 4.62124
R14004 VSS.n11527 VSS.n1776 4.62124
R14005 VSS.n1779 VSS.n1777 4.62124
R14006 VSS.n11526 VSS.n11525 4.62124
R14007 VSS.n11421 VSS.n1818 4.62124
R14008 VSS.n1821 VSS.n1819 4.62124
R14009 VSS.n11420 VSS.n11419 4.62124
R14010 VSS.n11315 VSS.n1860 4.62124
R14011 VSS.n1863 VSS.n1861 4.62124
R14012 VSS.n11314 VSS.n11313 4.62124
R14013 VSS.n11209 VSS.n1902 4.62124
R14014 VSS.n1905 VSS.n1903 4.62124
R14015 VSS.n11208 VSS.n11207 4.62124
R14016 VSS.n12921 VSS.n12920 4.62124
R14017 VSS.n11906 VSS.n11905 4.62124
R14018 VSS.n12777 VSS.n11926 4.62124
R14019 VSS.n11929 VSS.n11927 4.62124
R14020 VSS.n12776 VSS.n12775 4.62124
R14021 VSS.n12671 VSS.n11968 4.62124
R14022 VSS.n11971 VSS.n11969 4.62124
R14023 VSS.n12670 VSS.n12669 4.62124
R14024 VSS.n12565 VSS.n12010 4.62124
R14025 VSS.n12013 VSS.n12011 4.62124
R14026 VSS.n12564 VSS.n12563 4.62124
R14027 VSS.n12459 VSS.n12052 4.62124
R14028 VSS.n12055 VSS.n12053 4.62124
R14029 VSS.n12458 VSS.n12457 4.62124
R14030 VSS.n12353 VSS.n12094 4.62124
R14031 VSS.n12097 VSS.n12095 4.62124
R14032 VSS.n12352 VSS.n12351 4.62124
R14033 VSS.n12247 VSS.n12136 4.62124
R14034 VSS.n12139 VSS.n12137 4.62124
R14035 VSS.n12246 VSS.n12245 4.62124
R14036 VSS.n166 VSS.n1651 4.62124
R14037 VSS.n12934 VSS.n12933 4.62124
R14038 VSS.n12989 VSS.n12988 4.62124
R14039 VSS.n12991 VSS.n12990 4.62124
R14040 VSS.n12992 VSS.n1528 4.62124
R14041 VSS.n13090 VSS.n13089 4.62124
R14042 VSS.n13092 VSS.n13091 4.62124
R14043 VSS.n13093 VSS.n1478 4.62124
R14044 VSS.n13191 VSS.n13190 4.62124
R14045 VSS.n13193 VSS.n13192 4.62124
R14046 VSS.n13194 VSS.n1428 4.62124
R14047 VSS.n13292 VSS.n13291 4.62124
R14048 VSS.n13294 VSS.n13293 4.62124
R14049 VSS.n13295 VSS.n1378 4.62124
R14050 VSS.n13393 VSS.n13392 4.62124
R14051 VSS.n13395 VSS.n13394 4.62124
R14052 VSS.n13396 VSS.n1328 4.62124
R14053 VSS.n13494 VSS.n13493 4.62124
R14054 VSS.n13517 VSS.n1280 4.62124
R14055 VSS.n13516 VSS.n13515 4.62124
R14056 VSS.n163 VSS.n13933 4.62124
R14057 VSS.n13943 VSS.n13942 4.62124
R14058 VSS.n13998 VSS.n13997 4.62124
R14059 VSS.n14000 VSS.n13999 4.62124
R14060 VSS.n14001 VSS.n13810 4.62124
R14061 VSS.n14099 VSS.n14098 4.62124
R14062 VSS.n14101 VSS.n14100 4.62124
R14063 VSS.n14102 VSS.n13760 4.62124
R14064 VSS.n14180 VSS.n14156 4.62124
R14065 VSS.n14219 VSS.n14218 4.62124
R14066 VSS.n14361 VSS.n13643 4.62124
R14067 VSS.n14459 VSS.n14458 4.62124
R14068 VSS.n14482 VSS.n13595 4.62124
R14069 VSS.n14481 VSS.n14480 4.62124
R14070 VSS.t187 VSS.n302 4.62124
R14071 VSS.n15227 VSS.n15226 4.62124
R14072 VSS.t3290 VSS.n15044 4.62124
R14073 VSS.n15043 VSS.n317 4.62124
R14074 VSS.t3306 VSS.n15027 4.62124
R14075 VSS.n14649 VSS.n450 4.62124
R14076 VSS.n453 VSS.n451 4.62124
R14077 VSS.n14648 VSS.n14647 4.62124
R14078 VSS.n14244 VSS.t3430 4.51815
R14079 VSS.t3426 VSS.n14756 4.51815
R14080 VSS.n4414 VSS.n4413 4.51681
R14081 VSS.n5146 VSS.n5145 4.51681
R14082 VSS.n6495 VSS.n6494 4.51681
R14083 VSS.n7537 VSS.n7536 4.51681
R14084 VSS.n7623 VSS.n7622 4.51681
R14085 VSS.n8666 VSS.n8665 4.51681
R14086 VSS.n10015 VSS.n10014 4.51681
R14087 VSS.n11057 VSS.n11056 4.51681
R14088 VSS.n11143 VSS.n11142 4.51681
R14089 VSS.n12186 VSS.n12185 4.51681
R14090 VSS.n13535 VSS.n13534 4.51681
R14091 VSS.n14500 VSS.n14499 4.51681
R14092 VSS.n14583 VSS.n14582 4.51681
R14093 VSS.n4450 VSS.n4449 4.51681
R14094 VSS.n4366 VSS.n4365 4.51681
R14095 VSS.n4313 VSS.n4312 4.51681
R14096 VSS.n4265 VSS.n4264 4.51681
R14097 VSS.n4212 VSS.n4211 4.51681
R14098 VSS.n4164 VSS.n4163 4.51681
R14099 VSS.n4111 VSS.n4110 4.51681
R14100 VSS.n4063 VSS.n4062 4.51681
R14101 VSS.n4010 VSS.n4009 4.51681
R14102 VSS.n3962 VSS.n3961 4.51681
R14103 VSS.n3909 VSS.n3908 4.51681
R14104 VSS.n3861 VSS.n3860 4.51681
R14105 VSS.n5182 VSS.n5181 4.51681
R14106 VSS.n5213 VSS.n5212 4.51681
R14107 VSS.n5274 VSS.n5273 4.51681
R14108 VSS.n5319 VSS.n5318 4.51681
R14109 VSS.n5380 VSS.n5379 4.51681
R14110 VSS.n5425 VSS.n5424 4.51681
R14111 VSS.n5486 VSS.n5485 4.51681
R14112 VSS.n5531 VSS.n5530 4.51681
R14113 VSS.n5592 VSS.n5591 4.51681
R14114 VSS.n5637 VSS.n5636 4.51681
R14115 VSS.n5698 VSS.n5697 4.51681
R14116 VSS.n5743 VSS.n5742 4.51681
R14117 VSS.n6531 VSS.n6530 4.51681
R14118 VSS.n6447 VSS.n6446 4.51681
R14119 VSS.n6394 VSS.n6393 4.51681
R14120 VSS.n6346 VSS.n6345 4.51681
R14121 VSS.n6293 VSS.n6292 4.51681
R14122 VSS.n6245 VSS.n6244 4.51681
R14123 VSS.n6192 VSS.n6191 4.51681
R14124 VSS.n6144 VSS.n6143 4.51681
R14125 VSS.n6091 VSS.n6090 4.51681
R14126 VSS.n6043 VSS.n6042 4.51681
R14127 VSS.n5990 VSS.n5989 4.51681
R14128 VSS.n5942 VSS.n5941 4.51681
R14129 VSS.n7573 VSS.n7572 4.51681
R14130 VSS.n7489 VSS.n7488 4.51681
R14131 VSS.n7436 VSS.n7435 4.51681
R14132 VSS.n7388 VSS.n7387 4.51681
R14133 VSS.n7335 VSS.n7334 4.51681
R14134 VSS.n7287 VSS.n7286 4.51681
R14135 VSS.n7234 VSS.n7233 4.51681
R14136 VSS.n7186 VSS.n7185 4.51681
R14137 VSS.n7133 VSS.n7132 4.51681
R14138 VSS.n7085 VSS.n7084 4.51681
R14139 VSS.n7032 VSS.n7031 4.51681
R14140 VSS.n6984 VSS.n6983 4.51681
R14141 VSS.n7659 VSS.n7658 4.51681
R14142 VSS.n7695 VSS.n7694 4.51681
R14143 VSS.n7756 VSS.n7755 4.51681
R14144 VSS.n7801 VSS.n7800 4.51681
R14145 VSS.n7862 VSS.n7861 4.51681
R14146 VSS.n7907 VSS.n7906 4.51681
R14147 VSS.n7968 VSS.n7967 4.51681
R14148 VSS.n8013 VSS.n8012 4.51681
R14149 VSS.n8074 VSS.n8073 4.51681
R14150 VSS.n8119 VSS.n8118 4.51681
R14151 VSS.n8180 VSS.n8179 4.51681
R14152 VSS.n8225 VSS.n8224 4.51681
R14153 VSS.n8702 VSS.n8701 4.51681
R14154 VSS.n8733 VSS.n8732 4.51681
R14155 VSS.n8794 VSS.n8793 4.51681
R14156 VSS.n8839 VSS.n8838 4.51681
R14157 VSS.n8900 VSS.n8899 4.51681
R14158 VSS.n8945 VSS.n8944 4.51681
R14159 VSS.n9006 VSS.n9005 4.51681
R14160 VSS.n9051 VSS.n9050 4.51681
R14161 VSS.n9112 VSS.n9111 4.51681
R14162 VSS.n9157 VSS.n9156 4.51681
R14163 VSS.n9218 VSS.n9217 4.51681
R14164 VSS.n9263 VSS.n9262 4.51681
R14165 VSS.n10051 VSS.n10050 4.51681
R14166 VSS.n9967 VSS.n9966 4.51681
R14167 VSS.n9914 VSS.n9913 4.51681
R14168 VSS.n9866 VSS.n9865 4.51681
R14169 VSS.n9813 VSS.n9812 4.51681
R14170 VSS.n9765 VSS.n9764 4.51681
R14171 VSS.n9712 VSS.n9711 4.51681
R14172 VSS.n9664 VSS.n9663 4.51681
R14173 VSS.n9611 VSS.n9610 4.51681
R14174 VSS.n9563 VSS.n9562 4.51681
R14175 VSS.n9510 VSS.n9509 4.51681
R14176 VSS.n9462 VSS.n9461 4.51681
R14177 VSS.n11093 VSS.n11092 4.51681
R14178 VSS.n11009 VSS.n11008 4.51681
R14179 VSS.n10956 VSS.n10955 4.51681
R14180 VSS.n10908 VSS.n10907 4.51681
R14181 VSS.n10855 VSS.n10854 4.51681
R14182 VSS.n10807 VSS.n10806 4.51681
R14183 VSS.n10754 VSS.n10753 4.51681
R14184 VSS.n10706 VSS.n10705 4.51681
R14185 VSS.n10653 VSS.n10652 4.51681
R14186 VSS.n10605 VSS.n10604 4.51681
R14187 VSS.n10552 VSS.n10551 4.51681
R14188 VSS.n10504 VSS.n10503 4.51681
R14189 VSS.n11179 VSS.n11178 4.51681
R14190 VSS.n11215 VSS.n11214 4.51681
R14191 VSS.n11276 VSS.n11275 4.51681
R14192 VSS.n11321 VSS.n11320 4.51681
R14193 VSS.n11382 VSS.n11381 4.51681
R14194 VSS.n11427 VSS.n11426 4.51681
R14195 VSS.n11488 VSS.n11487 4.51681
R14196 VSS.n11533 VSS.n11532 4.51681
R14197 VSS.n11594 VSS.n11593 4.51681
R14198 VSS.n11639 VSS.n11638 4.51681
R14199 VSS.n11700 VSS.n11699 4.51681
R14200 VSS.n11745 VSS.n11744 4.51681
R14201 VSS.n12222 VSS.n12221 4.51681
R14202 VSS.n12253 VSS.n12252 4.51681
R14203 VSS.n12314 VSS.n12313 4.51681
R14204 VSS.n12359 VSS.n12358 4.51681
R14205 VSS.n12420 VSS.n12419 4.51681
R14206 VSS.n12465 VSS.n12464 4.51681
R14207 VSS.n12526 VSS.n12525 4.51681
R14208 VSS.n12571 VSS.n12570 4.51681
R14209 VSS.n12632 VSS.n12631 4.51681
R14210 VSS.n12677 VSS.n12676 4.51681
R14211 VSS.n12738 VSS.n12737 4.51681
R14212 VSS.n12783 VSS.n12782 4.51681
R14213 VSS.n13571 VSS.n13570 4.51681
R14214 VSS.n13487 VSS.n13486 4.51681
R14215 VSS.n13434 VSS.n13433 4.51681
R14216 VSS.n13386 VSS.n13385 4.51681
R14217 VSS.n13333 VSS.n13332 4.51681
R14218 VSS.n13285 VSS.n13284 4.51681
R14219 VSS.n13232 VSS.n13231 4.51681
R14220 VSS.n13184 VSS.n13183 4.51681
R14221 VSS.n13131 VSS.n13130 4.51681
R14222 VSS.n13083 VSS.n13082 4.51681
R14223 VSS.n13030 VSS.n13029 4.51681
R14224 VSS.n12982 VSS.n12981 4.51681
R14225 VSS.n14536 VSS.n14535 4.51681
R14226 VSS.n14452 VSS.n14451 4.51681
R14227 VSS.n14399 VSS.n14398 4.51681
R14228 VSS.n14233 VSS.n14232 4.51681
R14229 VSS.n14186 VSS.n14185 4.51681
R14230 VSS.n14140 VSS.n14139 4.51681
R14231 VSS.n14092 VSS.n14091 4.51681
R14232 VSS.n14039 VSS.n14038 4.51681
R14233 VSS.n13991 VSS.n13990 4.51681
R14234 VSS.n14619 VSS.n14618 4.51681
R14235 VSS.n14655 VSS.n14654 4.51681
R14236 VSS.n4463 VSS.n6 2.57344
R14237 VSS.n224 VSS.n8 2.57344
R14238 VSS.n6544 VSS.n10 2.57344
R14239 VSS.n7586 VSS.n12 2.57344
R14240 VSS.n7672 VSS.n14 2.57344
R14241 VSS.n223 VSS.n16 2.57344
R14242 VSS.n10064 VSS.n18 2.57344
R14243 VSS.n11106 VSS.n20 2.57344
R14244 VSS.n11192 VSS.n22 2.57344
R14245 VSS.n222 VSS.n24 2.57344
R14246 VSS.n13584 VSS.n26 2.57344
R14247 VSS.n14549 VSS.n28 2.57344
R14248 VSS.n14632 VSS.n30 2.57344
R14249 VSS.n193 VSS.n101 0.179323
R14250 VSS.n103 VSS.n190 0.179323
R14251 VSS.n105 VSS.n188 0.179323
R14252 VSS.n185 VSS.n107 0.179323
R14253 VSS.n109 VSS.n182 0.179323
R14254 VSS.n111 VSS.n180 0.179323
R14255 VSS.n113 VSS.n178 0.179323
R14256 VSS.n175 VSS.n115 0.179323
R14257 VSS.n117 VSS.n172 0.179323
R14258 VSS.n119 VSS.n170 0.179323
R14259 VSS.n121 VSS.n168 0.179323
R14260 VSS.n165 VSS.n123 0.179323
R14261 VSS.n3765 VSS.n3752 4.4978
R14262 VSS.n4395 VSS.n4374 4.4978
R14263 VSS.n4276 VSS.n4275 4.4978
R14264 VSS.n4175 VSS.n4174 4.4978
R14265 VSS.n4074 VSS.n4073 4.4978
R14266 VSS.n3973 VSS.n3972 4.4978
R14267 VSS.n3872 VSS.n3871 4.4978
R14268 VSS.n5206 VSS.n5098 4.4978
R14269 VSS.n5312 VSS.n5056 4.4978
R14270 VSS.n5418 VSS.n5014 4.4978
R14271 VSS.n5524 VSS.n4972 4.4978
R14272 VSS.n5630 VSS.n4930 4.4978
R14273 VSS.n5736 VSS.n4888 4.4978
R14274 VSS.n6476 VSS.n6455 4.4978
R14275 VSS.n6357 VSS.n6356 4.4978
R14276 VSS.n6256 VSS.n6255 4.4978
R14277 VSS.n6155 VSS.n6154 4.4978
R14278 VSS.n6054 VSS.n6053 4.4978
R14279 VSS.n5953 VSS.n5952 4.4978
R14280 VSS.n7518 VSS.n7497 4.4978
R14281 VSS.n7399 VSS.n7398 4.4978
R14282 VSS.n7298 VSS.n7297 4.4978
R14283 VSS.n7197 VSS.n7196 4.4978
R14284 VSS.n7096 VSS.n7095 4.4978
R14285 VSS.n6995 VSS.n6994 4.4978
R14286 VSS.n7688 VSS.n2526 4.4978
R14287 VSS.n7794 VSS.n2484 4.4978
R14288 VSS.n7900 VSS.n2442 4.4978
R14289 VSS.n8006 VSS.n2400 4.4978
R14290 VSS.n8112 VSS.n2358 4.4978
R14291 VSS.n8218 VSS.n2316 4.4978
R14292 VSS.n8726 VSS.n8618 4.4978
R14293 VSS.n8832 VSS.n8576 4.4978
R14294 VSS.n8938 VSS.n8534 4.4978
R14295 VSS.n9044 VSS.n8492 4.4978
R14296 VSS.n9150 VSS.n8450 4.4978
R14297 VSS.n9256 VSS.n8408 4.4978
R14298 VSS.n2235 VSS.n2222 4.4978
R14299 VSS.n9996 VSS.n9975 4.4978
R14300 VSS.n9877 VSS.n9876 4.4978
R14301 VSS.n9776 VSS.n9775 4.4978
R14302 VSS.n9675 VSS.n9674 4.4978
R14303 VSS.n9574 VSS.n9573 4.4978
R14304 VSS.n9473 VSS.n9472 4.4978
R14305 VSS.n11038 VSS.n11017 4.4978
R14306 VSS.n10919 VSS.n10918 4.4978
R14307 VSS.n10818 VSS.n10817 4.4978
R14308 VSS.n10717 VSS.n10716 4.4978
R14309 VSS.n10616 VSS.n10615 4.4978
R14310 VSS.n10515 VSS.n10514 4.4978
R14311 VSS.n11208 VSS.n1904 4.4978
R14312 VSS.n11314 VSS.n1862 4.4978
R14313 VSS.n11420 VSS.n1820 4.4978
R14314 VSS.n11526 VSS.n1778 4.4978
R14315 VSS.n11632 VSS.n1736 4.4978
R14316 VSS.n11738 VSS.n1694 4.4978
R14317 VSS.n12246 VSS.n12138 4.4978
R14318 VSS.n12352 VSS.n12096 4.4978
R14319 VSS.n12458 VSS.n12054 4.4978
R14320 VSS.n12564 VSS.n12012 4.4978
R14321 VSS.n12670 VSS.n11970 4.4978
R14322 VSS.n12776 VSS.n11928 4.4978
R14323 VSS.n13516 VSS.n13495 4.4978
R14324 VSS.n13397 VSS.n13396 4.4978
R14325 VSS.n13296 VSS.n13295 4.4978
R14326 VSS.n13195 VSS.n13194 4.4978
R14327 VSS.n13094 VSS.n13093 4.4978
R14328 VSS.n12993 VSS.n12992 4.4978
R14329 VSS.n14481 VSS.n14460 4.4978
R14330 VSS.n14362 VSS.n14361 4.4978
R14331 VSS.n14218 VSS.n13737 4.4978
R14332 VSS.n14103 VSS.n14102 4.4978
R14333 VSS.n14002 VSS.n14001 4.4978
R14334 VSS.n14648 VSS.n452 4.4978
R14335 VSS.t3316 VSS.n13659 4.42603
R14336 VSS.n13685 VSS.n13684 4.42603
R14337 VSS.n13695 VSS.n13694 4.42603
R14338 VSS.n4429 VSS.t3108 4.41131
R14339 VSS.t3096 VSS.n3459 4.41131
R14340 VSS.t3081 VSS.n3509 4.41131
R14341 VSS.t3066 VSS.n3559 4.41131
R14342 VSS.t3051 VSS.n3609 4.41131
R14343 VSS.t3036 VSS.n3659 4.41131
R14344 VSS.t3021 VSS.n3709 4.41131
R14345 VSS.n5161 VSS.t2890 4.41131
R14346 VSS.t2878 VSS.n5228 4.41131
R14347 VSS.t2863 VSS.n5334 4.41131
R14348 VSS.t2848 VSS.n5440 4.41131
R14349 VSS.t2833 VSS.n5546 4.41131
R14350 VSS.t2818 VSS.n5652 4.41131
R14351 VSS.t2803 VSS.n5758 4.41131
R14352 VSS.n6510 VSS.t2675 4.41131
R14353 VSS.t2663 VSS.n4482 4.41131
R14354 VSS.t2648 VSS.n4532 4.41131
R14355 VSS.t2633 VSS.n4582 4.41131
R14356 VSS.t2618 VSS.n4632 4.41131
R14357 VSS.t2603 VSS.n4682 4.41131
R14358 VSS.t2588 VSS.n4732 4.41131
R14359 VSS.n7552 VSS.t2460 4.41131
R14360 VSS.t2448 VSS.n6563 4.41131
R14361 VSS.t2433 VSS.n6613 4.41131
R14362 VSS.t2418 VSS.n6663 4.41131
R14363 VSS.t2403 VSS.n6713 4.41131
R14364 VSS.t2388 VSS.n6763 4.41131
R14365 VSS.t2373 VSS.n6813 4.41131
R14366 VSS.n7638 VSS.t2245 4.41131
R14367 VSS.t2233 VSS.n7710 4.41131
R14368 VSS.t2218 VSS.n7816 4.41131
R14369 VSS.t2203 VSS.n7922 4.41131
R14370 VSS.t2188 VSS.n8028 4.41131
R14371 VSS.t2173 VSS.n8134 4.41131
R14372 VSS.t2158 VSS.n8240 4.41131
R14373 VSS.n8681 VSS.t2030 4.41131
R14374 VSS.t2018 VSS.n8748 4.41131
R14375 VSS.t2003 VSS.n8854 4.41131
R14376 VSS.t1988 VSS.n8960 4.41131
R14377 VSS.t1973 VSS.n9066 4.41131
R14378 VSS.t1958 VSS.n9172 4.41131
R14379 VSS.t1943 VSS.n9278 4.41131
R14380 VSS.n10030 VSS.t1815 4.41131
R14381 VSS.t1803 VSS.n1929 4.41131
R14382 VSS.t1788 VSS.n1979 4.41131
R14383 VSS.t1773 VSS.n2029 4.41131
R14384 VSS.t1758 VSS.n2079 4.41131
R14385 VSS.t1743 VSS.n2129 4.41131
R14386 VSS.t1728 VSS.n2179 4.41131
R14387 VSS.n11072 VSS.t1597 4.41131
R14388 VSS.t1585 VSS.n10083 4.41131
R14389 VSS.t1570 VSS.n10133 4.41131
R14390 VSS.t1555 VSS.n10183 4.41131
R14391 VSS.t1540 VSS.n10233 4.41131
R14392 VSS.t1525 VSS.n10283 4.41131
R14393 VSS.t1510 VSS.n10333 4.41131
R14394 VSS.n11158 VSS.t1382 4.41131
R14395 VSS.t1370 VSS.n11230 4.41131
R14396 VSS.t1355 VSS.n11336 4.41131
R14397 VSS.t1340 VSS.n11442 4.41131
R14398 VSS.t1325 VSS.n11548 4.41131
R14399 VSS.t1310 VSS.n11654 4.41131
R14400 VSS.t1295 VSS.n11760 4.41131
R14401 VSS.n12201 VSS.t1167 4.41131
R14402 VSS.t1155 VSS.n12268 4.41131
R14403 VSS.t1140 VSS.n12374 4.41131
R14404 VSS.t1125 VSS.n12480 4.41131
R14405 VSS.t1110 VSS.n12586 4.41131
R14406 VSS.t1095 VSS.n12692 4.41131
R14407 VSS.t1080 VSS.n12798 4.41131
R14408 VSS.n13550 VSS.t952 4.41131
R14409 VSS.t940 VSS.n1288 4.41131
R14410 VSS.t925 VSS.n1338 4.41131
R14411 VSS.t910 VSS.n1388 4.41131
R14412 VSS.t895 VSS.n1438 4.41131
R14413 VSS.t880 VSS.n1488 4.41131
R14414 VSS.t865 VSS.n1538 4.41131
R14415 VSS.n14515 VSS.t737 4.41131
R14416 VSS.t725 VSS.n13603 4.41131
R14417 VSS.t682 VSS.n14201 4.41131
R14418 VSS.t670 VSS.n13770 4.41131
R14419 VSS.t655 VSS.n13820 4.41131
R14420 VSS.n14598 VSS.t542 4.41131
R14421 VSS.t530 VSS.n14670 4.41131
R14422 VSS.t380 VSS.n1218 4.28986
R14423 VSS.n996 VSS.t344 4.28986
R14424 VSS.n916 VSS.t332 4.28986
R14425 VSS.n291 VSS.t281 4.28986
R14426 VSS.n13690 VSS.t702 4.28986
R14427 VSS.n14312 VSS.t699 4.28986
R14428 VSS.n14164 VSS.t686 4.28986
R14429 VSS.n14927 VSS.t165 4.22178
R14430 VSS.t3012 VSS.t3519 4.14459
R14431 VSS.t3589 VSS.t2794 4.14459
R14432 VSS.t2579 VSS.t3659 4.14459
R14433 VSS.t2364 VSS.t3729 4.14459
R14434 VSS.t3799 VSS.t2149 4.14459
R14435 VSS.t3869 VSS.t1934 4.14459
R14436 VSS.t1719 VSS.t3939 4.14459
R14437 VSS.t1501 VSS.t4009 4.14459
R14438 VSS.t4079 VSS.t1286 4.14459
R14439 VSS.t4149 VSS.t1071 4.14459
R14440 VSS.t856 VSS.t4219 4.14459
R14441 VSS.t646 VSS.t4288 4.14459
R14442 VSS.n14780 VSS.t89 4.14168
R14443 VSS.t211 VSS.n14836 4.14168
R14444 VSS.n14836 VSS.t3333 4.14168
R14445 VSS.n219 VSS.t524 4.10717
R14446 VSS.n221 VSS.t521 4.10717
R14447 VSS.t611 VSS.n13646 4.09013
R14448 VSS.t702 VSS.n13689 4.09013
R14449 VSS.n13699 VSS.t699 4.09013
R14450 VSS.t686 VSS.n14163 4.09013
R14451 VSS.n1219 VSS.t380 4.07323
R14452 VSS.n574 VSS.t344 4.07323
R14453 VSS.t332 VSS.n915 4.07323
R14454 VSS.n242 VSS.t281 4.07323
R14455 VSS.n14160 VSS.t596 4.07323
R14456 VSS.n14796 VSS.t441 4.07323
R14457 VSS.n15300 VSS.n15291 4.03338
R14458 VSS.n15322 VSS.n15281 4.03338
R14459 VSS.n70 VSS.n507 2.79786
R14460 VSS.n1263 VSS.n463 4.03338
R14461 VSS.n1241 VSS.n1205 4.03338
R14462 VSS.n1176 VSS.n1175 4.03338
R14463 VSS.n1153 VSS.n1152 4.03338
R14464 VSS.n1074 VSS.n1043 4.03338
R14465 VSS.n1100 VSS.n1036 4.03338
R14466 VSS.n1016 VSS.n1015 4.03338
R14467 VSS.n959 VSS.n929 4.03338
R14468 VSS.n985 VSS.n922 4.03338
R14469 VSS.n847 VSS.n816 4.03338
R14470 VSS.n873 VSS.n809 4.03338
R14471 VSS.n766 VSS.n765 4.03338
R14472 VSS.n737 VSS.n736 4.03338
R14473 VSS.n714 VSS.n713 4.03338
R14474 VSS.n162 VSS.n650 2.79786
R14475 VSS.n15251 VSS.n298 4.03338
R14476 VSS.n4440 VSS.n3449 4.03338
R14477 VSS.n3481 VSS.n3477 4.03338
R14478 VSS.n3531 VSS.n3527 4.03338
R14479 VSS.n3581 VSS.n3577 4.03338
R14480 VSS.n3631 VSS.n3627 4.03338
R14481 VSS.n3681 VSS.n3677 4.03338
R14482 VSS.n3731 VSS.n3727 4.03338
R14483 VSS.n5172 VSS.n5117 4.03338
R14484 VSS.n5264 VSS.n5076 4.03338
R14485 VSS.n5370 VSS.n5034 4.03338
R14486 VSS.n5476 VSS.n4992 4.03338
R14487 VSS.n5582 VSS.n4950 4.03338
R14488 VSS.n5688 VSS.n4908 4.03338
R14489 VSS.n5793 VSS.n5792 4.03338
R14490 VSS.n6521 VSS.n4472 4.03338
R14491 VSS.n4504 VSS.n4500 4.03338
R14492 VSS.n4554 VSS.n4550 4.03338
R14493 VSS.n4604 VSS.n4600 4.03338
R14494 VSS.n4654 VSS.n4650 4.03338
R14495 VSS.n4704 VSS.n4700 4.03338
R14496 VSS.n4754 VSS.n4750 4.03338
R14497 VSS.n7563 VSS.n6553 4.03338
R14498 VSS.n6585 VSS.n6581 4.03338
R14499 VSS.n6635 VSS.n6631 4.03338
R14500 VSS.n6685 VSS.n6681 4.03338
R14501 VSS.n6735 VSS.n6731 4.03338
R14502 VSS.n6785 VSS.n6781 4.03338
R14503 VSS.n6835 VSS.n6831 4.03338
R14504 VSS.n7649 VSS.n7594 4.03338
R14505 VSS.n7746 VSS.n2504 4.03338
R14506 VSS.n7852 VSS.n2462 4.03338
R14507 VSS.n7958 VSS.n2420 4.03338
R14508 VSS.n8064 VSS.n2378 4.03338
R14509 VSS.n8170 VSS.n2336 4.03338
R14510 VSS.n8275 VSS.n8274 4.03338
R14511 VSS.n8692 VSS.n8637 4.03338
R14512 VSS.n8784 VSS.n8596 4.03338
R14513 VSS.n8890 VSS.n8554 4.03338
R14514 VSS.n8996 VSS.n8512 4.03338
R14515 VSS.n9102 VSS.n8470 4.03338
R14516 VSS.n9208 VSS.n8428 4.03338
R14517 VSS.n9313 VSS.n9312 4.03338
R14518 VSS.n10041 VSS.n1919 4.03338
R14519 VSS.n1951 VSS.n1947 4.03338
R14520 VSS.n2001 VSS.n1997 4.03338
R14521 VSS.n2051 VSS.n2047 4.03338
R14522 VSS.n2101 VSS.n2097 4.03338
R14523 VSS.n2151 VSS.n2147 4.03338
R14524 VSS.n2201 VSS.n2197 4.03338
R14525 VSS.n11083 VSS.n10073 4.03338
R14526 VSS.n10105 VSS.n10101 4.03338
R14527 VSS.n10155 VSS.n10151 4.03338
R14528 VSS.n10205 VSS.n10201 4.03338
R14529 VSS.n10255 VSS.n10251 4.03338
R14530 VSS.n10305 VSS.n10301 4.03338
R14531 VSS.n10355 VSS.n10351 4.03338
R14532 VSS.n11169 VSS.n11114 4.03338
R14533 VSS.n11266 VSS.n1882 4.03338
R14534 VSS.n11372 VSS.n1840 4.03338
R14535 VSS.n11478 VSS.n1798 4.03338
R14536 VSS.n11584 VSS.n1756 4.03338
R14537 VSS.n11690 VSS.n1714 4.03338
R14538 VSS.n11795 VSS.n11794 4.03338
R14539 VSS.n12212 VSS.n12157 4.03338
R14540 VSS.n12304 VSS.n12116 4.03338
R14541 VSS.n12410 VSS.n12074 4.03338
R14542 VSS.n12516 VSS.n12032 4.03338
R14543 VSS.n12622 VSS.n11990 4.03338
R14544 VSS.n12728 VSS.n11948 4.03338
R14545 VSS.n12833 VSS.n12832 4.03338
R14546 VSS.n13561 VSS.n1278 4.03338
R14547 VSS.n1310 VSS.n1306 4.03338
R14548 VSS.n1360 VSS.n1356 4.03338
R14549 VSS.n1410 VSS.n1406 4.03338
R14550 VSS.n1460 VSS.n1456 4.03338
R14551 VSS.n1510 VSS.n1506 4.03338
R14552 VSS.n1560 VSS.n1556 4.03338
R14553 VSS.n14526 VSS.n13593 4.03338
R14554 VSS.n13625 VSS.n13621 4.03338
R14555 VSS.n14342 VSS.t232 4.03338
R14556 VSS.n14299 VSS.n14298 4.03338
R14557 VSS.n14211 VSS.n14210 4.03338
R14558 VSS.n13792 VSS.n13788 4.03338
R14559 VSS.n13842 VSS.n13838 4.03338
R14560 VSS.n14609 VSS.n14557 4.03338
R14561 VSS.n14706 VSS.t525 4.03338
R14562 VSS.n14725 VSS.t522 4.03338
R14563 VSS.n14743 VSS.t519 4.03338
R14564 VSS.n14904 VSS.n352 4.03338
R14565 VSS.n14942 VSS.t499 4.03338
R14566 VSS.n15113 VSS.n15112 4.03338
R14567 VSS.n262 VSS.n261 4.03338
R14568 VSS.n15348 VSS.n15347 4.03338
R14569 VSS.n2889 VSS.n161 2.79786
R14570 VSS.n2578 VSS.n2543 4.03338
R14571 VSS.n69 VSS.n2587 2.79786
R14572 VSS.n3434 VSS.n2537 4.03338
R14573 VSS.n2648 VSS.n2617 4.03338
R14574 VSS.n2674 VSS.n2610 4.03338
R14575 VSS.n3402 VSS.n3401 4.03338
R14576 VSS.n3379 VSS.n3378 4.03338
R14577 VSS.n3350 VSS.n3349 4.03338
R14578 VSS.n3327 VSS.n3326 4.03338
R14579 VSS.n3298 VSS.n3297 4.03338
R14580 VSS.n3275 VSS.n3274 4.03338
R14581 VSS.n3246 VSS.n3245 4.03338
R14582 VSS.n3223 VSS.n3222 4.03338
R14583 VSS.n3194 VSS.n3193 4.03338
R14584 VSS.n3171 VSS.n3170 4.03338
R14585 VSS.n3142 VSS.n3141 4.03338
R14586 VSS.n3119 VSS.n3118 4.03338
R14587 VSS.n3090 VSS.n3089 4.03338
R14588 VSS.n3067 VSS.n3066 4.03338
R14589 VSS.n3038 VSS.n3037 4.03338
R14590 VSS.n3015 VSS.n3014 4.03338
R14591 VSS.n2986 VSS.n2985 4.03338
R14592 VSS.n2963 VSS.n2962 4.03338
R14593 VSS.n2934 VSS.n2933 4.03338
R14594 VSS.n2911 VSS.n2910 4.03338
R14595 VSS.n13678 VSS.t72 3.94944
R14596 VSS.t4330 VSS.t433 3.89484
R14597 VSS.n15229 VSS.t10 3.7713
R14598 VSS.t3339 VSS.n14320 3.77036
R14599 VSS.t107 VSS.t514 3.76521
R14600 VSS.n3758 VSS.t3356 3.72653
R14601 VSS.n2228 VSS.t3399 3.72653
R14602 VSS.n3752 VSS.t2896 3.71942
R14603 VSS.t2991 VSS.n4374 3.71942
R14604 VSS.n4276 VSS.t2976 3.71942
R14605 VSS.n4175 VSS.t2961 3.71942
R14606 VSS.n4074 VSS.t2946 3.71942
R14607 VSS.n3973 VSS.t2931 3.71942
R14608 VSS.n3872 VSS.t2916 3.71942
R14609 VSS.t2776 VSS.n5098 3.71942
R14610 VSS.t2761 VSS.n5056 3.71942
R14611 VSS.t2746 VSS.n5014 3.71942
R14612 VSS.t2731 VSS.n4972 3.71942
R14613 VSS.t2716 VSS.n4930 3.71942
R14614 VSS.t2701 VSS.n4888 3.71942
R14615 VSS.t2561 VSS.n6455 3.71942
R14616 VSS.n6357 VSS.t2546 3.71942
R14617 VSS.n6256 VSS.t2531 3.71942
R14618 VSS.n6155 VSS.t2516 3.71942
R14619 VSS.n6054 VSS.t2501 3.71942
R14620 VSS.n5953 VSS.t2486 3.71942
R14621 VSS.t2346 VSS.n7497 3.71942
R14622 VSS.n7399 VSS.t2331 3.71942
R14623 VSS.n7298 VSS.t2316 3.71942
R14624 VSS.n7197 VSS.t2301 3.71942
R14625 VSS.n7096 VSS.t2286 3.71942
R14626 VSS.n6995 VSS.t2271 3.71942
R14627 VSS.t2131 VSS.n2526 3.71942
R14628 VSS.t2116 VSS.n2484 3.71942
R14629 VSS.t2101 VSS.n2442 3.71942
R14630 VSS.t2086 VSS.n2400 3.71942
R14631 VSS.t2071 VSS.n2358 3.71942
R14632 VSS.t2056 VSS.n2316 3.71942
R14633 VSS.t1916 VSS.n8618 3.71942
R14634 VSS.t1901 VSS.n8576 3.71942
R14635 VSS.t1886 VSS.n8534 3.71942
R14636 VSS.t1871 VSS.n8492 3.71942
R14637 VSS.t1856 VSS.n8450 3.71942
R14638 VSS.t1841 VSS.n8408 3.71942
R14639 VSS.n2222 VSS.t1603 3.71942
R14640 VSS.t1698 VSS.n9975 3.71942
R14641 VSS.n9877 VSS.t1683 3.71942
R14642 VSS.n9776 VSS.t1668 3.71942
R14643 VSS.n9675 VSS.t1653 3.71942
R14644 VSS.n9574 VSS.t1638 3.71942
R14645 VSS.n9473 VSS.t1623 3.71942
R14646 VSS.t1483 VSS.n11017 3.71942
R14647 VSS.n10919 VSS.t1468 3.71942
R14648 VSS.n10818 VSS.t1453 3.71942
R14649 VSS.n10717 VSS.t1438 3.71942
R14650 VSS.n10616 VSS.t1423 3.71942
R14651 VSS.n10515 VSS.t1408 3.71942
R14652 VSS.t1268 VSS.n1904 3.71942
R14653 VSS.t1253 VSS.n1862 3.71942
R14654 VSS.t1238 VSS.n1820 3.71942
R14655 VSS.t1223 VSS.n1778 3.71942
R14656 VSS.t1208 VSS.n1736 3.71942
R14657 VSS.t1193 VSS.n1694 3.71942
R14658 VSS.t1053 VSS.n12138 3.71942
R14659 VSS.t1038 VSS.n12096 3.71942
R14660 VSS.t1023 VSS.n12054 3.71942
R14661 VSS.t1008 VSS.n12012 3.71942
R14662 VSS.t993 VSS.n11970 3.71942
R14663 VSS.t978 VSS.n11928 3.71942
R14664 VSS.t838 VSS.n13495 3.71942
R14665 VSS.n13397 VSS.t823 3.71942
R14666 VSS.n13296 VSS.t808 3.71942
R14667 VSS.n13195 VSS.t793 3.71942
R14668 VSS.n13094 VSS.t778 3.71942
R14669 VSS.n12993 VSS.t763 3.71942
R14670 VSS.t628 VSS.n14460 3.71942
R14671 VSS.n14362 VSS.t613 3.71942
R14672 VSS.n13737 VSS.t598 3.71942
R14673 VSS.n14103 VSS.t583 3.71942
R14674 VSS.n14002 VSS.t568 3.71942
R14675 VSS.t458 VSS.n452 3.71942
R14676 VSS.t3007 VSS.n3782 3.65215
R14677 VSS.n4462 VSS.t3102 3.65215
R14678 VSS.t3087 VSS.n4290 3.65215
R14679 VSS.t3072 VSS.n4189 3.65215
R14680 VSS.t3057 VSS.n4088 3.65215
R14681 VSS.t3042 VSS.n3987 3.65215
R14682 VSS.t3027 VSS.n3886 3.65215
R14683 VSS.t2884 VSS.n229 3.65215
R14684 VSS.t2869 VSS.n5063 3.65215
R14685 VSS.t2854 VSS.n5021 3.65215
R14686 VSS.t2839 VSS.n4979 3.65215
R14687 VSS.t2824 VSS.n4937 3.65215
R14688 VSS.t2809 VSS.n4895 3.65215
R14689 VSS.n6543 VSS.t2669 3.65215
R14690 VSS.t2654 VSS.n6371 3.65215
R14691 VSS.t2639 VSS.n6270 3.65215
R14692 VSS.t2624 VSS.n6169 3.65215
R14693 VSS.t2609 VSS.n6068 3.65215
R14694 VSS.t2594 VSS.n5967 3.65215
R14695 VSS.n7585 VSS.t2454 3.65215
R14696 VSS.t2439 VSS.n7413 3.65215
R14697 VSS.t2424 VSS.n7312 3.65215
R14698 VSS.t2409 VSS.n7211 3.65215
R14699 VSS.t2394 VSS.n7110 3.65215
R14700 VSS.t2379 VSS.n7009 3.65215
R14701 VSS.t2239 VSS.n230 3.65215
R14702 VSS.t2224 VSS.n2491 3.65215
R14703 VSS.t2209 VSS.n2449 3.65215
R14704 VSS.t2194 VSS.n2407 3.65215
R14705 VSS.t2179 VSS.n2365 3.65215
R14706 VSS.t2164 VSS.n2323 3.65215
R14707 VSS.t2024 VSS.n231 3.65215
R14708 VSS.t2009 VSS.n8583 3.65215
R14709 VSS.t1994 VSS.n8541 3.65215
R14710 VSS.t1979 VSS.n8499 3.65215
R14711 VSS.t1964 VSS.n8457 3.65215
R14712 VSS.t1949 VSS.n8415 3.65215
R14713 VSS.t1714 VSS.n2252 3.65215
R14714 VSS.n10063 VSS.t1809 3.65215
R14715 VSS.t1794 VSS.n9891 3.65215
R14716 VSS.t1779 VSS.n9790 3.65215
R14717 VSS.t1764 VSS.n9689 3.65215
R14718 VSS.t1749 VSS.n9588 3.65215
R14719 VSS.t1734 VSS.n9487 3.65215
R14720 VSS.n11105 VSS.t1591 3.65215
R14721 VSS.t1576 VSS.n10933 3.65215
R14722 VSS.t1561 VSS.n10832 3.65215
R14723 VSS.t1546 VSS.n10731 3.65215
R14724 VSS.t1531 VSS.n10630 3.65215
R14725 VSS.t1516 VSS.n10529 3.65215
R14726 VSS.t1376 VSS.n232 3.65215
R14727 VSS.t1361 VSS.n1869 3.65215
R14728 VSS.t1346 VSS.n1827 3.65215
R14729 VSS.t1331 VSS.n1785 3.65215
R14730 VSS.t1316 VSS.n1743 3.65215
R14731 VSS.t1301 VSS.n1701 3.65215
R14732 VSS.t1161 VSS.n233 3.65215
R14733 VSS.t1146 VSS.n12103 3.65215
R14734 VSS.t1131 VSS.n12061 3.65215
R14735 VSS.t1116 VSS.n12019 3.65215
R14736 VSS.t1101 VSS.n11977 3.65215
R14737 VSS.t1086 VSS.n11935 3.65215
R14738 VSS.n13583 VSS.t946 3.65215
R14739 VSS.t931 VSS.n13411 3.65215
R14740 VSS.t916 VSS.n13310 3.65215
R14741 VSS.t901 VSS.n13209 3.65215
R14742 VSS.t886 VSS.n13108 3.65215
R14743 VSS.t871 VSS.n13007 3.65215
R14744 VSS.n14548 VSS.t731 3.65215
R14745 VSS.t716 VSS.n14376 3.65215
R14746 VSS.t676 VSS.n14117 3.65215
R14747 VSS.t661 VSS.n14016 3.65215
R14748 VSS.t536 VSS.n234 3.65215
R14749 VSS.n3805 VSS.t2904 3.61789
R14750 VSS.n3796 VSS.t2901 3.61789
R14751 VSS.n4858 VSS.t2689 3.61789
R14752 VSS.n5872 VSS.t2686 3.61789
R14753 VSS.n5886 VSS.t2474 3.61789
R14754 VSS.n4838 VSS.t2471 3.61789
R14755 VSS.n6928 VSS.t2259 3.61789
R14756 VSS.n6919 VSS.t2256 3.61789
R14757 VSS.n2286 VSS.t2044 3.61789
R14758 VSS.n8354 VSS.t2041 3.61789
R14759 VSS.n8378 VSS.t1829 3.61789
R14760 VSS.n9392 VSS.t1826 3.61789
R14761 VSS.n9406 VSS.t1611 3.61789
R14762 VSS.n2266 VSS.t1608 3.61789
R14763 VSS.n10448 VSS.t1396 3.61789
R14764 VSS.n10439 VSS.t1393 3.61789
R14765 VSS.n1664 VSS.t1181 3.61789
R14766 VSS.n11874 VSS.t1178 3.61789
R14767 VSS.n11898 VSS.t966 3.61789
R14768 VSS.n12912 VSS.t963 3.61789
R14769 VSS.n12926 VSS.t751 3.61789
R14770 VSS.n1644 VSS.t748 3.61789
R14771 VSS.n13935 VSS.t556 3.61789
R14772 VSS.n13926 VSS.t553 3.61789
R14773 VSS.n15301 VSS.n15288 3.59502
R14774 VSS.n15306 VSS.n15287 3.59502
R14775 VSS.n15323 VSS.n15278 3.59502
R14776 VSS.n15328 VSS.n15277 3.59502
R14777 VSS.n508 VSS.n505 3.59502
R14778 VSS.n512 VSS.n55 3.59502
R14779 VSS.n1264 VSS.n460 3.59502
R14780 VSS.n1269 VSS.n459 3.59502
R14781 VSS.n1238 VSS.n1237 3.59502
R14782 VSS.n1234 VSS.n1233 3.59502
R14783 VSS.n1179 VSS.n534 3.59502
R14784 VSS.n1183 VSS.n532 3.59502
R14785 VSS.n1156 VSS.n543 3.59502
R14786 VSS.n1160 VSS.n541 3.59502
R14787 VSS.n1075 VSS.n1045 3.59502
R14788 VSS.n1069 VSS.n1065 3.59502
R14789 VSS.n1097 VSS.n1096 3.59502
R14790 VSS.n1093 VSS.n1092 3.59502
R14791 VSS.n1019 VSS.n566 3.59502
R14792 VSS.n1023 VSS.n564 3.59502
R14793 VSS.n960 VSS.n931 3.59502
R14794 VSS.n954 VSS.n950 3.59502
R14795 VSS.n982 VSS.n981 3.59502
R14796 VSS.n978 VSS.n977 3.59502
R14797 VSS.n848 VSS.n818 3.59502
R14798 VSS.n842 VSS.n838 3.59502
R14799 VSS.n870 VSS.n869 3.59502
R14800 VSS.n866 VSS.n865 3.59502
R14801 VSS.n769 VSS.n607 3.59502
R14802 VSS.n773 VSS.n605 3.59502
R14803 VSS.n740 VSS.n618 3.59502
R14804 VSS.n744 VSS.n616 3.59502
R14805 VSS.n717 VSS.n627 3.59502
R14806 VSS.n721 VSS.n625 3.59502
R14807 VSS.n651 VSS.n648 3.59502
R14808 VSS.n53 VSS.n84 3.59502
R14809 VSS.n15248 VSS.n15247 3.59502
R14810 VSS.n15244 VSS.n15243 3.59502
R14811 VSS.n3759 VSS.t3433 3.59502
R14812 VSS.n4441 VSS.n4398 3.59502
R14813 VSS.n4346 VSS.n3464 3.59502
R14814 VSS.n4324 VSS.n4323 3.59502
R14815 VSS.n4245 VSS.n3514 3.59502
R14816 VSS.n4223 VSS.n4222 3.59502
R14817 VSS.n4144 VSS.n3564 3.59502
R14818 VSS.n4122 VSS.n4121 3.59502
R14819 VSS.n4043 VSS.n3614 3.59502
R14820 VSS.n4021 VSS.n4020 3.59502
R14821 VSS.n3942 VSS.n3664 3.59502
R14822 VSS.n3920 VSS.n3919 3.59502
R14823 VSS.n3841 VSS.n3714 3.59502
R14824 VSS.n3819 VSS.n3818 3.59502
R14825 VSS.n5173 VSS.n5130 3.59502
R14826 VSS.n5237 VSS.n5236 3.59502
R14827 VSS.n5265 VSS.n5078 3.59502
R14828 VSS.n5343 VSS.n5342 3.59502
R14829 VSS.n5371 VSS.n5036 3.59502
R14830 VSS.n5449 VSS.n5448 3.59502
R14831 VSS.n5477 VSS.n4994 3.59502
R14832 VSS.n5555 VSS.n5554 3.59502
R14833 VSS.n5583 VSS.n4952 3.59502
R14834 VSS.n5661 VSS.n5660 3.59502
R14835 VSS.n5689 VSS.n4910 3.59502
R14836 VSS.n5767 VSS.n5766 3.59502
R14837 VSS.n5796 VSS.n4850 3.59502
R14838 VSS.n6522 VSS.n6479 3.59502
R14839 VSS.n6427 VSS.n4487 3.59502
R14840 VSS.n6405 VSS.n6404 3.59502
R14841 VSS.n6326 VSS.n4537 3.59502
R14842 VSS.n6304 VSS.n6303 3.59502
R14843 VSS.n6225 VSS.n4587 3.59502
R14844 VSS.n6203 VSS.n6202 3.59502
R14845 VSS.n6124 VSS.n4637 3.59502
R14846 VSS.n6102 VSS.n6101 3.59502
R14847 VSS.n6023 VSS.n4687 3.59502
R14848 VSS.n6001 VSS.n6000 3.59502
R14849 VSS.n5922 VSS.n4737 3.59502
R14850 VSS.n5900 VSS.n5899 3.59502
R14851 VSS.n7564 VSS.n7521 3.59502
R14852 VSS.n7469 VSS.n6568 3.59502
R14853 VSS.n7447 VSS.n7446 3.59502
R14854 VSS.n7368 VSS.n6618 3.59502
R14855 VSS.n7346 VSS.n7345 3.59502
R14856 VSS.n7267 VSS.n6668 3.59502
R14857 VSS.n7245 VSS.n7244 3.59502
R14858 VSS.n7166 VSS.n6718 3.59502
R14859 VSS.n7144 VSS.n7143 3.59502
R14860 VSS.n7065 VSS.n6768 3.59502
R14861 VSS.n7043 VSS.n7042 3.59502
R14862 VSS.n6964 VSS.n6818 3.59502
R14863 VSS.n6942 VSS.n6941 3.59502
R14864 VSS.n7650 VSS.n7607 3.59502
R14865 VSS.n7719 VSS.n7718 3.59502
R14866 VSS.n7747 VSS.n2506 3.59502
R14867 VSS.n7825 VSS.n7824 3.59502
R14868 VSS.n7853 VSS.n2464 3.59502
R14869 VSS.n7931 VSS.n7930 3.59502
R14870 VSS.n7959 VSS.n2422 3.59502
R14871 VSS.n8037 VSS.n8036 3.59502
R14872 VSS.n8065 VSS.n2380 3.59502
R14873 VSS.n8143 VSS.n8142 3.59502
R14874 VSS.n8171 VSS.n2338 3.59502
R14875 VSS.n8249 VSS.n8248 3.59502
R14876 VSS.n8278 VSS.n2278 3.59502
R14877 VSS.n8693 VSS.n8650 3.59502
R14878 VSS.n8757 VSS.n8756 3.59502
R14879 VSS.n8785 VSS.n8598 3.59502
R14880 VSS.n8863 VSS.n8862 3.59502
R14881 VSS.n8891 VSS.n8556 3.59502
R14882 VSS.n8969 VSS.n8968 3.59502
R14883 VSS.n8997 VSS.n8514 3.59502
R14884 VSS.n9075 VSS.n9074 3.59502
R14885 VSS.n9103 VSS.n8472 3.59502
R14886 VSS.n9181 VSS.n9180 3.59502
R14887 VSS.n9209 VSS.n8430 3.59502
R14888 VSS.n9287 VSS.n9286 3.59502
R14889 VSS.n9316 VSS.n8370 3.59502
R14890 VSS.n2229 VSS.t3401 3.59502
R14891 VSS.n10042 VSS.n9999 3.59502
R14892 VSS.n9947 VSS.n1934 3.59502
R14893 VSS.n9925 VSS.n9924 3.59502
R14894 VSS.n9846 VSS.n1984 3.59502
R14895 VSS.n9824 VSS.n9823 3.59502
R14896 VSS.n9745 VSS.n2034 3.59502
R14897 VSS.n9723 VSS.n9722 3.59502
R14898 VSS.n9644 VSS.n2084 3.59502
R14899 VSS.n9622 VSS.n9621 3.59502
R14900 VSS.n9543 VSS.n2134 3.59502
R14901 VSS.n9521 VSS.n9520 3.59502
R14902 VSS.n9442 VSS.n2184 3.59502
R14903 VSS.n9420 VSS.n9419 3.59502
R14904 VSS.n11084 VSS.n11041 3.59502
R14905 VSS.n10989 VSS.n10088 3.59502
R14906 VSS.n10967 VSS.n10966 3.59502
R14907 VSS.n10888 VSS.n10138 3.59502
R14908 VSS.n10866 VSS.n10865 3.59502
R14909 VSS.n10787 VSS.n10188 3.59502
R14910 VSS.n10765 VSS.n10764 3.59502
R14911 VSS.n10686 VSS.n10238 3.59502
R14912 VSS.n10664 VSS.n10663 3.59502
R14913 VSS.n10585 VSS.n10288 3.59502
R14914 VSS.n10563 VSS.n10562 3.59502
R14915 VSS.n10484 VSS.n10338 3.59502
R14916 VSS.n10462 VSS.n10461 3.59502
R14917 VSS.n11170 VSS.n11127 3.59502
R14918 VSS.n11239 VSS.n11238 3.59502
R14919 VSS.n11267 VSS.n1884 3.59502
R14920 VSS.n11345 VSS.n11344 3.59502
R14921 VSS.n11373 VSS.n1842 3.59502
R14922 VSS.n11451 VSS.n11450 3.59502
R14923 VSS.n11479 VSS.n1800 3.59502
R14924 VSS.n11557 VSS.n11556 3.59502
R14925 VSS.n11585 VSS.n1758 3.59502
R14926 VSS.n11663 VSS.n11662 3.59502
R14927 VSS.n11691 VSS.n1716 3.59502
R14928 VSS.n11769 VSS.n11768 3.59502
R14929 VSS.n11798 VSS.n1656 3.59502
R14930 VSS.n12213 VSS.n12170 3.59502
R14931 VSS.n12277 VSS.n12276 3.59502
R14932 VSS.n12305 VSS.n12118 3.59502
R14933 VSS.n12383 VSS.n12382 3.59502
R14934 VSS.n12411 VSS.n12076 3.59502
R14935 VSS.n12489 VSS.n12488 3.59502
R14936 VSS.n12517 VSS.n12034 3.59502
R14937 VSS.n12595 VSS.n12594 3.59502
R14938 VSS.n12623 VSS.n11992 3.59502
R14939 VSS.n12701 VSS.n12700 3.59502
R14940 VSS.n12729 VSS.n11950 3.59502
R14941 VSS.n12807 VSS.n12806 3.59502
R14942 VSS.n12836 VSS.n11890 3.59502
R14943 VSS.n13562 VSS.n13519 3.59502
R14944 VSS.n13467 VSS.n1293 3.59502
R14945 VSS.n13445 VSS.n13444 3.59502
R14946 VSS.n13366 VSS.n1343 3.59502
R14947 VSS.n13344 VSS.n13343 3.59502
R14948 VSS.n13265 VSS.n1393 3.59502
R14949 VSS.n13243 VSS.n13242 3.59502
R14950 VSS.n13164 VSS.n1443 3.59502
R14951 VSS.n13142 VSS.n13141 3.59502
R14952 VSS.n13063 VSS.n1493 3.59502
R14953 VSS.n13041 VSS.n13040 3.59502
R14954 VSS.n12962 VSS.n1543 3.59502
R14955 VSS.n12940 VSS.n12939 3.59502
R14956 VSS.n14527 VSS.n14484 3.59502
R14957 VSS.n14432 VSS.n13608 3.59502
R14958 VSS.n14410 VSS.n14409 3.59502
R14959 VSS.n14324 VSS.n13663 3.59502
R14960 VSS.n14328 VSS.n13661 3.59502
R14961 VSS.n14302 VSS.n13704 3.59502
R14962 VSS.n14306 VSS.n13702 3.59502
R14963 VSS.n14175 VSS.n14158 3.59502
R14964 VSS.n14170 VSS.t109 3.59502
R14965 VSS.n14214 VSS.n13741 3.59502
R14966 VSS.n14072 VSS.n13775 3.59502
R14967 VSS.n14050 VSS.n14049 3.59502
R14968 VSS.n13971 VSS.n13825 3.59502
R14969 VSS.n13949 VSS.n13948 3.59502
R14970 VSS.n15236 VSS.n15234 3.59502
R14971 VSS.n15230 VSS.n216 3.59502
R14972 VSS.n14610 VSS.n14567 3.59502
R14973 VSS.n14679 VSS.n14678 3.59502
R14974 VSS.n14707 VSS.n432 3.59502
R14975 VSS.n14726 VSS.n414 3.59502
R14976 VSS.n219 VSS.n416 3.59502
R14977 VSS.n14744 VSS.n396 3.59502
R14978 VSS.n221 VSS.n398 3.59502
R14979 VSS.n14943 VSS.n337 3.59502
R14980 VSS.n15116 VSS.n15087 3.59502
R14981 VSS.n265 VSS.n250 3.59502
R14982 VSS.n269 VSS.n248 3.59502
R14983 VSS.n15351 VSS.n237 3.59502
R14984 VSS.n15355 VSS.n235 3.59502
R14985 VSS.n2892 VSS.n2891 3.59502
R14986 VSS.n2896 VSS.n85 3.59502
R14987 VSS.n2575 VSS.n2574 3.59502
R14988 VSS.n2571 VSS.n2570 3.59502
R14989 VSS.n2588 VSS.n2585 3.59502
R14990 VSS.n2592 VSS.n54 3.59502
R14991 VSS.n3435 VSS.n2534 3.59502
R14992 VSS.n3440 VSS.n2533 3.59502
R14993 VSS.n2649 VSS.n2619 3.59502
R14994 VSS.n2643 VSS.n2639 3.59502
R14995 VSS.n2671 VSS.n2670 3.59502
R14996 VSS.n2667 VSS.n2666 3.59502
R14997 VSS.n3405 VSS.n2683 3.59502
R14998 VSS.n3409 VSS.n2681 3.59502
R14999 VSS.n3382 VSS.n2692 3.59502
R15000 VSS.n3386 VSS.n2690 3.59502
R15001 VSS.n3353 VSS.n2703 3.59502
R15002 VSS.n3357 VSS.n2701 3.59502
R15003 VSS.n3330 VSS.n2712 3.59502
R15004 VSS.n3334 VSS.n2710 3.59502
R15005 VSS.n3301 VSS.n2723 3.59502
R15006 VSS.n3305 VSS.n2721 3.59502
R15007 VSS.n3278 VSS.n2732 3.59502
R15008 VSS.n3282 VSS.n2730 3.59502
R15009 VSS.n3249 VSS.n2743 3.59502
R15010 VSS.n3253 VSS.n2741 3.59502
R15011 VSS.n3226 VSS.n2752 3.59502
R15012 VSS.n3230 VSS.n2750 3.59502
R15013 VSS.n3197 VSS.n2763 3.59502
R15014 VSS.n3201 VSS.n2761 3.59502
R15015 VSS.n3174 VSS.n2772 3.59502
R15016 VSS.n3178 VSS.n2770 3.59502
R15017 VSS.n3145 VSS.n2783 3.59502
R15018 VSS.n3149 VSS.n2781 3.59502
R15019 VSS.n3122 VSS.n2792 3.59502
R15020 VSS.n3126 VSS.n2790 3.59502
R15021 VSS.n3093 VSS.n2803 3.59502
R15022 VSS.n3097 VSS.n2801 3.59502
R15023 VSS.n3070 VSS.n2812 3.59502
R15024 VSS.n3074 VSS.n2810 3.59502
R15025 VSS.n3041 VSS.n2823 3.59502
R15026 VSS.n3045 VSS.n2821 3.59502
R15027 VSS.n3018 VSS.n2832 3.59502
R15028 VSS.n3022 VSS.n2830 3.59502
R15029 VSS.n2989 VSS.n2843 3.59502
R15030 VSS.n2993 VSS.n2841 3.59502
R15031 VSS.n2966 VSS.n2852 3.59502
R15032 VSS.n2970 VSS.n2850 3.59502
R15033 VSS.n2937 VSS.n2863 3.59502
R15034 VSS.n2941 VSS.n2861 3.59502
R15035 VSS.n2914 VSS.n2872 3.59502
R15036 VSS.n2918 VSS.n2870 3.59502
R15037 VSS.n14934 VSS.t3358 3.55118
R15038 VSS.n488 VSS.n472 3.50735
R15039 VSS.n887 VSS.n588 3.50735
R15040 VSS.n793 VSS.n597 3.50735
R15041 VSS.n698 VSS.n634 3.50735
R15042 VSS.n14255 VSS.n13724 3.50735
R15043 VSS.n15235 VSS.t3415 3.50735
R15044 VSS.t234 VSS.n362 3.50735
R15045 VSS.n15056 VSS.n313 3.50735
R15046 VSS.n15086 VSS.t257 3.50735
R15047 VSS.t421 VSS.t82 3.47876
R15048 VSS.n3786 VSS.n3785 3.44377
R15049 VSS.n3786 VSS.n3742 3.44377
R15050 VSS.n3790 VSS.n3742 3.44377
R15051 VSS.t3523 VSS.n4406 3.44377
R15052 VSS.t3488 VSS.n3446 3.44377
R15053 VSS.n4369 VSS.t3527 3.44377
R15054 VSS.n4330 VSS.n4329 3.44377
R15055 VSS.n4334 VSS.n3468 3.44377
R15056 VSS.n4335 VSS.n4334 3.44377
R15057 VSS.n4316 VSS.t3493 3.44377
R15058 VSS.n4269 VSS.t3532 3.44377
R15059 VSS.n4229 VSS.n4228 3.44377
R15060 VSS.n4233 VSS.n3518 3.44377
R15061 VSS.n4234 VSS.n4233 3.44377
R15062 VSS.n4215 VSS.t3498 3.44377
R15063 VSS.n4168 VSS.t3537 3.44377
R15064 VSS.n4128 VSS.n4127 3.44377
R15065 VSS.n4132 VSS.n3568 3.44377
R15066 VSS.n4133 VSS.n4132 3.44377
R15067 VSS.n4114 VSS.t3503 3.44377
R15068 VSS.n4067 VSS.t3542 3.44377
R15069 VSS.n4027 VSS.n4026 3.44377
R15070 VSS.n4031 VSS.n3618 3.44377
R15071 VSS.n4032 VSS.n4031 3.44377
R15072 VSS.n4013 VSS.t3508 3.44377
R15073 VSS.n3966 VSS.t3547 3.44377
R15074 VSS.n3926 VSS.n3925 3.44377
R15075 VSS.n3930 VSS.n3668 3.44377
R15076 VSS.n3931 VSS.n3930 3.44377
R15077 VSS.n3912 VSS.t3513 3.44377
R15078 VSS.n3865 VSS.t3552 3.44377
R15079 VSS.n3825 VSS.n3824 3.44377
R15080 VSS.n3829 VSS.n3718 3.44377
R15081 VSS.n3830 VSS.n3829 3.44377
R15082 VSS.n3806 VSS.n3736 3.44377
R15083 VSS.n3810 VSS.n3736 3.44377
R15084 VSS.n3797 VSS.n3738 3.44377
R15085 VSS.n3801 VSS.n3738 3.44377
R15086 VSS.n5837 VSS.n5814 3.44377
R15087 VSS.n5841 VSS.n5814 3.44377
R15088 VSS.n5842 VSS.n5841 3.44377
R15089 VSS.n5843 VSS.n5842 3.44377
R15090 VSS.n5860 VSS.n5801 3.44377
R15091 VSS.n5864 VSS.n5801 3.44377
R15092 VSS.n5865 VSS.n5864 3.44377
R15093 VSS.n5866 VSS.n5865 3.44377
R15094 VSS.t3593 VSS.n5138 3.44377
R15095 VSS.t3558 VSS.n5114 3.44377
R15096 VSS.t3597 VSS.n5095 3.44377
R15097 VSS.n5253 VSS.n5080 3.44377
R15098 VSS.n5249 VSS.n5247 3.44377
R15099 VSS.n5247 VSS.n5246 3.44377
R15100 VSS.t3563 VSS.n5073 3.44377
R15101 VSS.t3602 VSS.n5053 3.44377
R15102 VSS.n5359 VSS.n5038 3.44377
R15103 VSS.n5355 VSS.n5353 3.44377
R15104 VSS.n5353 VSS.n5352 3.44377
R15105 VSS.t3568 VSS.n5031 3.44377
R15106 VSS.t3607 VSS.n5011 3.44377
R15107 VSS.n5465 VSS.n4996 3.44377
R15108 VSS.n5461 VSS.n5459 3.44377
R15109 VSS.n5459 VSS.n5458 3.44377
R15110 VSS.t3573 VSS.n4989 3.44377
R15111 VSS.t3612 VSS.n4969 3.44377
R15112 VSS.n5571 VSS.n4954 3.44377
R15113 VSS.n5567 VSS.n5565 3.44377
R15114 VSS.n5565 VSS.n5564 3.44377
R15115 VSS.t3578 VSS.n4947 3.44377
R15116 VSS.t3617 VSS.n4927 3.44377
R15117 VSS.n5677 VSS.n4912 3.44377
R15118 VSS.n5673 VSS.n5671 3.44377
R15119 VSS.n5671 VSS.n5670 3.44377
R15120 VSS.t3583 VSS.n4905 3.44377
R15121 VSS.t3622 VSS.n4885 3.44377
R15122 VSS.n5784 VSS.n4870 3.44377
R15123 VSS.n5779 VSS.n5777 3.44377
R15124 VSS.n5777 VSS.n5776 3.44377
R15125 VSS.n4859 VSS.n4856 3.44377
R15126 VSS.n4863 VSS.n4856 3.44377
R15127 VSS.n5876 VSS.n4847 3.44377
R15128 VSS.n5877 VSS.n5876 3.44377
R15129 VSS.n4805 VSS.n4804 3.44377
R15130 VSS.n4806 VSS.n4805 3.44377
R15131 VSS.n4806 VSS.n4779 3.44377
R15132 VSS.n4810 VSS.n4779 3.44377
R15133 VSS.n4827 VSS.n4826 3.44377
R15134 VSS.n4828 VSS.n4827 3.44377
R15135 VSS.n4828 VSS.n4765 3.44377
R15136 VSS.n4832 VSS.n4765 3.44377
R15137 VSS.t3663 VSS.n6487 3.44377
R15138 VSS.t3628 VSS.n4469 3.44377
R15139 VSS.n6450 VSS.t3667 3.44377
R15140 VSS.n6411 VSS.n6410 3.44377
R15141 VSS.n6415 VSS.n4491 3.44377
R15142 VSS.n6416 VSS.n6415 3.44377
R15143 VSS.n6397 VSS.t3633 3.44377
R15144 VSS.n6350 VSS.t3672 3.44377
R15145 VSS.n6310 VSS.n6309 3.44377
R15146 VSS.n6314 VSS.n4541 3.44377
R15147 VSS.n6315 VSS.n6314 3.44377
R15148 VSS.n6296 VSS.t3638 3.44377
R15149 VSS.n6249 VSS.t3677 3.44377
R15150 VSS.n6209 VSS.n6208 3.44377
R15151 VSS.n6213 VSS.n4591 3.44377
R15152 VSS.n6214 VSS.n6213 3.44377
R15153 VSS.n6195 VSS.t3643 3.44377
R15154 VSS.n6148 VSS.t3682 3.44377
R15155 VSS.n6108 VSS.n6107 3.44377
R15156 VSS.n6112 VSS.n4641 3.44377
R15157 VSS.n6113 VSS.n6112 3.44377
R15158 VSS.n6094 VSS.t3648 3.44377
R15159 VSS.n6047 VSS.t3687 3.44377
R15160 VSS.n6007 VSS.n6006 3.44377
R15161 VSS.n6011 VSS.n4691 3.44377
R15162 VSS.n6012 VSS.n6011 3.44377
R15163 VSS.n5993 VSS.t3653 3.44377
R15164 VSS.n5946 VSS.t3692 3.44377
R15165 VSS.n5906 VSS.n5905 3.44377
R15166 VSS.n5910 VSS.n4741 3.44377
R15167 VSS.n5911 VSS.n5910 3.44377
R15168 VSS.n5887 VSS.n4759 3.44377
R15169 VSS.n5891 VSS.n4759 3.44377
R15170 VSS.n4839 VSS.n4761 3.44377
R15171 VSS.n4843 VSS.n4761 3.44377
R15172 VSS.n6886 VSS.n6885 3.44377
R15173 VSS.n6887 VSS.n6886 3.44377
R15174 VSS.n6887 VSS.n6860 3.44377
R15175 VSS.n6891 VSS.n6860 3.44377
R15176 VSS.n6908 VSS.n6907 3.44377
R15177 VSS.n6909 VSS.n6908 3.44377
R15178 VSS.n6909 VSS.n6846 3.44377
R15179 VSS.n6913 VSS.n6846 3.44377
R15180 VSS.t3733 VSS.n7529 3.44377
R15181 VSS.t3698 VSS.n6550 3.44377
R15182 VSS.n7492 VSS.t3737 3.44377
R15183 VSS.n7453 VSS.n7452 3.44377
R15184 VSS.n7457 VSS.n6572 3.44377
R15185 VSS.n7458 VSS.n7457 3.44377
R15186 VSS.n7439 VSS.t3703 3.44377
R15187 VSS.n7392 VSS.t3742 3.44377
R15188 VSS.n7352 VSS.n7351 3.44377
R15189 VSS.n7356 VSS.n6622 3.44377
R15190 VSS.n7357 VSS.n7356 3.44377
R15191 VSS.n7338 VSS.t3708 3.44377
R15192 VSS.n7291 VSS.t3747 3.44377
R15193 VSS.n7251 VSS.n7250 3.44377
R15194 VSS.n7255 VSS.n6672 3.44377
R15195 VSS.n7256 VSS.n7255 3.44377
R15196 VSS.n7237 VSS.t3713 3.44377
R15197 VSS.n7190 VSS.t3752 3.44377
R15198 VSS.n7150 VSS.n7149 3.44377
R15199 VSS.n7154 VSS.n6722 3.44377
R15200 VSS.n7155 VSS.n7154 3.44377
R15201 VSS.n7136 VSS.t3718 3.44377
R15202 VSS.n7089 VSS.t3757 3.44377
R15203 VSS.n7049 VSS.n7048 3.44377
R15204 VSS.n7053 VSS.n6772 3.44377
R15205 VSS.n7054 VSS.n7053 3.44377
R15206 VSS.n7035 VSS.t3723 3.44377
R15207 VSS.n6988 VSS.t3762 3.44377
R15208 VSS.n6948 VSS.n6947 3.44377
R15209 VSS.n6952 VSS.n6822 3.44377
R15210 VSS.n6953 VSS.n6952 3.44377
R15211 VSS.n6929 VSS.n6840 3.44377
R15212 VSS.n6933 VSS.n6840 3.44377
R15213 VSS.n6920 VSS.n6842 3.44377
R15214 VSS.n6924 VSS.n6842 3.44377
R15215 VSS.n8319 VSS.n8296 3.44377
R15216 VSS.n8323 VSS.n8296 3.44377
R15217 VSS.n8324 VSS.n8323 3.44377
R15218 VSS.n8325 VSS.n8324 3.44377
R15219 VSS.n8342 VSS.n8283 3.44377
R15220 VSS.n8346 VSS.n8283 3.44377
R15221 VSS.n8347 VSS.n8346 3.44377
R15222 VSS.n8348 VSS.n8347 3.44377
R15223 VSS.t3803 VSS.n7615 3.44377
R15224 VSS.t3768 VSS.n7591 3.44377
R15225 VSS.t3807 VSS.n2523 3.44377
R15226 VSS.n7735 VSS.n2508 3.44377
R15227 VSS.n7731 VSS.n7729 3.44377
R15228 VSS.n7729 VSS.n7728 3.44377
R15229 VSS.t3773 VSS.n2501 3.44377
R15230 VSS.t3812 VSS.n2481 3.44377
R15231 VSS.n7841 VSS.n2466 3.44377
R15232 VSS.n7837 VSS.n7835 3.44377
R15233 VSS.n7835 VSS.n7834 3.44377
R15234 VSS.t3778 VSS.n2459 3.44377
R15235 VSS.t3817 VSS.n2439 3.44377
R15236 VSS.n7947 VSS.n2424 3.44377
R15237 VSS.n7943 VSS.n7941 3.44377
R15238 VSS.n7941 VSS.n7940 3.44377
R15239 VSS.t3783 VSS.n2417 3.44377
R15240 VSS.t3822 VSS.n2397 3.44377
R15241 VSS.n8053 VSS.n2382 3.44377
R15242 VSS.n8049 VSS.n8047 3.44377
R15243 VSS.n8047 VSS.n8046 3.44377
R15244 VSS.t3788 VSS.n2375 3.44377
R15245 VSS.t3827 VSS.n2355 3.44377
R15246 VSS.n8159 VSS.n2340 3.44377
R15247 VSS.n8155 VSS.n8153 3.44377
R15248 VSS.n8153 VSS.n8152 3.44377
R15249 VSS.t3793 VSS.n2333 3.44377
R15250 VSS.t3832 VSS.n2313 3.44377
R15251 VSS.n8266 VSS.n2298 3.44377
R15252 VSS.n8261 VSS.n8259 3.44377
R15253 VSS.n8259 VSS.n8258 3.44377
R15254 VSS.n2287 VSS.n2284 3.44377
R15255 VSS.n2291 VSS.n2284 3.44377
R15256 VSS.n8358 VSS.n2275 3.44377
R15257 VSS.n8359 VSS.n8358 3.44377
R15258 VSS.n9357 VSS.n9334 3.44377
R15259 VSS.n9361 VSS.n9334 3.44377
R15260 VSS.n9362 VSS.n9361 3.44377
R15261 VSS.n9363 VSS.n9362 3.44377
R15262 VSS.n9380 VSS.n9321 3.44377
R15263 VSS.n9384 VSS.n9321 3.44377
R15264 VSS.n9385 VSS.n9384 3.44377
R15265 VSS.n9386 VSS.n9385 3.44377
R15266 VSS.t3873 VSS.n8658 3.44377
R15267 VSS.t3838 VSS.n8634 3.44377
R15268 VSS.t3877 VSS.n8615 3.44377
R15269 VSS.n8773 VSS.n8600 3.44377
R15270 VSS.n8769 VSS.n8767 3.44377
R15271 VSS.n8767 VSS.n8766 3.44377
R15272 VSS.t3843 VSS.n8593 3.44377
R15273 VSS.t3882 VSS.n8573 3.44377
R15274 VSS.n8879 VSS.n8558 3.44377
R15275 VSS.n8875 VSS.n8873 3.44377
R15276 VSS.n8873 VSS.n8872 3.44377
R15277 VSS.t3848 VSS.n8551 3.44377
R15278 VSS.t3887 VSS.n8531 3.44377
R15279 VSS.n8985 VSS.n8516 3.44377
R15280 VSS.n8981 VSS.n8979 3.44377
R15281 VSS.n8979 VSS.n8978 3.44377
R15282 VSS.t3853 VSS.n8509 3.44377
R15283 VSS.t3892 VSS.n8489 3.44377
R15284 VSS.n9091 VSS.n8474 3.44377
R15285 VSS.n9087 VSS.n9085 3.44377
R15286 VSS.n9085 VSS.n9084 3.44377
R15287 VSS.t3858 VSS.n8467 3.44377
R15288 VSS.t3897 VSS.n8447 3.44377
R15289 VSS.n9197 VSS.n8432 3.44377
R15290 VSS.n9193 VSS.n9191 3.44377
R15291 VSS.n9191 VSS.n9190 3.44377
R15292 VSS.t3863 VSS.n8425 3.44377
R15293 VSS.t3902 VSS.n8405 3.44377
R15294 VSS.n9304 VSS.n8390 3.44377
R15295 VSS.n9299 VSS.n9297 3.44377
R15296 VSS.n9297 VSS.n9296 3.44377
R15297 VSS.n8379 VSS.n8376 3.44377
R15298 VSS.n8383 VSS.n8376 3.44377
R15299 VSS.n9396 VSS.n8367 3.44377
R15300 VSS.n9397 VSS.n9396 3.44377
R15301 VSS.n2256 VSS.n2255 3.44377
R15302 VSS.n2256 VSS.n2212 3.44377
R15303 VSS.n2260 VSS.n2212 3.44377
R15304 VSS.t3943 VSS.n10007 3.44377
R15305 VSS.t3908 VSS.n1916 3.44377
R15306 VSS.n9970 VSS.t3947 3.44377
R15307 VSS.n9931 VSS.n9930 3.44377
R15308 VSS.n9935 VSS.n1938 3.44377
R15309 VSS.n9936 VSS.n9935 3.44377
R15310 VSS.n9917 VSS.t3913 3.44377
R15311 VSS.n9870 VSS.t3952 3.44377
R15312 VSS.n9830 VSS.n9829 3.44377
R15313 VSS.n9834 VSS.n1988 3.44377
R15314 VSS.n9835 VSS.n9834 3.44377
R15315 VSS.n9816 VSS.t3918 3.44377
R15316 VSS.n9769 VSS.t3957 3.44377
R15317 VSS.n9729 VSS.n9728 3.44377
R15318 VSS.n9733 VSS.n2038 3.44377
R15319 VSS.n9734 VSS.n9733 3.44377
R15320 VSS.n9715 VSS.t3923 3.44377
R15321 VSS.n9668 VSS.t3962 3.44377
R15322 VSS.n9628 VSS.n9627 3.44377
R15323 VSS.n9632 VSS.n2088 3.44377
R15324 VSS.n9633 VSS.n9632 3.44377
R15325 VSS.n9614 VSS.t3928 3.44377
R15326 VSS.n9567 VSS.t3967 3.44377
R15327 VSS.n9527 VSS.n9526 3.44377
R15328 VSS.n9531 VSS.n2138 3.44377
R15329 VSS.n9532 VSS.n9531 3.44377
R15330 VSS.n9513 VSS.t3933 3.44377
R15331 VSS.n9466 VSS.t3972 3.44377
R15332 VSS.n9426 VSS.n9425 3.44377
R15333 VSS.n9430 VSS.n2188 3.44377
R15334 VSS.n9431 VSS.n9430 3.44377
R15335 VSS.n9407 VSS.n2206 3.44377
R15336 VSS.n9411 VSS.n2206 3.44377
R15337 VSS.n2267 VSS.n2208 3.44377
R15338 VSS.n2271 VSS.n2208 3.44377
R15339 VSS.n10406 VSS.n10405 3.44377
R15340 VSS.n10407 VSS.n10406 3.44377
R15341 VSS.n10407 VSS.n10380 3.44377
R15342 VSS.n10411 VSS.n10380 3.44377
R15343 VSS.n10428 VSS.n10427 3.44377
R15344 VSS.n10429 VSS.n10428 3.44377
R15345 VSS.n10429 VSS.n10366 3.44377
R15346 VSS.n10433 VSS.n10366 3.44377
R15347 VSS.t4013 VSS.n11049 3.44377
R15348 VSS.t3978 VSS.n10070 3.44377
R15349 VSS.n11012 VSS.t4017 3.44377
R15350 VSS.n10973 VSS.n10972 3.44377
R15351 VSS.n10977 VSS.n10092 3.44377
R15352 VSS.n10978 VSS.n10977 3.44377
R15353 VSS.n10959 VSS.t3983 3.44377
R15354 VSS.n10912 VSS.t4022 3.44377
R15355 VSS.n10872 VSS.n10871 3.44377
R15356 VSS.n10876 VSS.n10142 3.44377
R15357 VSS.n10877 VSS.n10876 3.44377
R15358 VSS.n10858 VSS.t3988 3.44377
R15359 VSS.n10811 VSS.t4027 3.44377
R15360 VSS.n10771 VSS.n10770 3.44377
R15361 VSS.n10775 VSS.n10192 3.44377
R15362 VSS.n10776 VSS.n10775 3.44377
R15363 VSS.n10757 VSS.t3993 3.44377
R15364 VSS.n10710 VSS.t4032 3.44377
R15365 VSS.n10670 VSS.n10669 3.44377
R15366 VSS.n10674 VSS.n10242 3.44377
R15367 VSS.n10675 VSS.n10674 3.44377
R15368 VSS.n10656 VSS.t3998 3.44377
R15369 VSS.n10609 VSS.t4037 3.44377
R15370 VSS.n10569 VSS.n10568 3.44377
R15371 VSS.n10573 VSS.n10292 3.44377
R15372 VSS.n10574 VSS.n10573 3.44377
R15373 VSS.n10555 VSS.t4003 3.44377
R15374 VSS.n10508 VSS.t4042 3.44377
R15375 VSS.n10468 VSS.n10467 3.44377
R15376 VSS.n10472 VSS.n10342 3.44377
R15377 VSS.n10473 VSS.n10472 3.44377
R15378 VSS.n10449 VSS.n10360 3.44377
R15379 VSS.n10453 VSS.n10360 3.44377
R15380 VSS.n10440 VSS.n10362 3.44377
R15381 VSS.n10444 VSS.n10362 3.44377
R15382 VSS.n11839 VSS.n11816 3.44377
R15383 VSS.n11843 VSS.n11816 3.44377
R15384 VSS.n11844 VSS.n11843 3.44377
R15385 VSS.n11845 VSS.n11844 3.44377
R15386 VSS.n11862 VSS.n11803 3.44377
R15387 VSS.n11866 VSS.n11803 3.44377
R15388 VSS.n11867 VSS.n11866 3.44377
R15389 VSS.n11868 VSS.n11867 3.44377
R15390 VSS.t4083 VSS.n11135 3.44377
R15391 VSS.t4048 VSS.n11111 3.44377
R15392 VSS.t4087 VSS.n1901 3.44377
R15393 VSS.n11255 VSS.n1886 3.44377
R15394 VSS.n11251 VSS.n11249 3.44377
R15395 VSS.n11249 VSS.n11248 3.44377
R15396 VSS.t4053 VSS.n1879 3.44377
R15397 VSS.t4092 VSS.n1859 3.44377
R15398 VSS.n11361 VSS.n1844 3.44377
R15399 VSS.n11357 VSS.n11355 3.44377
R15400 VSS.n11355 VSS.n11354 3.44377
R15401 VSS.t4058 VSS.n1837 3.44377
R15402 VSS.t4097 VSS.n1817 3.44377
R15403 VSS.n11467 VSS.n1802 3.44377
R15404 VSS.n11463 VSS.n11461 3.44377
R15405 VSS.n11461 VSS.n11460 3.44377
R15406 VSS.t4063 VSS.n1795 3.44377
R15407 VSS.t4102 VSS.n1775 3.44377
R15408 VSS.n11573 VSS.n1760 3.44377
R15409 VSS.n11569 VSS.n11567 3.44377
R15410 VSS.n11567 VSS.n11566 3.44377
R15411 VSS.t4068 VSS.n1753 3.44377
R15412 VSS.t4107 VSS.n1733 3.44377
R15413 VSS.n11679 VSS.n1718 3.44377
R15414 VSS.n11675 VSS.n11673 3.44377
R15415 VSS.n11673 VSS.n11672 3.44377
R15416 VSS.t4073 VSS.n1711 3.44377
R15417 VSS.t4112 VSS.n1691 3.44377
R15418 VSS.n11786 VSS.n1676 3.44377
R15419 VSS.n11781 VSS.n11779 3.44377
R15420 VSS.n11779 VSS.n11778 3.44377
R15421 VSS.n1665 VSS.n1662 3.44377
R15422 VSS.n1669 VSS.n1662 3.44377
R15423 VSS.n11878 VSS.n1653 3.44377
R15424 VSS.n11879 VSS.n11878 3.44377
R15425 VSS.n12877 VSS.n12854 3.44377
R15426 VSS.n12881 VSS.n12854 3.44377
R15427 VSS.n12882 VSS.n12881 3.44377
R15428 VSS.n12883 VSS.n12882 3.44377
R15429 VSS.n12900 VSS.n12841 3.44377
R15430 VSS.n12904 VSS.n12841 3.44377
R15431 VSS.n12905 VSS.n12904 3.44377
R15432 VSS.n12906 VSS.n12905 3.44377
R15433 VSS.t4153 VSS.n12178 3.44377
R15434 VSS.t4118 VSS.n12154 3.44377
R15435 VSS.t4157 VSS.n12135 3.44377
R15436 VSS.n12293 VSS.n12120 3.44377
R15437 VSS.n12289 VSS.n12287 3.44377
R15438 VSS.n12287 VSS.n12286 3.44377
R15439 VSS.t4123 VSS.n12113 3.44377
R15440 VSS.t4162 VSS.n12093 3.44377
R15441 VSS.n12399 VSS.n12078 3.44377
R15442 VSS.n12395 VSS.n12393 3.44377
R15443 VSS.n12393 VSS.n12392 3.44377
R15444 VSS.t4128 VSS.n12071 3.44377
R15445 VSS.t4167 VSS.n12051 3.44377
R15446 VSS.n12505 VSS.n12036 3.44377
R15447 VSS.n12501 VSS.n12499 3.44377
R15448 VSS.n12499 VSS.n12498 3.44377
R15449 VSS.t4133 VSS.n12029 3.44377
R15450 VSS.t4172 VSS.n12009 3.44377
R15451 VSS.n12611 VSS.n11994 3.44377
R15452 VSS.n12607 VSS.n12605 3.44377
R15453 VSS.n12605 VSS.n12604 3.44377
R15454 VSS.t4138 VSS.n11987 3.44377
R15455 VSS.t4177 VSS.n11967 3.44377
R15456 VSS.n12717 VSS.n11952 3.44377
R15457 VSS.n12713 VSS.n12711 3.44377
R15458 VSS.n12711 VSS.n12710 3.44377
R15459 VSS.t4143 VSS.n11945 3.44377
R15460 VSS.t4182 VSS.n11925 3.44377
R15461 VSS.n12824 VSS.n11910 3.44377
R15462 VSS.n12819 VSS.n12817 3.44377
R15463 VSS.n12817 VSS.n12816 3.44377
R15464 VSS.n11899 VSS.n11896 3.44377
R15465 VSS.n11903 VSS.n11896 3.44377
R15466 VSS.n12916 VSS.n11887 3.44377
R15467 VSS.n12917 VSS.n12916 3.44377
R15468 VSS.n1611 VSS.n1610 3.44377
R15469 VSS.n1612 VSS.n1611 3.44377
R15470 VSS.n1612 VSS.n1585 3.44377
R15471 VSS.n1616 VSS.n1585 3.44377
R15472 VSS.n1633 VSS.n1632 3.44377
R15473 VSS.n1634 VSS.n1633 3.44377
R15474 VSS.n1634 VSS.n1571 3.44377
R15475 VSS.n1638 VSS.n1571 3.44377
R15476 VSS.t4223 VSS.n13527 3.44377
R15477 VSS.t4188 VSS.n1275 3.44377
R15478 VSS.n13490 VSS.t4227 3.44377
R15479 VSS.n13451 VSS.n13450 3.44377
R15480 VSS.n13455 VSS.n1297 3.44377
R15481 VSS.n13456 VSS.n13455 3.44377
R15482 VSS.n13437 VSS.t4193 3.44377
R15483 VSS.n13390 VSS.t4232 3.44377
R15484 VSS.n13350 VSS.n13349 3.44377
R15485 VSS.n13354 VSS.n1347 3.44377
R15486 VSS.n13355 VSS.n13354 3.44377
R15487 VSS.n13336 VSS.t4198 3.44377
R15488 VSS.n13289 VSS.t4237 3.44377
R15489 VSS.n13249 VSS.n13248 3.44377
R15490 VSS.n13253 VSS.n1397 3.44377
R15491 VSS.n13254 VSS.n13253 3.44377
R15492 VSS.n13235 VSS.t4203 3.44377
R15493 VSS.n13188 VSS.t4242 3.44377
R15494 VSS.n13148 VSS.n13147 3.44377
R15495 VSS.n13152 VSS.n1447 3.44377
R15496 VSS.n13153 VSS.n13152 3.44377
R15497 VSS.n13134 VSS.t4208 3.44377
R15498 VSS.n13087 VSS.t4247 3.44377
R15499 VSS.n13047 VSS.n13046 3.44377
R15500 VSS.n13051 VSS.n1497 3.44377
R15501 VSS.n13052 VSS.n13051 3.44377
R15502 VSS.n13033 VSS.t4213 3.44377
R15503 VSS.n12986 VSS.t4252 3.44377
R15504 VSS.n12946 VSS.n12945 3.44377
R15505 VSS.n12950 VSS.n1547 3.44377
R15506 VSS.n12951 VSS.n12950 3.44377
R15507 VSS.n12927 VSS.n1565 3.44377
R15508 VSS.n12931 VSS.n1565 3.44377
R15509 VSS.n1645 VSS.n1567 3.44377
R15510 VSS.n1649 VSS.n1567 3.44377
R15511 VSS.n13893 VSS.n13892 3.44377
R15512 VSS.n13894 VSS.n13893 3.44377
R15513 VSS.n13894 VSS.n13867 3.44377
R15514 VSS.n13898 VSS.n13867 3.44377
R15515 VSS.n13915 VSS.n13914 3.44377
R15516 VSS.n13916 VSS.n13915 3.44377
R15517 VSS.n13916 VSS.n13853 3.44377
R15518 VSS.n13920 VSS.n13853 3.44377
R15519 VSS.t4292 VSS.n14492 3.44377
R15520 VSS.t4258 VSS.n13590 3.44377
R15521 VSS.n14455 VSS.t4296 3.44377
R15522 VSS.n14416 VSS.n14415 3.44377
R15523 VSS.n14420 VSS.n13612 3.44377
R15524 VSS.n14421 VSS.n14420 3.44377
R15525 VSS.n14402 VSS.t4263 3.44377
R15526 VSS.n14355 VSS.n14354 3.44377
R15527 VSS.n14237 VSS.n13730 3.44377
R15528 VSS.t4307 VSS.n14155 3.44377
R15529 VSS.n14143 VSS.t4277 3.44377
R15530 VSS.n14096 VSS.t4311 3.44377
R15531 VSS.n14056 VSS.n14055 3.44377
R15532 VSS.n14060 VSS.n13779 3.44377
R15533 VSS.n14061 VSS.n14060 3.44377
R15534 VSS.n14042 VSS.t4282 3.44377
R15535 VSS.n13995 VSS.t4316 3.44377
R15536 VSS.n13955 VSS.n13954 3.44377
R15537 VSS.n13959 VSS.n13829 3.44377
R15538 VSS.n13960 VSS.n13959 3.44377
R15539 VSS.n13936 VSS.n13847 3.44377
R15540 VSS.n13940 VSS.n13847 3.44377
R15541 VSS.n13927 VSS.n13849 3.44377
R15542 VSS.n13931 VSS.n13849 3.44377
R15543 VSS.n15189 VSS.n15188 3.44377
R15544 VSS.n15190 VSS.n15189 3.44377
R15545 VSS.n15190 VSS.n15163 3.44377
R15546 VSS.n15194 VSS.n15163 3.44377
R15547 VSS.n15211 VSS.n15210 3.44377
R15548 VSS.n15212 VSS.n15211 3.44377
R15549 VSS.n15212 VSS.n15149 3.44377
R15550 VSS.n15216 VSS.n15149 3.44377
R15551 VSS.t4345 VSS.n14575 3.44377
R15552 VSS.t4322 VSS.n14554 3.44377
R15553 VSS.t4349 VSS.n449 3.44377
R15554 VSS.n14695 VSS.n434 3.44377
R15555 VSS.n14691 VSS.n14689 3.44377
R15556 VSS.n14689 VSS.n14688 3.44377
R15557 VSS.n14717 VSS.n14716 3.44377
R15558 VSS.n14716 VSS.n14715 3.44377
R15559 VSS.n14715 VSS.n428 3.44377
R15560 VSS.n14736 VSS.n14735 3.44377
R15561 VSS.n14735 VSS.n14734 3.44377
R15562 VSS.n14734 VSS.n410 3.44377
R15563 VSS.n14803 VSS.n14802 3.44377
R15564 VSS.n14802 VSS.n382 3.44377
R15565 VSS.n14798 VSS.n382 3.44377
R15566 VSS.n14896 VSS.n14895 3.44377
R15567 VSS.n14895 VSS.n14894 3.44377
R15568 VSS.n14894 VSS.n355 3.44377
R15569 VSS.n14956 VSS.n333 3.44377
R15570 VSS.n14952 VSS.n333 3.44377
R15571 VSS.n14952 VSS.n14951 3.44377
R15572 VSS.n14951 VSS.n14950 3.44377
R15573 VSS.n14984 VSS.n325 3.44377
R15574 VSS.n14980 VSS.n325 3.44377
R15575 VSS.n14980 VSS.n14979 3.44377
R15576 VSS.n14979 VSS.n14978 3.44377
R15577 VSS.n15028 VSS.n15002 3.44377
R15578 VSS.n15032 VSS.n15002 3.44377
R15579 VSS.n3779 VSS.t2895 3.43143
R15580 VSS.n4381 VSS.t2992 3.43143
R15581 VSS.n4370 VSS.t2989 3.43143
R15582 VSS.t2977 VSS.n4289 3.43143
R15583 VSS.t2974 VSS.n4270 3.43143
R15584 VSS.t2962 VSS.n4188 3.43143
R15585 VSS.t2959 VSS.n4169 3.43143
R15586 VSS.t2947 VSS.n4087 3.43143
R15587 VSS.t2944 VSS.n4068 3.43143
R15588 VSS.t2932 VSS.n3986 3.43143
R15589 VSS.t2929 VSS.n3967 3.43143
R15590 VSS.t2917 VSS.n3885 3.43143
R15591 VSS.t2914 VSS.n3866 3.43143
R15592 VSS.t2905 VSS.n3811 3.43143
R15593 VSS.t2902 VSS.n3802 3.43143
R15594 VSS.n5192 VSS.t2777 3.43143
R15595 VSS.n5208 VSS.t2774 3.43143
R15596 VSS.n5298 VSS.t2762 3.43143
R15597 VSS.n5314 VSS.t2759 3.43143
R15598 VSS.n5404 VSS.t2747 3.43143
R15599 VSS.n5420 VSS.t2744 3.43143
R15600 VSS.n5510 VSS.t2732 3.43143
R15601 VSS.n5526 VSS.t2729 3.43143
R15602 VSS.n5616 VSS.t2717 3.43143
R15603 VSS.n5632 VSS.t2714 3.43143
R15604 VSS.n5722 VSS.t2702 3.43143
R15605 VSS.n5738 VSS.t2699 3.43143
R15606 VSS.t2690 VSS.n4864 3.43143
R15607 VSS.n5878 VSS.t2687 3.43143
R15608 VSS.n6462 VSS.t2562 3.43143
R15609 VSS.n6451 VSS.t2559 3.43143
R15610 VSS.t2547 VSS.n6370 3.43143
R15611 VSS.t2544 VSS.n6351 3.43143
R15612 VSS.t2532 VSS.n6269 3.43143
R15613 VSS.t2529 VSS.n6250 3.43143
R15614 VSS.t2517 VSS.n6168 3.43143
R15615 VSS.t2514 VSS.n6149 3.43143
R15616 VSS.t2502 VSS.n6067 3.43143
R15617 VSS.t2499 VSS.n6048 3.43143
R15618 VSS.t2487 VSS.n5966 3.43143
R15619 VSS.t2484 VSS.n5947 3.43143
R15620 VSS.t2475 VSS.n5892 3.43143
R15621 VSS.t2472 VSS.n4844 3.43143
R15622 VSS.n7504 VSS.t2347 3.43143
R15623 VSS.n7493 VSS.t2344 3.43143
R15624 VSS.t2332 VSS.n7412 3.43143
R15625 VSS.t2329 VSS.n7393 3.43143
R15626 VSS.t2317 VSS.n7311 3.43143
R15627 VSS.t2314 VSS.n7292 3.43143
R15628 VSS.t2302 VSS.n7210 3.43143
R15629 VSS.t2299 VSS.n7191 3.43143
R15630 VSS.t2287 VSS.n7109 3.43143
R15631 VSS.t2284 VSS.n7090 3.43143
R15632 VSS.t2272 VSS.n7008 3.43143
R15633 VSS.t2269 VSS.n6989 3.43143
R15634 VSS.t2260 VSS.n6934 3.43143
R15635 VSS.t2257 VSS.n6925 3.43143
R15636 VSS.n7674 VSS.t2132 3.43143
R15637 VSS.n7690 VSS.t2129 3.43143
R15638 VSS.n7780 VSS.t2117 3.43143
R15639 VSS.n7796 VSS.t2114 3.43143
R15640 VSS.n7886 VSS.t2102 3.43143
R15641 VSS.n7902 VSS.t2099 3.43143
R15642 VSS.n7992 VSS.t2087 3.43143
R15643 VSS.n8008 VSS.t2084 3.43143
R15644 VSS.n8098 VSS.t2072 3.43143
R15645 VSS.n8114 VSS.t2069 3.43143
R15646 VSS.n8204 VSS.t2057 3.43143
R15647 VSS.n8220 VSS.t2054 3.43143
R15648 VSS.t2045 VSS.n2292 3.43143
R15649 VSS.n8360 VSS.t2042 3.43143
R15650 VSS.n8712 VSS.t1917 3.43143
R15651 VSS.n8728 VSS.t1914 3.43143
R15652 VSS.n8818 VSS.t1902 3.43143
R15653 VSS.n8834 VSS.t1899 3.43143
R15654 VSS.n8924 VSS.t1887 3.43143
R15655 VSS.n8940 VSS.t1884 3.43143
R15656 VSS.n9030 VSS.t1872 3.43143
R15657 VSS.n9046 VSS.t1869 3.43143
R15658 VSS.n9136 VSS.t1857 3.43143
R15659 VSS.n9152 VSS.t1854 3.43143
R15660 VSS.n9242 VSS.t1842 3.43143
R15661 VSS.n9258 VSS.t1839 3.43143
R15662 VSS.t1830 VSS.n8384 3.43143
R15663 VSS.n9398 VSS.t1827 3.43143
R15664 VSS.n2249 VSS.t1602 3.43143
R15665 VSS.n9982 VSS.t1699 3.43143
R15666 VSS.n9971 VSS.t1696 3.43143
R15667 VSS.t1684 VSS.n9890 3.43143
R15668 VSS.t1681 VSS.n9871 3.43143
R15669 VSS.t1669 VSS.n9789 3.43143
R15670 VSS.t1666 VSS.n9770 3.43143
R15671 VSS.t1654 VSS.n9688 3.43143
R15672 VSS.t1651 VSS.n9669 3.43143
R15673 VSS.t1639 VSS.n9587 3.43143
R15674 VSS.t1636 VSS.n9568 3.43143
R15675 VSS.t1624 VSS.n9486 3.43143
R15676 VSS.t1621 VSS.n9467 3.43143
R15677 VSS.t1612 VSS.n9412 3.43143
R15678 VSS.t1609 VSS.n2272 3.43143
R15679 VSS.n11024 VSS.t1484 3.43143
R15680 VSS.n11013 VSS.t1481 3.43143
R15681 VSS.t1469 VSS.n10932 3.43143
R15682 VSS.t1466 VSS.n10913 3.43143
R15683 VSS.t1454 VSS.n10831 3.43143
R15684 VSS.t1451 VSS.n10812 3.43143
R15685 VSS.t1439 VSS.n10730 3.43143
R15686 VSS.t1436 VSS.n10711 3.43143
R15687 VSS.t1424 VSS.n10629 3.43143
R15688 VSS.t1421 VSS.n10610 3.43143
R15689 VSS.t1409 VSS.n10528 3.43143
R15690 VSS.t1406 VSS.n10509 3.43143
R15691 VSS.t1397 VSS.n10454 3.43143
R15692 VSS.t1394 VSS.n10445 3.43143
R15693 VSS.n11194 VSS.t1269 3.43143
R15694 VSS.n11210 VSS.t1266 3.43143
R15695 VSS.n11300 VSS.t1254 3.43143
R15696 VSS.n11316 VSS.t1251 3.43143
R15697 VSS.n11406 VSS.t1239 3.43143
R15698 VSS.n11422 VSS.t1236 3.43143
R15699 VSS.n11512 VSS.t1224 3.43143
R15700 VSS.n11528 VSS.t1221 3.43143
R15701 VSS.n11618 VSS.t1209 3.43143
R15702 VSS.n11634 VSS.t1206 3.43143
R15703 VSS.n11724 VSS.t1194 3.43143
R15704 VSS.n11740 VSS.t1191 3.43143
R15705 VSS.t1182 VSS.n1670 3.43143
R15706 VSS.n11880 VSS.t1179 3.43143
R15707 VSS.n12232 VSS.t1054 3.43143
R15708 VSS.n12248 VSS.t1051 3.43143
R15709 VSS.n12338 VSS.t1039 3.43143
R15710 VSS.n12354 VSS.t1036 3.43143
R15711 VSS.n12444 VSS.t1024 3.43143
R15712 VSS.n12460 VSS.t1021 3.43143
R15713 VSS.n12550 VSS.t1009 3.43143
R15714 VSS.n12566 VSS.t1006 3.43143
R15715 VSS.n12656 VSS.t994 3.43143
R15716 VSS.n12672 VSS.t991 3.43143
R15717 VSS.n12762 VSS.t979 3.43143
R15718 VSS.n12778 VSS.t976 3.43143
R15719 VSS.t967 VSS.n11904 3.43143
R15720 VSS.n12918 VSS.t964 3.43143
R15721 VSS.n13502 VSS.t839 3.43143
R15722 VSS.n13491 VSS.t836 3.43143
R15723 VSS.t824 VSS.n13410 3.43143
R15724 VSS.t821 VSS.n13391 3.43143
R15725 VSS.t809 VSS.n13309 3.43143
R15726 VSS.t806 VSS.n13290 3.43143
R15727 VSS.t794 VSS.n13208 3.43143
R15728 VSS.t791 VSS.n13189 3.43143
R15729 VSS.t779 VSS.n13107 3.43143
R15730 VSS.t776 VSS.n13088 3.43143
R15731 VSS.t764 VSS.n13006 3.43143
R15732 VSS.t761 VSS.n12987 3.43143
R15733 VSS.t752 VSS.n12932 3.43143
R15734 VSS.t749 VSS.n1650 3.43143
R15735 VSS.n14467 VSS.t629 3.43143
R15736 VSS.n14456 VSS.t626 3.43143
R15737 VSS.t614 VSS.n14375 3.43143
R15738 VSS.n14356 VSS.t611 3.43143
R15739 VSS.n14181 VSS.t593 3.43143
R15740 VSS.t584 VSS.n14116 3.43143
R15741 VSS.t581 VSS.n14097 3.43143
R15742 VSS.t569 VSS.n14015 3.43143
R15743 VSS.t566 VSS.n13996 3.43143
R15744 VSS.t557 VSS.n13941 3.43143
R15745 VSS.t554 VSS.n13932 3.43143
R15746 VSS.n14634 VSS.t459 3.43143
R15747 VSS.n14650 VSS.t456 3.43143
R15748 VSS.n15240 VSS.n2 2.73839
R15749 VSS.n101 VSS.n102 2.3438
R15750 VSS.n103 VSS.n104 2.3438
R15751 VSS.n105 VSS.n106 2.3438
R15752 VSS.n107 VSS.n108 2.3438
R15753 VSS.n109 VSS.n110 2.3438
R15754 VSS.n111 VSS.n112 2.3438
R15755 VSS.n113 VSS.n114 2.3438
R15756 VSS.n115 VSS.n116 2.3438
R15757 VSS.n117 VSS.n118 2.3438
R15758 VSS.n119 VSS.n120 2.3438
R15759 VSS.n121 VSS.n122 2.3438
R15760 VSS.n123 VSS.n124 2.3438
R15761 VSS.n14797 VSS.n14796 3.40077
R15762 VSS.n14242 VSS.t127 3.38874
R15763 VSS.n426 VSS.n425 3.32358
R15764 VSS.n408 VSS.n407 3.32358
R15765 VSS.n15134 VSS.t4338 3.26859
R15766 VSS.t3004 VSS.n3778 3.21921
R15767 VSS.t2898 VSS.n3790 3.21921
R15768 VSS.n4417 VSS.t2997 3.21921
R15769 VSS.t3000 VSS.t3523 3.21921
R15770 VSS.t3107 VSS.n4406 3.21921
R15771 VSS.t3105 VSS.t3488 3.21921
R15772 VSS.t2995 VSS.n3446 3.21921
R15773 VSS.n52 VSS.t3103 4.58763
R15774 VSS.n4382 VSS.t3100 3.21921
R15775 VSS.t3527 VSS.t2988 3.21921
R15776 VSS.t3097 VSS.n4369 3.21921
R15777 VSS.t2986 VSS.n4364 3.21921
R15778 VSS.t2983 VSS.n4335 3.21921
R15779 VSS.t3493 VSS.t3090 3.21921
R15780 VSS.t2980 VSS.n4316 3.21921
R15781 VSS.t3088 VSS.n4311 3.21921
R15782 VSS.n4286 VSS.t3085 3.21921
R15783 VSS.t2973 VSS.t3532 3.21921
R15784 VSS.t3082 VSS.n4269 3.21921
R15785 VSS.t2971 VSS.n4263 3.21921
R15786 VSS.t2968 VSS.n4234 3.21921
R15787 VSS.t3498 VSS.t3075 3.21921
R15788 VSS.t2965 VSS.n4215 3.21921
R15789 VSS.t3073 VSS.n4210 3.21921
R15790 VSS.n4185 VSS.t3070 3.21921
R15791 VSS.t2958 VSS.t3537 3.21921
R15792 VSS.t3067 VSS.n4168 3.21921
R15793 VSS.t2956 VSS.n4162 3.21921
R15794 VSS.t2953 VSS.n4133 3.21921
R15795 VSS.t3503 VSS.t3060 3.21921
R15796 VSS.t2950 VSS.n4114 3.21921
R15797 VSS.t3058 VSS.n4109 3.21921
R15798 VSS.n4084 VSS.t3055 3.21921
R15799 VSS.t2943 VSS.t3542 3.21921
R15800 VSS.t3052 VSS.n4067 3.21921
R15801 VSS.t2941 VSS.n4061 3.21921
R15802 VSS.t2938 VSS.n4032 3.21921
R15803 VSS.t3508 VSS.t3045 3.21921
R15804 VSS.t2935 VSS.n4013 3.21921
R15805 VSS.t3043 VSS.n4008 3.21921
R15806 VSS.n3983 VSS.t3040 3.21921
R15807 VSS.t2928 VSS.t3547 3.21921
R15808 VSS.t3037 VSS.n3966 3.21921
R15809 VSS.t2926 VSS.n3960 3.21921
R15810 VSS.t2923 VSS.n3931 3.21921
R15811 VSS.t3513 VSS.t3030 3.21921
R15812 VSS.t2920 VSS.n3912 3.21921
R15813 VSS.t3028 VSS.n3907 3.21921
R15814 VSS.n3882 VSS.t3025 3.21921
R15815 VSS.t2913 VSS.t3552 3.21921
R15816 VSS.t3022 VSS.n3865 3.21921
R15817 VSS.t2911 VSS.n3859 3.21921
R15818 VSS.t2908 VSS.n3830 3.21921
R15819 VSS.t3013 VSS.n3810 3.21921
R15820 VSS.t3009 VSS.n3801 3.21921
R15821 VSS.n5843 VSS.t2680 3.21921
R15822 VSS.n5866 VSS.t2683 3.21921
R15823 VSS.n5149 VSS.t2782 3.21921
R15824 VSS.t2785 VSS.t3593 3.21921
R15825 VSS.t2889 VSS.n5138 3.21921
R15826 VSS.t2887 VSS.t3558 3.21921
R15827 VSS.t2780 VSS.n5114 3.21921
R15828 VSS.n51 VSS.t2885 4.58763
R15829 VSS.n5193 VSS.t2882 3.21921
R15830 VSS.t2773 VSS.t3597 3.21921
R15831 VSS.t2879 VSS.n5095 3.21921
R15832 VSS.t2771 VSS.n5093 3.21921
R15833 VSS.n5246 VSS.t2768 3.21921
R15834 VSS.t2872 VSS.t3563 3.21921
R15835 VSS.t2765 VSS.n5073 3.21921
R15836 VSS.n5277 VSS.t2870 3.21921
R15837 VSS.n5299 VSS.t2867 3.21921
R15838 VSS.t2758 VSS.t3602 3.21921
R15839 VSS.t2864 VSS.n5053 3.21921
R15840 VSS.t2756 VSS.n5051 3.21921
R15841 VSS.n5352 VSS.t2753 3.21921
R15842 VSS.t2857 VSS.t3568 3.21921
R15843 VSS.t2750 VSS.n5031 3.21921
R15844 VSS.n5383 VSS.t2855 3.21921
R15845 VSS.n5405 VSS.t2852 3.21921
R15846 VSS.t2743 VSS.t3607 3.21921
R15847 VSS.t2849 VSS.n5011 3.21921
R15848 VSS.t2741 VSS.n5009 3.21921
R15849 VSS.n5458 VSS.t2738 3.21921
R15850 VSS.t2842 VSS.t3573 3.21921
R15851 VSS.t2735 VSS.n4989 3.21921
R15852 VSS.n5489 VSS.t2840 3.21921
R15853 VSS.n5511 VSS.t2837 3.21921
R15854 VSS.t2728 VSS.t3612 3.21921
R15855 VSS.t2834 VSS.n4969 3.21921
R15856 VSS.t2726 VSS.n4967 3.21921
R15857 VSS.n5564 VSS.t2723 3.21921
R15858 VSS.t2827 VSS.t3578 3.21921
R15859 VSS.t2720 VSS.n4947 3.21921
R15860 VSS.n5595 VSS.t2825 3.21921
R15861 VSS.n5617 VSS.t2822 3.21921
R15862 VSS.t2713 VSS.t3617 3.21921
R15863 VSS.t2819 VSS.n4927 3.21921
R15864 VSS.t2711 VSS.n4925 3.21921
R15865 VSS.n5670 VSS.t2708 3.21921
R15866 VSS.t2812 VSS.t3583 3.21921
R15867 VSS.t2705 VSS.n4905 3.21921
R15868 VSS.n5701 VSS.t2810 3.21921
R15869 VSS.n5723 VSS.t2807 3.21921
R15870 VSS.t2698 VSS.t3622 3.21921
R15871 VSS.t2804 VSS.n4885 3.21921
R15872 VSS.t2696 VSS.n4883 3.21921
R15873 VSS.n5776 VSS.t2693 3.21921
R15874 VSS.t2795 VSS.n4863 3.21921
R15875 VSS.t2791 VSS.n5877 3.21921
R15876 VSS.t2465 VSS.n4810 3.21921
R15877 VSS.t2468 VSS.n4832 3.21921
R15878 VSS.n6498 VSS.t2567 3.21921
R15879 VSS.t2570 VSS.t3663 3.21921
R15880 VSS.t2674 VSS.n6487 3.21921
R15881 VSS.t2672 VSS.t3628 3.21921
R15882 VSS.t2565 VSS.n4469 3.21921
R15883 VSS.n50 VSS.t2670 4.58763
R15884 VSS.n6463 VSS.t2667 3.21921
R15885 VSS.t3667 VSS.t2558 3.21921
R15886 VSS.t2664 VSS.n6450 3.21921
R15887 VSS.t2556 VSS.n6445 3.21921
R15888 VSS.t2553 VSS.n6416 3.21921
R15889 VSS.t3633 VSS.t2657 3.21921
R15890 VSS.t2550 VSS.n6397 3.21921
R15891 VSS.t2655 VSS.n6392 3.21921
R15892 VSS.n6367 VSS.t2652 3.21921
R15893 VSS.t2543 VSS.t3672 3.21921
R15894 VSS.t2649 VSS.n6350 3.21921
R15895 VSS.t2541 VSS.n6344 3.21921
R15896 VSS.t2538 VSS.n6315 3.21921
R15897 VSS.t3638 VSS.t2642 3.21921
R15898 VSS.t2535 VSS.n6296 3.21921
R15899 VSS.t2640 VSS.n6291 3.21921
R15900 VSS.n6266 VSS.t2637 3.21921
R15901 VSS.t2528 VSS.t3677 3.21921
R15902 VSS.t2634 VSS.n6249 3.21921
R15903 VSS.t2526 VSS.n6243 3.21921
R15904 VSS.t2523 VSS.n6214 3.21921
R15905 VSS.t3643 VSS.t2627 3.21921
R15906 VSS.t2520 VSS.n6195 3.21921
R15907 VSS.t2625 VSS.n6190 3.21921
R15908 VSS.n6165 VSS.t2622 3.21921
R15909 VSS.t2513 VSS.t3682 3.21921
R15910 VSS.t2619 VSS.n6148 3.21921
R15911 VSS.t2511 VSS.n6142 3.21921
R15912 VSS.t2508 VSS.n6113 3.21921
R15913 VSS.t3648 VSS.t2612 3.21921
R15914 VSS.t2505 VSS.n6094 3.21921
R15915 VSS.t2610 VSS.n6089 3.21921
R15916 VSS.n6064 VSS.t2607 3.21921
R15917 VSS.t2498 VSS.t3687 3.21921
R15918 VSS.t2604 VSS.n6047 3.21921
R15919 VSS.t2496 VSS.n6041 3.21921
R15920 VSS.t2493 VSS.n6012 3.21921
R15921 VSS.t3653 VSS.t2597 3.21921
R15922 VSS.t2490 VSS.n5993 3.21921
R15923 VSS.t2595 VSS.n5988 3.21921
R15924 VSS.n5963 VSS.t2592 3.21921
R15925 VSS.t2483 VSS.t3692 3.21921
R15926 VSS.t2589 VSS.n5946 3.21921
R15927 VSS.t2481 VSS.n5940 3.21921
R15928 VSS.t2478 VSS.n5911 3.21921
R15929 VSS.t2580 VSS.n5891 3.21921
R15930 VSS.t2576 VSS.n4843 3.21921
R15931 VSS.t2250 VSS.n6891 3.21921
R15932 VSS.t2253 VSS.n6913 3.21921
R15933 VSS.n7540 VSS.t2352 3.21921
R15934 VSS.t2355 VSS.t3733 3.21921
R15935 VSS.t2459 VSS.n7529 3.21921
R15936 VSS.t2457 VSS.t3698 3.21921
R15937 VSS.t2350 VSS.n6550 3.21921
R15938 VSS.n49 VSS.t2455 4.58763
R15939 VSS.n7505 VSS.t2452 3.21921
R15940 VSS.t3737 VSS.t2343 3.21921
R15941 VSS.t2449 VSS.n7492 3.21921
R15942 VSS.t2341 VSS.n7487 3.21921
R15943 VSS.t2338 VSS.n7458 3.21921
R15944 VSS.t3703 VSS.t2442 3.21921
R15945 VSS.t2335 VSS.n7439 3.21921
R15946 VSS.t2440 VSS.n7434 3.21921
R15947 VSS.n7409 VSS.t2437 3.21921
R15948 VSS.t2328 VSS.t3742 3.21921
R15949 VSS.t2434 VSS.n7392 3.21921
R15950 VSS.t2326 VSS.n7386 3.21921
R15951 VSS.t2323 VSS.n7357 3.21921
R15952 VSS.t3708 VSS.t2427 3.21921
R15953 VSS.t2320 VSS.n7338 3.21921
R15954 VSS.t2425 VSS.n7333 3.21921
R15955 VSS.n7308 VSS.t2422 3.21921
R15956 VSS.t2313 VSS.t3747 3.21921
R15957 VSS.t2419 VSS.n7291 3.21921
R15958 VSS.t2311 VSS.n7285 3.21921
R15959 VSS.t2308 VSS.n7256 3.21921
R15960 VSS.t3713 VSS.t2412 3.21921
R15961 VSS.t2305 VSS.n7237 3.21921
R15962 VSS.t2410 VSS.n7232 3.21921
R15963 VSS.n7207 VSS.t2407 3.21921
R15964 VSS.t2298 VSS.t3752 3.21921
R15965 VSS.t2404 VSS.n7190 3.21921
R15966 VSS.t2296 VSS.n7184 3.21921
R15967 VSS.t2293 VSS.n7155 3.21921
R15968 VSS.t3718 VSS.t2397 3.21921
R15969 VSS.t2290 VSS.n7136 3.21921
R15970 VSS.t2395 VSS.n7131 3.21921
R15971 VSS.n7106 VSS.t2392 3.21921
R15972 VSS.t2283 VSS.t3757 3.21921
R15973 VSS.t2389 VSS.n7089 3.21921
R15974 VSS.t2281 VSS.n7083 3.21921
R15975 VSS.t2278 VSS.n7054 3.21921
R15976 VSS.t3723 VSS.t2382 3.21921
R15977 VSS.t2275 VSS.n7035 3.21921
R15978 VSS.t2380 VSS.n7030 3.21921
R15979 VSS.n7005 VSS.t2377 3.21921
R15980 VSS.t2268 VSS.t3762 3.21921
R15981 VSS.t2374 VSS.n6988 3.21921
R15982 VSS.t2266 VSS.n6982 3.21921
R15983 VSS.t2263 VSS.n6953 3.21921
R15984 VSS.t2365 VSS.n6933 3.21921
R15985 VSS.t2361 VSS.n6924 3.21921
R15986 VSS.n8325 VSS.t2035 3.21921
R15987 VSS.n8348 VSS.t2038 3.21921
R15988 VSS.n7626 VSS.t2137 3.21921
R15989 VSS.t2140 VSS.t3803 3.21921
R15990 VSS.t2244 VSS.n7615 3.21921
R15991 VSS.t2242 VSS.t3768 3.21921
R15992 VSS.t2135 VSS.n7591 3.21921
R15993 VSS.n48 VSS.t2240 4.58763
R15994 VSS.n7675 VSS.t2237 3.21921
R15995 VSS.t2128 VSS.t3807 3.21921
R15996 VSS.t2234 VSS.n2523 3.21921
R15997 VSS.t2126 VSS.n2521 3.21921
R15998 VSS.n7728 VSS.t2123 3.21921
R15999 VSS.t2227 VSS.t3773 3.21921
R16000 VSS.t2120 VSS.n2501 3.21921
R16001 VSS.n7759 VSS.t2225 3.21921
R16002 VSS.n7781 VSS.t2222 3.21921
R16003 VSS.t2113 VSS.t3812 3.21921
R16004 VSS.t2219 VSS.n2481 3.21921
R16005 VSS.t2111 VSS.n2479 3.21921
R16006 VSS.n7834 VSS.t2108 3.21921
R16007 VSS.t2212 VSS.t3778 3.21921
R16008 VSS.t2105 VSS.n2459 3.21921
R16009 VSS.n7865 VSS.t2210 3.21921
R16010 VSS.n7887 VSS.t2207 3.21921
R16011 VSS.t2098 VSS.t3817 3.21921
R16012 VSS.t2204 VSS.n2439 3.21921
R16013 VSS.t2096 VSS.n2437 3.21921
R16014 VSS.n7940 VSS.t2093 3.21921
R16015 VSS.t2197 VSS.t3783 3.21921
R16016 VSS.t2090 VSS.n2417 3.21921
R16017 VSS.n7971 VSS.t2195 3.21921
R16018 VSS.n7993 VSS.t2192 3.21921
R16019 VSS.t2083 VSS.t3822 3.21921
R16020 VSS.t2189 VSS.n2397 3.21921
R16021 VSS.t2081 VSS.n2395 3.21921
R16022 VSS.n8046 VSS.t2078 3.21921
R16023 VSS.t2182 VSS.t3788 3.21921
R16024 VSS.t2075 VSS.n2375 3.21921
R16025 VSS.n8077 VSS.t2180 3.21921
R16026 VSS.n8099 VSS.t2177 3.21921
R16027 VSS.t2068 VSS.t3827 3.21921
R16028 VSS.t2174 VSS.n2355 3.21921
R16029 VSS.t2066 VSS.n2353 3.21921
R16030 VSS.n8152 VSS.t2063 3.21921
R16031 VSS.t2167 VSS.t3793 3.21921
R16032 VSS.t2060 VSS.n2333 3.21921
R16033 VSS.n8183 VSS.t2165 3.21921
R16034 VSS.n8205 VSS.t2162 3.21921
R16035 VSS.t2053 VSS.t3832 3.21921
R16036 VSS.t2159 VSS.n2313 3.21921
R16037 VSS.t2051 VSS.n2311 3.21921
R16038 VSS.n8258 VSS.t2048 3.21921
R16039 VSS.t2150 VSS.n2291 3.21921
R16040 VSS.t2146 VSS.n8359 3.21921
R16041 VSS.n9363 VSS.t1820 3.21921
R16042 VSS.n9386 VSS.t1823 3.21921
R16043 VSS.n8669 VSS.t1922 3.21921
R16044 VSS.t1925 VSS.t3873 3.21921
R16045 VSS.t2029 VSS.n8658 3.21921
R16046 VSS.t2027 VSS.t3838 3.21921
R16047 VSS.t1920 VSS.n8634 3.21921
R16048 VSS.n47 VSS.t2025 4.58763
R16049 VSS.n8713 VSS.t2022 3.21921
R16050 VSS.t1913 VSS.t3877 3.21921
R16051 VSS.t2019 VSS.n8615 3.21921
R16052 VSS.t1911 VSS.n8613 3.21921
R16053 VSS.n8766 VSS.t1908 3.21921
R16054 VSS.t2012 VSS.t3843 3.21921
R16055 VSS.t1905 VSS.n8593 3.21921
R16056 VSS.n8797 VSS.t2010 3.21921
R16057 VSS.n8819 VSS.t2007 3.21921
R16058 VSS.t1898 VSS.t3882 3.21921
R16059 VSS.t2004 VSS.n8573 3.21921
R16060 VSS.t1896 VSS.n8571 3.21921
R16061 VSS.n8872 VSS.t1893 3.21921
R16062 VSS.t1997 VSS.t3848 3.21921
R16063 VSS.t1890 VSS.n8551 3.21921
R16064 VSS.n8903 VSS.t1995 3.21921
R16065 VSS.n8925 VSS.t1992 3.21921
R16066 VSS.t1883 VSS.t3887 3.21921
R16067 VSS.t1989 VSS.n8531 3.21921
R16068 VSS.t1881 VSS.n8529 3.21921
R16069 VSS.n8978 VSS.t1878 3.21921
R16070 VSS.t1982 VSS.t3853 3.21921
R16071 VSS.t1875 VSS.n8509 3.21921
R16072 VSS.n9009 VSS.t1980 3.21921
R16073 VSS.n9031 VSS.t1977 3.21921
R16074 VSS.t1868 VSS.t3892 3.21921
R16075 VSS.t1974 VSS.n8489 3.21921
R16076 VSS.t1866 VSS.n8487 3.21921
R16077 VSS.n9084 VSS.t1863 3.21921
R16078 VSS.t1967 VSS.t3858 3.21921
R16079 VSS.t1860 VSS.n8467 3.21921
R16080 VSS.n9115 VSS.t1965 3.21921
R16081 VSS.n9137 VSS.t1962 3.21921
R16082 VSS.t1853 VSS.t3897 3.21921
R16083 VSS.t1959 VSS.n8447 3.21921
R16084 VSS.t1851 VSS.n8445 3.21921
R16085 VSS.n9190 VSS.t1848 3.21921
R16086 VSS.t1952 VSS.t3863 3.21921
R16087 VSS.t1845 VSS.n8425 3.21921
R16088 VSS.n9221 VSS.t1950 3.21921
R16089 VSS.n9243 VSS.t1947 3.21921
R16090 VSS.t1838 VSS.t3902 3.21921
R16091 VSS.t1944 VSS.n8405 3.21921
R16092 VSS.t1836 VSS.n8403 3.21921
R16093 VSS.n9296 VSS.t1833 3.21921
R16094 VSS.t1935 VSS.n8383 3.21921
R16095 VSS.t1931 VSS.n9397 3.21921
R16096 VSS.t1711 VSS.n2248 3.21921
R16097 VSS.t1605 VSS.n2260 3.21921
R16098 VSS.n10018 VSS.t1704 3.21921
R16099 VSS.t1707 VSS.t3943 3.21921
R16100 VSS.t1814 VSS.n10007 3.21921
R16101 VSS.t1812 VSS.t3908 3.21921
R16102 VSS.t1702 VSS.n1916 3.21921
R16103 VSS.n46 VSS.t1810 4.58763
R16104 VSS.n9983 VSS.t1807 3.21921
R16105 VSS.t3947 VSS.t1695 3.21921
R16106 VSS.t1804 VSS.n9970 3.21921
R16107 VSS.t1693 VSS.n9965 3.21921
R16108 VSS.t1690 VSS.n9936 3.21921
R16109 VSS.t3913 VSS.t1797 3.21921
R16110 VSS.t1687 VSS.n9917 3.21921
R16111 VSS.t1795 VSS.n9912 3.21921
R16112 VSS.n9887 VSS.t1792 3.21921
R16113 VSS.t1680 VSS.t3952 3.21921
R16114 VSS.t1789 VSS.n9870 3.21921
R16115 VSS.t1678 VSS.n9864 3.21921
R16116 VSS.t1675 VSS.n9835 3.21921
R16117 VSS.t3918 VSS.t1782 3.21921
R16118 VSS.t1672 VSS.n9816 3.21921
R16119 VSS.t1780 VSS.n9811 3.21921
R16120 VSS.n9786 VSS.t1777 3.21921
R16121 VSS.t1665 VSS.t3957 3.21921
R16122 VSS.t1774 VSS.n9769 3.21921
R16123 VSS.t1663 VSS.n9763 3.21921
R16124 VSS.t1660 VSS.n9734 3.21921
R16125 VSS.t3923 VSS.t1767 3.21921
R16126 VSS.t1657 VSS.n9715 3.21921
R16127 VSS.t1765 VSS.n9710 3.21921
R16128 VSS.n9685 VSS.t1762 3.21921
R16129 VSS.t1650 VSS.t3962 3.21921
R16130 VSS.t1759 VSS.n9668 3.21921
R16131 VSS.t1648 VSS.n9662 3.21921
R16132 VSS.t1645 VSS.n9633 3.21921
R16133 VSS.t3928 VSS.t1752 3.21921
R16134 VSS.t1642 VSS.n9614 3.21921
R16135 VSS.t1750 VSS.n9609 3.21921
R16136 VSS.n9584 VSS.t1747 3.21921
R16137 VSS.t1635 VSS.t3967 3.21921
R16138 VSS.t1744 VSS.n9567 3.21921
R16139 VSS.t1633 VSS.n9561 3.21921
R16140 VSS.t1630 VSS.n9532 3.21921
R16141 VSS.t3933 VSS.t1737 3.21921
R16142 VSS.t1627 VSS.n9513 3.21921
R16143 VSS.t1735 VSS.n9508 3.21921
R16144 VSS.n9483 VSS.t1732 3.21921
R16145 VSS.t1620 VSS.t3972 3.21921
R16146 VSS.t1729 VSS.n9466 3.21921
R16147 VSS.t1618 VSS.n9460 3.21921
R16148 VSS.t1615 VSS.n9431 3.21921
R16149 VSS.t1720 VSS.n9411 3.21921
R16150 VSS.t1716 VSS.n2271 3.21921
R16151 VSS.t1387 VSS.n10411 3.21921
R16152 VSS.t1390 VSS.n10433 3.21921
R16153 VSS.n11060 VSS.t1489 3.21921
R16154 VSS.t1492 VSS.t4013 3.21921
R16155 VSS.t1596 VSS.n11049 3.21921
R16156 VSS.t1594 VSS.t3978 3.21921
R16157 VSS.t1487 VSS.n10070 3.21921
R16158 VSS.n45 VSS.t1592 4.58763
R16159 VSS.n11025 VSS.t1589 3.21921
R16160 VSS.t4017 VSS.t1480 3.21921
R16161 VSS.t1586 VSS.n11012 3.21921
R16162 VSS.t1478 VSS.n11007 3.21921
R16163 VSS.t1475 VSS.n10978 3.21921
R16164 VSS.t3983 VSS.t1579 3.21921
R16165 VSS.t1472 VSS.n10959 3.21921
R16166 VSS.t1577 VSS.n10954 3.21921
R16167 VSS.n10929 VSS.t1574 3.21921
R16168 VSS.t1465 VSS.t4022 3.21921
R16169 VSS.t1571 VSS.n10912 3.21921
R16170 VSS.t1463 VSS.n10906 3.21921
R16171 VSS.t1460 VSS.n10877 3.21921
R16172 VSS.t3988 VSS.t1564 3.21921
R16173 VSS.t1457 VSS.n10858 3.21921
R16174 VSS.t1562 VSS.n10853 3.21921
R16175 VSS.n10828 VSS.t1559 3.21921
R16176 VSS.t1450 VSS.t4027 3.21921
R16177 VSS.t1556 VSS.n10811 3.21921
R16178 VSS.t1448 VSS.n10805 3.21921
R16179 VSS.t1445 VSS.n10776 3.21921
R16180 VSS.t3993 VSS.t1549 3.21921
R16181 VSS.t1442 VSS.n10757 3.21921
R16182 VSS.t1547 VSS.n10752 3.21921
R16183 VSS.n10727 VSS.t1544 3.21921
R16184 VSS.t1435 VSS.t4032 3.21921
R16185 VSS.t1541 VSS.n10710 3.21921
R16186 VSS.t1433 VSS.n10704 3.21921
R16187 VSS.t1430 VSS.n10675 3.21921
R16188 VSS.t3998 VSS.t1534 3.21921
R16189 VSS.t1427 VSS.n10656 3.21921
R16190 VSS.t1532 VSS.n10651 3.21921
R16191 VSS.n10626 VSS.t1529 3.21921
R16192 VSS.t1420 VSS.t4037 3.21921
R16193 VSS.t1526 VSS.n10609 3.21921
R16194 VSS.t1418 VSS.n10603 3.21921
R16195 VSS.t1415 VSS.n10574 3.21921
R16196 VSS.t4003 VSS.t1519 3.21921
R16197 VSS.t1412 VSS.n10555 3.21921
R16198 VSS.t1517 VSS.n10550 3.21921
R16199 VSS.n10525 VSS.t1514 3.21921
R16200 VSS.t1405 VSS.t4042 3.21921
R16201 VSS.t1511 VSS.n10508 3.21921
R16202 VSS.t1403 VSS.n10502 3.21921
R16203 VSS.t1400 VSS.n10473 3.21921
R16204 VSS.t1502 VSS.n10453 3.21921
R16205 VSS.t1498 VSS.n10444 3.21921
R16206 VSS.n11845 VSS.t1172 3.21921
R16207 VSS.n11868 VSS.t1175 3.21921
R16208 VSS.n11146 VSS.t1274 3.21921
R16209 VSS.t1277 VSS.t4083 3.21921
R16210 VSS.t1381 VSS.n11135 3.21921
R16211 VSS.t1379 VSS.t4048 3.21921
R16212 VSS.t1272 VSS.n11111 3.21921
R16213 VSS.n44 VSS.t1377 4.58763
R16214 VSS.n11195 VSS.t1374 3.21921
R16215 VSS.t1265 VSS.t4087 3.21921
R16216 VSS.t1371 VSS.n1901 3.21921
R16217 VSS.t1263 VSS.n1899 3.21921
R16218 VSS.n11248 VSS.t1260 3.21921
R16219 VSS.t1364 VSS.t4053 3.21921
R16220 VSS.t1257 VSS.n1879 3.21921
R16221 VSS.n11279 VSS.t1362 3.21921
R16222 VSS.n11301 VSS.t1359 3.21921
R16223 VSS.t1250 VSS.t4092 3.21921
R16224 VSS.t1356 VSS.n1859 3.21921
R16225 VSS.t1248 VSS.n1857 3.21921
R16226 VSS.n11354 VSS.t1245 3.21921
R16227 VSS.t1349 VSS.t4058 3.21921
R16228 VSS.t1242 VSS.n1837 3.21921
R16229 VSS.n11385 VSS.t1347 3.21921
R16230 VSS.n11407 VSS.t1344 3.21921
R16231 VSS.t1235 VSS.t4097 3.21921
R16232 VSS.t1341 VSS.n1817 3.21921
R16233 VSS.t1233 VSS.n1815 3.21921
R16234 VSS.n11460 VSS.t1230 3.21921
R16235 VSS.t1334 VSS.t4063 3.21921
R16236 VSS.t1227 VSS.n1795 3.21921
R16237 VSS.n11491 VSS.t1332 3.21921
R16238 VSS.n11513 VSS.t1329 3.21921
R16239 VSS.t1220 VSS.t4102 3.21921
R16240 VSS.t1326 VSS.n1775 3.21921
R16241 VSS.t1218 VSS.n1773 3.21921
R16242 VSS.n11566 VSS.t1215 3.21921
R16243 VSS.t1319 VSS.t4068 3.21921
R16244 VSS.t1212 VSS.n1753 3.21921
R16245 VSS.n11597 VSS.t1317 3.21921
R16246 VSS.n11619 VSS.t1314 3.21921
R16247 VSS.t1205 VSS.t4107 3.21921
R16248 VSS.t1311 VSS.n1733 3.21921
R16249 VSS.t1203 VSS.n1731 3.21921
R16250 VSS.n11672 VSS.t1200 3.21921
R16251 VSS.t1304 VSS.t4073 3.21921
R16252 VSS.t1197 VSS.n1711 3.21921
R16253 VSS.n11703 VSS.t1302 3.21921
R16254 VSS.n11725 VSS.t1299 3.21921
R16255 VSS.t1190 VSS.t4112 3.21921
R16256 VSS.t1296 VSS.n1691 3.21921
R16257 VSS.t1188 VSS.n1689 3.21921
R16258 VSS.n11778 VSS.t1185 3.21921
R16259 VSS.t1287 VSS.n1669 3.21921
R16260 VSS.t1283 VSS.n11879 3.21921
R16261 VSS.n12883 VSS.t957 3.21921
R16262 VSS.n12906 VSS.t960 3.21921
R16263 VSS.n12189 VSS.t1059 3.21921
R16264 VSS.t1062 VSS.t4153 3.21921
R16265 VSS.t1166 VSS.n12178 3.21921
R16266 VSS.t1164 VSS.t4118 3.21921
R16267 VSS.t1057 VSS.n12154 3.21921
R16268 VSS.n43 VSS.t1162 4.58763
R16269 VSS.n12233 VSS.t1159 3.21921
R16270 VSS.t1050 VSS.t4157 3.21921
R16271 VSS.t1156 VSS.n12135 3.21921
R16272 VSS.t1048 VSS.n12133 3.21921
R16273 VSS.n12286 VSS.t1045 3.21921
R16274 VSS.t1149 VSS.t4123 3.21921
R16275 VSS.t1042 VSS.n12113 3.21921
R16276 VSS.n12317 VSS.t1147 3.21921
R16277 VSS.n12339 VSS.t1144 3.21921
R16278 VSS.t1035 VSS.t4162 3.21921
R16279 VSS.t1141 VSS.n12093 3.21921
R16280 VSS.t1033 VSS.n12091 3.21921
R16281 VSS.n12392 VSS.t1030 3.21921
R16282 VSS.t1134 VSS.t4128 3.21921
R16283 VSS.t1027 VSS.n12071 3.21921
R16284 VSS.n12423 VSS.t1132 3.21921
R16285 VSS.n12445 VSS.t1129 3.21921
R16286 VSS.t1020 VSS.t4167 3.21921
R16287 VSS.t1126 VSS.n12051 3.21921
R16288 VSS.t1018 VSS.n12049 3.21921
R16289 VSS.n12498 VSS.t1015 3.21921
R16290 VSS.t1119 VSS.t4133 3.21921
R16291 VSS.t1012 VSS.n12029 3.21921
R16292 VSS.n12529 VSS.t1117 3.21921
R16293 VSS.n12551 VSS.t1114 3.21921
R16294 VSS.t1005 VSS.t4172 3.21921
R16295 VSS.t1111 VSS.n12009 3.21921
R16296 VSS.t1003 VSS.n12007 3.21921
R16297 VSS.n12604 VSS.t1000 3.21921
R16298 VSS.t1104 VSS.t4138 3.21921
R16299 VSS.t997 VSS.n11987 3.21921
R16300 VSS.n12635 VSS.t1102 3.21921
R16301 VSS.n12657 VSS.t1099 3.21921
R16302 VSS.t990 VSS.t4177 3.21921
R16303 VSS.t1096 VSS.n11967 3.21921
R16304 VSS.t988 VSS.n11965 3.21921
R16305 VSS.n12710 VSS.t985 3.21921
R16306 VSS.t1089 VSS.t4143 3.21921
R16307 VSS.t982 VSS.n11945 3.21921
R16308 VSS.n12741 VSS.t1087 3.21921
R16309 VSS.n12763 VSS.t1084 3.21921
R16310 VSS.t975 VSS.t4182 3.21921
R16311 VSS.t1081 VSS.n11925 3.21921
R16312 VSS.t973 VSS.n11923 3.21921
R16313 VSS.n12816 VSS.t970 3.21921
R16314 VSS.t1072 VSS.n11903 3.21921
R16315 VSS.t1068 VSS.n12917 3.21921
R16316 VSS.t742 VSS.n1616 3.21921
R16317 VSS.t745 VSS.n1638 3.21921
R16318 VSS.n13538 VSS.t844 3.21921
R16319 VSS.t847 VSS.t4223 3.21921
R16320 VSS.t951 VSS.n13527 3.21921
R16321 VSS.t949 VSS.t4188 3.21921
R16322 VSS.t842 VSS.n1275 3.21921
R16323 VSS.n42 VSS.t947 4.58763
R16324 VSS.n13503 VSS.t944 3.21921
R16325 VSS.t4227 VSS.t835 3.21921
R16326 VSS.t941 VSS.n13490 3.21921
R16327 VSS.t833 VSS.n13485 3.21921
R16328 VSS.t830 VSS.n13456 3.21921
R16329 VSS.t4193 VSS.t934 3.21921
R16330 VSS.t827 VSS.n13437 3.21921
R16331 VSS.t932 VSS.n13432 3.21921
R16332 VSS.n13407 VSS.t929 3.21921
R16333 VSS.t820 VSS.t4232 3.21921
R16334 VSS.t926 VSS.n13390 3.21921
R16335 VSS.t818 VSS.n13384 3.21921
R16336 VSS.t815 VSS.n13355 3.21921
R16337 VSS.t4198 VSS.t919 3.21921
R16338 VSS.t812 VSS.n13336 3.21921
R16339 VSS.t917 VSS.n13331 3.21921
R16340 VSS.n13306 VSS.t914 3.21921
R16341 VSS.t805 VSS.t4237 3.21921
R16342 VSS.t911 VSS.n13289 3.21921
R16343 VSS.t803 VSS.n13283 3.21921
R16344 VSS.t800 VSS.n13254 3.21921
R16345 VSS.t4203 VSS.t904 3.21921
R16346 VSS.t797 VSS.n13235 3.21921
R16347 VSS.t902 VSS.n13230 3.21921
R16348 VSS.n13205 VSS.t899 3.21921
R16349 VSS.t790 VSS.t4242 3.21921
R16350 VSS.t896 VSS.n13188 3.21921
R16351 VSS.t788 VSS.n13182 3.21921
R16352 VSS.t785 VSS.n13153 3.21921
R16353 VSS.t4208 VSS.t889 3.21921
R16354 VSS.t782 VSS.n13134 3.21921
R16355 VSS.t887 VSS.n13129 3.21921
R16356 VSS.n13104 VSS.t884 3.21921
R16357 VSS.t775 VSS.t4247 3.21921
R16358 VSS.t881 VSS.n13087 3.21921
R16359 VSS.t773 VSS.n13081 3.21921
R16360 VSS.t770 VSS.n13052 3.21921
R16361 VSS.t4213 VSS.t874 3.21921
R16362 VSS.t767 VSS.n13033 3.21921
R16363 VSS.t872 VSS.n13028 3.21921
R16364 VSS.n13003 VSS.t869 3.21921
R16365 VSS.t760 VSS.t4252 3.21921
R16366 VSS.t866 VSS.n12986 3.21921
R16367 VSS.t758 VSS.n12980 3.21921
R16368 VSS.t755 VSS.n12951 3.21921
R16369 VSS.t857 VSS.n12931 3.21921
R16370 VSS.t853 VSS.n1649 3.21921
R16371 VSS.t547 VSS.n13898 3.21921
R16372 VSS.t550 VSS.n13920 3.21921
R16373 VSS.n14503 VSS.t634 3.21921
R16374 VSS.t637 VSS.t4292 3.21921
R16375 VSS.t736 VSS.n14492 3.21921
R16376 VSS.t734 VSS.t4258 3.21921
R16377 VSS.t632 VSS.n13590 3.21921
R16378 VSS.n41 VSS.t732 4.58763
R16379 VSS.n14468 VSS.t729 3.21921
R16380 VSS.t4296 VSS.t625 3.21921
R16381 VSS.t726 VSS.n14455 3.21921
R16382 VSS.t623 VSS.n14450 3.21921
R16383 VSS.t620 VSS.n14421 3.21921
R16384 VSS.t4263 VSS.t719 3.21921
R16385 VSS.t617 VSS.n14402 3.21921
R16386 VSS.t717 VSS.n14397 3.21921
R16387 VSS.n14372 VSS.t714 3.21921
R16388 VSS.t711 VSS.n14355 3.21921
R16389 VSS.t599 VSS.n14237 3.21921
R16390 VSS.t689 VSS.n14231 3.21921
R16391 VSS.t592 VSS.t4307 3.21921
R16392 VSS.t683 VSS.n14155 3.21921
R16393 VSS.t590 VSS.n14153 3.21921
R16394 VSS.t4277 VSS.t679 3.21921
R16395 VSS.t587 VSS.n14143 3.21921
R16396 VSS.t677 VSS.n14138 3.21921
R16397 VSS.n14113 VSS.t674 3.21921
R16398 VSS.t580 VSS.t4311 3.21921
R16399 VSS.t671 VSS.n14096 3.21921
R16400 VSS.t578 VSS.n14090 3.21921
R16401 VSS.t575 VSS.n14061 3.21921
R16402 VSS.t4282 VSS.t664 3.21921
R16403 VSS.t572 VSS.n14042 3.21921
R16404 VSS.t662 VSS.n14037 3.21921
R16405 VSS.n14012 VSS.t659 3.21921
R16406 VSS.t565 VSS.t4316 3.21921
R16407 VSS.t656 VSS.n13995 3.21921
R16408 VSS.t563 VSS.n13989 3.21921
R16409 VSS.t560 VSS.n13960 3.21921
R16410 VSS.t647 VSS.n13940 3.21921
R16411 VSS.t643 VSS.n13931 3.21921
R16412 VSS.t399 VSS.n15194 3.21921
R16413 VSS.t402 VSS.n15216 3.21921
R16414 VSS.n14586 VSS.t464 3.21921
R16415 VSS.t467 VSS.t4345 3.21921
R16416 VSS.t541 VSS.n14575 3.21921
R16417 VSS.t539 VSS.t4322 3.21921
R16418 VSS.t462 VSS.n14554 3.21921
R16419 VSS.n40 VSS.t537 4.58763
R16420 VSS.n14635 VSS.t534 3.21921
R16421 VSS.t455 VSS.t4349 3.21921
R16422 VSS.t531 VSS.n449 3.21921
R16423 VSS.t453 VSS.n447 3.21921
R16424 VSS.n14688 VSS.t450 3.21921
R16425 VSS.t447 VSS.n428 3.21921
R16426 VSS.t444 VSS.n410 3.21921
R16427 VSS.t439 VSS.n14807 3.21921
R16428 VSS.n14798 VSS.t438 3.21921
R16429 VSS.t435 VSS.n14827 3.21921
R16430 VSS.n14826 VSS.t509 3.21921
R16431 VSS.t427 VSS.n14866 3.21921
R16432 VSS.n14863 VSS.t507 3.21921
R16433 VSS.t425 VSS.n355 3.21921
R16434 VSS.n14950 VSS.t416 3.21921
R16435 VSS.n14978 VSS.t413 3.21921
R16436 VSS.t410 VSS.n15032 3.21921
R16437 VSS.n3778 VSS.n3777 3.20814
R16438 VSS.n4418 VSS.n4417 3.20814
R16439 VSS.n4451 VSS.n52 1.65591
R16440 VSS.n4383 VSS.n4382 3.20814
R16441 VSS.n4364 VSS.n3454 3.20814
R16442 VSS.n4311 VSS.n3486 3.20814
R16443 VSS.n4286 VSS.n4285 3.20814
R16444 VSS.n4263 VSS.n3504 3.20814
R16445 VSS.n4210 VSS.n3536 3.20814
R16446 VSS.n4185 VSS.n4184 3.20814
R16447 VSS.n4162 VSS.n3554 3.20814
R16448 VSS.n4109 VSS.n3586 3.20814
R16449 VSS.n4084 VSS.n4083 3.20814
R16450 VSS.n4061 VSS.n3604 3.20814
R16451 VSS.n4008 VSS.n3636 3.20814
R16452 VSS.n3983 VSS.n3982 3.20814
R16453 VSS.n3960 VSS.n3654 3.20814
R16454 VSS.n3907 VSS.n3686 3.20814
R16455 VSS.n3882 VSS.n3881 3.20814
R16456 VSS.n3859 VSS.n3704 3.20814
R16457 VSS.n5150 VSS.n5149 3.20814
R16458 VSS.n5185 VSS.n51 1.65591
R16459 VSS.n5194 VSS.n5193 3.20814
R16460 VSS.n5217 VSS.n5093 3.20814
R16461 VSS.n5278 VSS.n5277 3.20814
R16462 VSS.n5300 VSS.n5299 3.20814
R16463 VSS.n5323 VSS.n5051 3.20814
R16464 VSS.n5384 VSS.n5383 3.20814
R16465 VSS.n5406 VSS.n5405 3.20814
R16466 VSS.n5429 VSS.n5009 3.20814
R16467 VSS.n5490 VSS.n5489 3.20814
R16468 VSS.n5512 VSS.n5511 3.20814
R16469 VSS.n5535 VSS.n4967 3.20814
R16470 VSS.n5596 VSS.n5595 3.20814
R16471 VSS.n5618 VSS.n5617 3.20814
R16472 VSS.n5641 VSS.n4925 3.20814
R16473 VSS.n5702 VSS.n5701 3.20814
R16474 VSS.n5724 VSS.n5723 3.20814
R16475 VSS.n5747 VSS.n4883 3.20814
R16476 VSS.n6499 VSS.n6498 3.20814
R16477 VSS.n6532 VSS.n50 1.65591
R16478 VSS.n6464 VSS.n6463 3.20814
R16479 VSS.n6445 VSS.n4477 3.20814
R16480 VSS.n6392 VSS.n4509 3.20814
R16481 VSS.n6367 VSS.n6366 3.20814
R16482 VSS.n6344 VSS.n4527 3.20814
R16483 VSS.n6291 VSS.n4559 3.20814
R16484 VSS.n6266 VSS.n6265 3.20814
R16485 VSS.n6243 VSS.n4577 3.20814
R16486 VSS.n6190 VSS.n4609 3.20814
R16487 VSS.n6165 VSS.n6164 3.20814
R16488 VSS.n6142 VSS.n4627 3.20814
R16489 VSS.n6089 VSS.n4659 3.20814
R16490 VSS.n6064 VSS.n6063 3.20814
R16491 VSS.n6041 VSS.n4677 3.20814
R16492 VSS.n5988 VSS.n4709 3.20814
R16493 VSS.n5963 VSS.n5962 3.20814
R16494 VSS.n5940 VSS.n4727 3.20814
R16495 VSS.n7541 VSS.n7540 3.20814
R16496 VSS.n7574 VSS.n49 1.65591
R16497 VSS.n7506 VSS.n7505 3.20814
R16498 VSS.n7487 VSS.n6558 3.20814
R16499 VSS.n7434 VSS.n6590 3.20814
R16500 VSS.n7409 VSS.n7408 3.20814
R16501 VSS.n7386 VSS.n6608 3.20814
R16502 VSS.n7333 VSS.n6640 3.20814
R16503 VSS.n7308 VSS.n7307 3.20814
R16504 VSS.n7285 VSS.n6658 3.20814
R16505 VSS.n7232 VSS.n6690 3.20814
R16506 VSS.n7207 VSS.n7206 3.20814
R16507 VSS.n7184 VSS.n6708 3.20814
R16508 VSS.n7131 VSS.n6740 3.20814
R16509 VSS.n7106 VSS.n7105 3.20814
R16510 VSS.n7083 VSS.n6758 3.20814
R16511 VSS.n7030 VSS.n6790 3.20814
R16512 VSS.n7005 VSS.n7004 3.20814
R16513 VSS.n6982 VSS.n6808 3.20814
R16514 VSS.n7627 VSS.n7626 3.20814
R16515 VSS.n7660 VSS.n48 1.65591
R16516 VSS.n7676 VSS.n7675 3.20814
R16517 VSS.n7699 VSS.n2521 3.20814
R16518 VSS.n7760 VSS.n7759 3.20814
R16519 VSS.n7782 VSS.n7781 3.20814
R16520 VSS.n7805 VSS.n2479 3.20814
R16521 VSS.n7866 VSS.n7865 3.20814
R16522 VSS.n7888 VSS.n7887 3.20814
R16523 VSS.n7911 VSS.n2437 3.20814
R16524 VSS.n7972 VSS.n7971 3.20814
R16525 VSS.n7994 VSS.n7993 3.20814
R16526 VSS.n8017 VSS.n2395 3.20814
R16527 VSS.n8078 VSS.n8077 3.20814
R16528 VSS.n8100 VSS.n8099 3.20814
R16529 VSS.n8123 VSS.n2353 3.20814
R16530 VSS.n8184 VSS.n8183 3.20814
R16531 VSS.n8206 VSS.n8205 3.20814
R16532 VSS.n8229 VSS.n2311 3.20814
R16533 VSS.n8670 VSS.n8669 3.20814
R16534 VSS.n8705 VSS.n47 1.65591
R16535 VSS.n8714 VSS.n8713 3.20814
R16536 VSS.n8737 VSS.n8613 3.20814
R16537 VSS.n8798 VSS.n8797 3.20814
R16538 VSS.n8820 VSS.n8819 3.20814
R16539 VSS.n8843 VSS.n8571 3.20814
R16540 VSS.n8904 VSS.n8903 3.20814
R16541 VSS.n8926 VSS.n8925 3.20814
R16542 VSS.n8949 VSS.n8529 3.20814
R16543 VSS.n9010 VSS.n9009 3.20814
R16544 VSS.n9032 VSS.n9031 3.20814
R16545 VSS.n9055 VSS.n8487 3.20814
R16546 VSS.n9116 VSS.n9115 3.20814
R16547 VSS.n9138 VSS.n9137 3.20814
R16548 VSS.n9161 VSS.n8445 3.20814
R16549 VSS.n9222 VSS.n9221 3.20814
R16550 VSS.n9244 VSS.n9243 3.20814
R16551 VSS.n9267 VSS.n8403 3.20814
R16552 VSS.n2248 VSS.n2247 3.20814
R16553 VSS.n10019 VSS.n10018 3.20814
R16554 VSS.n10052 VSS.n46 1.65591
R16555 VSS.n9984 VSS.n9983 3.20814
R16556 VSS.n9965 VSS.n1924 3.20814
R16557 VSS.n9912 VSS.n1956 3.20814
R16558 VSS.n9887 VSS.n9886 3.20814
R16559 VSS.n9864 VSS.n1974 3.20814
R16560 VSS.n9811 VSS.n2006 3.20814
R16561 VSS.n9786 VSS.n9785 3.20814
R16562 VSS.n9763 VSS.n2024 3.20814
R16563 VSS.n9710 VSS.n2056 3.20814
R16564 VSS.n9685 VSS.n9684 3.20814
R16565 VSS.n9662 VSS.n2074 3.20814
R16566 VSS.n9609 VSS.n2106 3.20814
R16567 VSS.n9584 VSS.n9583 3.20814
R16568 VSS.n9561 VSS.n2124 3.20814
R16569 VSS.n9508 VSS.n2156 3.20814
R16570 VSS.n9483 VSS.n9482 3.20814
R16571 VSS.n9460 VSS.n2174 3.20814
R16572 VSS.n11061 VSS.n11060 3.20814
R16573 VSS.n11094 VSS.n45 1.65591
R16574 VSS.n11026 VSS.n11025 3.20814
R16575 VSS.n11007 VSS.n10078 3.20814
R16576 VSS.n10954 VSS.n10110 3.20814
R16577 VSS.n10929 VSS.n10928 3.20814
R16578 VSS.n10906 VSS.n10128 3.20814
R16579 VSS.n10853 VSS.n10160 3.20814
R16580 VSS.n10828 VSS.n10827 3.20814
R16581 VSS.n10805 VSS.n10178 3.20814
R16582 VSS.n10752 VSS.n10210 3.20814
R16583 VSS.n10727 VSS.n10726 3.20814
R16584 VSS.n10704 VSS.n10228 3.20814
R16585 VSS.n10651 VSS.n10260 3.20814
R16586 VSS.n10626 VSS.n10625 3.20814
R16587 VSS.n10603 VSS.n10278 3.20814
R16588 VSS.n10550 VSS.n10310 3.20814
R16589 VSS.n10525 VSS.n10524 3.20814
R16590 VSS.n10502 VSS.n10328 3.20814
R16591 VSS.n11147 VSS.n11146 3.20814
R16592 VSS.n11180 VSS.n44 1.65591
R16593 VSS.n11196 VSS.n11195 3.20814
R16594 VSS.n11219 VSS.n1899 3.20814
R16595 VSS.n11280 VSS.n11279 3.20814
R16596 VSS.n11302 VSS.n11301 3.20814
R16597 VSS.n11325 VSS.n1857 3.20814
R16598 VSS.n11386 VSS.n11385 3.20814
R16599 VSS.n11408 VSS.n11407 3.20814
R16600 VSS.n11431 VSS.n1815 3.20814
R16601 VSS.n11492 VSS.n11491 3.20814
R16602 VSS.n11514 VSS.n11513 3.20814
R16603 VSS.n11537 VSS.n1773 3.20814
R16604 VSS.n11598 VSS.n11597 3.20814
R16605 VSS.n11620 VSS.n11619 3.20814
R16606 VSS.n11643 VSS.n1731 3.20814
R16607 VSS.n11704 VSS.n11703 3.20814
R16608 VSS.n11726 VSS.n11725 3.20814
R16609 VSS.n11749 VSS.n1689 3.20814
R16610 VSS.n12190 VSS.n12189 3.20814
R16611 VSS.n12225 VSS.n43 1.65591
R16612 VSS.n12234 VSS.n12233 3.20814
R16613 VSS.n12257 VSS.n12133 3.20814
R16614 VSS.n12318 VSS.n12317 3.20814
R16615 VSS.n12340 VSS.n12339 3.20814
R16616 VSS.n12363 VSS.n12091 3.20814
R16617 VSS.n12424 VSS.n12423 3.20814
R16618 VSS.n12446 VSS.n12445 3.20814
R16619 VSS.n12469 VSS.n12049 3.20814
R16620 VSS.n12530 VSS.n12529 3.20814
R16621 VSS.n12552 VSS.n12551 3.20814
R16622 VSS.n12575 VSS.n12007 3.20814
R16623 VSS.n12636 VSS.n12635 3.20814
R16624 VSS.n12658 VSS.n12657 3.20814
R16625 VSS.n12681 VSS.n11965 3.20814
R16626 VSS.n12742 VSS.n12741 3.20814
R16627 VSS.n12764 VSS.n12763 3.20814
R16628 VSS.n12787 VSS.n11923 3.20814
R16629 VSS.n13539 VSS.n13538 3.20814
R16630 VSS.n13572 VSS.n42 1.65591
R16631 VSS.n13504 VSS.n13503 3.20814
R16632 VSS.n13485 VSS.n1283 3.20814
R16633 VSS.n13432 VSS.n1315 3.20814
R16634 VSS.n13407 VSS.n13406 3.20814
R16635 VSS.n13384 VSS.n1333 3.20814
R16636 VSS.n13331 VSS.n1365 3.20814
R16637 VSS.n13306 VSS.n13305 3.20814
R16638 VSS.n13283 VSS.n1383 3.20814
R16639 VSS.n13230 VSS.n1415 3.20814
R16640 VSS.n13205 VSS.n13204 3.20814
R16641 VSS.n13182 VSS.n1433 3.20814
R16642 VSS.n13129 VSS.n1465 3.20814
R16643 VSS.n13104 VSS.n13103 3.20814
R16644 VSS.n13081 VSS.n1483 3.20814
R16645 VSS.n13028 VSS.n1515 3.20814
R16646 VSS.n13003 VSS.n13002 3.20814
R16647 VSS.n12980 VSS.n1533 3.20814
R16648 VSS.n14504 VSS.n14503 3.20814
R16649 VSS.n14537 VSS.n41 1.65591
R16650 VSS.n14469 VSS.n14468 3.20814
R16651 VSS.n14450 VSS.n13598 3.20814
R16652 VSS.n14397 VSS.n13630 3.20814
R16653 VSS.n14372 VSS.n14371 3.20814
R16654 VSS.n14354 VSS.n13648 3.20814
R16655 VSS.n14231 VSS.n13732 3.20814
R16656 VSS.n14190 VSS.n14153 3.20814
R16657 VSS.n14138 VSS.n13747 3.20814
R16658 VSS.n14113 VSS.n14112 3.20814
R16659 VSS.n14090 VSS.n13765 3.20814
R16660 VSS.n14037 VSS.n13797 3.20814
R16661 VSS.n14012 VSS.n14011 3.20814
R16662 VSS.n13989 VSS.n13815 3.20814
R16663 VSS.n14587 VSS.n14586 3.20814
R16664 VSS.n14620 VSS.n40 1.65591
R16665 VSS.n14636 VSS.n14635 3.20814
R16666 VSS.n14659 VSS.n447 3.20814
R16667 VSS.n489 VSS.n471 3.2005
R16668 VSS.n885 VSS.n884 3.2005
R16669 VSS.n792 VSS.n598 3.2005
R16670 VSS.n696 VSS.n695 3.2005
R16671 VSS.n14871 VSS.n361 3.2005
R16672 VSS.n15057 VSS.n312 3.2005
R16673 VSS.n1251 VSS.t4371 3.13241
R16674 VSS.n1143 VSS.t4375 3.13241
R16675 VSS.n1123 VSS.t4376 3.13241
R16676 VSS.n682 VSS.t4395 3.13241
R16677 VSS.n15221 VSS.t4342 3.13241
R16678 VSS.n14886 VSS.t4332 3.13241
R16679 VSS.n15095 VSS.t4340 3.13241
R16680 VSS.n5837 VSS.n5836 3.06161
R16681 VSS.n5860 VSS.n5859 3.06161
R16682 VSS.n4804 VSS.n4781 3.06161
R16683 VSS.n4826 VSS.n4767 3.06161
R16684 VSS.n6885 VSS.n6862 3.06161
R16685 VSS.n6907 VSS.n6848 3.06161
R16686 VSS.n8319 VSS.n8318 3.06161
R16687 VSS.n8342 VSS.n8341 3.06161
R16688 VSS.n9357 VSS.n9356 3.06161
R16689 VSS.n9380 VSS.n9379 3.06161
R16690 VSS.n10405 VSS.n10382 3.06161
R16691 VSS.n10427 VSS.n10368 3.06161
R16692 VSS.n11839 VSS.n11838 3.06161
R16693 VSS.n11862 VSS.n11861 3.06161
R16694 VSS.n12877 VSS.n12876 3.06161
R16695 VSS.n12900 VSS.n12899 3.06161
R16696 VSS.n1610 VSS.n1587 3.06161
R16697 VSS.n1632 VSS.n1573 3.06161
R16698 VSS.n13892 VSS.n13869 3.06161
R16699 VSS.n13914 VSS.n13855 3.06161
R16700 VSS.n15188 VSS.n15165 3.06161
R16701 VSS.n15210 VSS.n15151 3.06161
R16702 VSS.n14957 VSS.n14956 3.06161
R16703 VSS.n14985 VSS.n14984 3.06161
R16704 VSS.n289 VSS.n242 3.04861
R16705 VSS.n915 VSS.n914 3.04861
R16706 VSS.n994 VSS.n574 3.04861
R16707 VSS.n1219 VSS.n1211 3.04861
R16708 VSS.n14163 VSS.n14162 3.04861
R16709 VSS.n14161 VSS.n14160 3.04861
R16710 VSS.n13700 VSS.n13699 3.04861
R16711 VSS.n13689 VSS.n13688 3.04861
R16712 VSS.n14345 VSS.n14344 3.04861
R16713 VSS.n14358 VSS.n13646 3.04861
R16714 VSS.n14899 VSS.n14898 3.04861
R16715 VSS.n14792 VSS.t441 3.04861
R16716 VSS.n14816 VSS.t159 3.01226
R16717 VSS.t79 VSS.t189 3.01226
R16718 VSS.n15131 VSS.t4338 2.99624
R16719 VSS.t490 VSS.t195 2.99624
R16720 VSS.t181 VSS.t481 2.99624
R16721 VSS.n3782 VSS.t2895 2.96026
R16722 VSS.n4462 VSS.t2992 2.96026
R16723 VSS.n4290 VSS.t2977 2.96026
R16724 VSS.n4189 VSS.t2962 2.96026
R16725 VSS.n4088 VSS.t2947 2.96026
R16726 VSS.n3987 VSS.t2932 2.96026
R16727 VSS.n3886 VSS.t2917 2.96026
R16728 VSS.n229 VSS.t2777 2.96026
R16729 VSS.n5063 VSS.t2762 2.96026
R16730 VSS.n5021 VSS.t2747 2.96026
R16731 VSS.n4979 VSS.t2732 2.96026
R16732 VSS.n4937 VSS.t2717 2.96026
R16733 VSS.n4895 VSS.t2702 2.96026
R16734 VSS.n6543 VSS.t2562 2.96026
R16735 VSS.n6371 VSS.t2547 2.96026
R16736 VSS.n6270 VSS.t2532 2.96026
R16737 VSS.n6169 VSS.t2517 2.96026
R16738 VSS.n6068 VSS.t2502 2.96026
R16739 VSS.n5967 VSS.t2487 2.96026
R16740 VSS.n7585 VSS.t2347 2.96026
R16741 VSS.n7413 VSS.t2332 2.96026
R16742 VSS.n7312 VSS.t2317 2.96026
R16743 VSS.n7211 VSS.t2302 2.96026
R16744 VSS.n7110 VSS.t2287 2.96026
R16745 VSS.n7009 VSS.t2272 2.96026
R16746 VSS.n230 VSS.t2132 2.96026
R16747 VSS.n2491 VSS.t2117 2.96026
R16748 VSS.n2449 VSS.t2102 2.96026
R16749 VSS.n2407 VSS.t2087 2.96026
R16750 VSS.n2365 VSS.t2072 2.96026
R16751 VSS.n2323 VSS.t2057 2.96026
R16752 VSS.n231 VSS.t1917 2.96026
R16753 VSS.n8583 VSS.t1902 2.96026
R16754 VSS.n8541 VSS.t1887 2.96026
R16755 VSS.n8499 VSS.t1872 2.96026
R16756 VSS.n8457 VSS.t1857 2.96026
R16757 VSS.n8415 VSS.t1842 2.96026
R16758 VSS.n2252 VSS.t1602 2.96026
R16759 VSS.n10063 VSS.t1699 2.96026
R16760 VSS.n9891 VSS.t1684 2.96026
R16761 VSS.n9790 VSS.t1669 2.96026
R16762 VSS.n9689 VSS.t1654 2.96026
R16763 VSS.n9588 VSS.t1639 2.96026
R16764 VSS.n9487 VSS.t1624 2.96026
R16765 VSS.n11105 VSS.t1484 2.96026
R16766 VSS.n10933 VSS.t1469 2.96026
R16767 VSS.n10832 VSS.t1454 2.96026
R16768 VSS.n10731 VSS.t1439 2.96026
R16769 VSS.n10630 VSS.t1424 2.96026
R16770 VSS.n10529 VSS.t1409 2.96026
R16771 VSS.n232 VSS.t1269 2.96026
R16772 VSS.n1869 VSS.t1254 2.96026
R16773 VSS.n1827 VSS.t1239 2.96026
R16774 VSS.n1785 VSS.t1224 2.96026
R16775 VSS.n1743 VSS.t1209 2.96026
R16776 VSS.n1701 VSS.t1194 2.96026
R16777 VSS.n233 VSS.t1054 2.96026
R16778 VSS.n12103 VSS.t1039 2.96026
R16779 VSS.n12061 VSS.t1024 2.96026
R16780 VSS.n12019 VSS.t1009 2.96026
R16781 VSS.n11977 VSS.t994 2.96026
R16782 VSS.n11935 VSS.t979 2.96026
R16783 VSS.n13583 VSS.t839 2.96026
R16784 VSS.n13411 VSS.t824 2.96026
R16785 VSS.n13310 VSS.t809 2.96026
R16786 VSS.n13209 VSS.t794 2.96026
R16787 VSS.n13108 VSS.t779 2.96026
R16788 VSS.n13007 VSS.t764 2.96026
R16789 VSS.n14548 VSS.t629 2.96026
R16790 VSS.n14376 VSS.t614 2.96026
R16791 VSS.n14117 VSS.t584 2.96026
R16792 VSS.n14016 VSS.t569 2.96026
R16793 VSS.n234 VSS.t459 2.96026
R16794 VSS.n14848 VSS.t170 2.92224
R16795 VSS.t3490 VSS.t3099 2.90183
R16796 VSS.t3495 VSS.t3084 2.90183
R16797 VSS.t3500 VSS.t3069 2.90183
R16798 VSS.t3505 VSS.t3054 2.90183
R16799 VSS.t3510 VSS.t3039 2.90183
R16800 VSS.t3515 VSS.t3024 2.90183
R16801 VSS.t2881 VSS.t3560 2.90183
R16802 VSS.t2866 VSS.t3565 2.90183
R16803 VSS.t2851 VSS.t3570 2.90183
R16804 VSS.t2836 VSS.t3575 2.90183
R16805 VSS.t2821 VSS.t3580 2.90183
R16806 VSS.t2806 VSS.t3585 2.90183
R16807 VSS.t3630 VSS.t2666 2.90183
R16808 VSS.t3635 VSS.t2651 2.90183
R16809 VSS.t3640 VSS.t2636 2.90183
R16810 VSS.t3645 VSS.t2621 2.90183
R16811 VSS.t3650 VSS.t2606 2.90183
R16812 VSS.t3655 VSS.t2591 2.90183
R16813 VSS.t3700 VSS.t2451 2.90183
R16814 VSS.t3705 VSS.t2436 2.90183
R16815 VSS.t3710 VSS.t2421 2.90183
R16816 VSS.t3715 VSS.t2406 2.90183
R16817 VSS.t3720 VSS.t2391 2.90183
R16818 VSS.t3725 VSS.t2376 2.90183
R16819 VSS.t2236 VSS.t3770 2.90183
R16820 VSS.t2221 VSS.t3775 2.90183
R16821 VSS.t2206 VSS.t3780 2.90183
R16822 VSS.t2191 VSS.t3785 2.90183
R16823 VSS.t2176 VSS.t3790 2.90183
R16824 VSS.t2161 VSS.t3795 2.90183
R16825 VSS.t2021 VSS.t3840 2.90183
R16826 VSS.t2006 VSS.t3845 2.90183
R16827 VSS.t1991 VSS.t3850 2.90183
R16828 VSS.t1976 VSS.t3855 2.90183
R16829 VSS.t1961 VSS.t3860 2.90183
R16830 VSS.t1946 VSS.t3865 2.90183
R16831 VSS.t3910 VSS.t1806 2.90183
R16832 VSS.t3915 VSS.t1791 2.90183
R16833 VSS.t3920 VSS.t1776 2.90183
R16834 VSS.t3925 VSS.t1761 2.90183
R16835 VSS.t3930 VSS.t1746 2.90183
R16836 VSS.t3935 VSS.t1731 2.90183
R16837 VSS.t3980 VSS.t1588 2.90183
R16838 VSS.t3985 VSS.t1573 2.90183
R16839 VSS.t3990 VSS.t1558 2.90183
R16840 VSS.t3995 VSS.t1543 2.90183
R16841 VSS.t4000 VSS.t1528 2.90183
R16842 VSS.t4005 VSS.t1513 2.90183
R16843 VSS.t1373 VSS.t4050 2.90183
R16844 VSS.t1358 VSS.t4055 2.90183
R16845 VSS.t1343 VSS.t4060 2.90183
R16846 VSS.t1328 VSS.t4065 2.90183
R16847 VSS.t1313 VSS.t4070 2.90183
R16848 VSS.t1298 VSS.t4075 2.90183
R16849 VSS.t1158 VSS.t4120 2.90183
R16850 VSS.t1143 VSS.t4125 2.90183
R16851 VSS.t1128 VSS.t4130 2.90183
R16852 VSS.t1113 VSS.t4135 2.90183
R16853 VSS.t1098 VSS.t4140 2.90183
R16854 VSS.t1083 VSS.t4145 2.90183
R16855 VSS.t4190 VSS.t943 2.90183
R16856 VSS.t4195 VSS.t928 2.90183
R16857 VSS.t4200 VSS.t913 2.90183
R16858 VSS.t4205 VSS.t898 2.90183
R16859 VSS.t4210 VSS.t883 2.90183
R16860 VSS.t4215 VSS.t868 2.90183
R16861 VSS.t4260 VSS.t728 2.90183
R16862 VSS.t685 VSS.n14179 2.90183
R16863 VSS.t4279 VSS.t673 2.90183
R16864 VSS.t4284 VSS.t658 2.90183
R16865 VSS.t533 VSS.t4324 2.90183
R16866 VSS.t195 VSS.n315 2.86007
R16867 VSS.n15096 VSS.t181 2.86007
R16868 VSS.t704 VSS.n13674 2.85496
R16869 VSS.n13696 VSS.t701 2.85496
R16870 VSS.t3321 VSS.n14252 2.84982
R16871 VSS.n14346 VSS.n14345 2.77383
R16872 VSS.n14179 VSS.n14178 2.76214
R16873 VSS.n14720 VSS.n426 2.73266
R16874 VSS.n14739 VSS.n408 2.73266
R16875 VSS.t4371 VSS.t375 2.7239
R16876 VSS.t363 VSS.t4375 2.7239
R16877 VSS.t4376 VSS.t360 2.7239
R16878 VSS.t4395 VSS.t297 2.7239
R16879 VSS.t474 VSS.t4342 2.7239
R16880 VSS.t4332 VSS.t505 2.7239
R16881 VSS.t4340 VSS.t482 2.7239
R16882 VSS.n83 VSS.n4458 1.90326
R16883 VSS.n4301 VSS.n3492 2.64086
R16884 VSS.n4200 VSS.n3542 2.64086
R16885 VSS.n4099 VSS.n3592 2.64086
R16886 VSS.n3998 VSS.n3642 2.64086
R16887 VSS.n3897 VSS.n3692 2.64086
R16888 VSS.n5190 VSS.n82 1.90326
R16889 VSS.n5287 VSS.n5068 2.64086
R16890 VSS.n5393 VSS.n5026 2.64086
R16891 VSS.n5499 VSS.n4984 2.64086
R16892 VSS.n5605 VSS.n4942 2.64086
R16893 VSS.n5711 VSS.n4900 2.64086
R16894 VSS.n81 VSS.n6539 1.90326
R16895 VSS.n6382 VSS.n4515 2.64086
R16896 VSS.n6281 VSS.n4565 2.64086
R16897 VSS.n6180 VSS.n4615 2.64086
R16898 VSS.n6079 VSS.n4665 2.64086
R16899 VSS.n5978 VSS.n4715 2.64086
R16900 VSS.n80 VSS.n7581 1.90326
R16901 VSS.n7424 VSS.n6596 2.64086
R16902 VSS.n7323 VSS.n6646 2.64086
R16903 VSS.n7222 VSS.n6696 2.64086
R16904 VSS.n7121 VSS.n6746 2.64086
R16905 VSS.n7020 VSS.n6796 2.64086
R16906 VSS.n79 VSS.n7667 1.90326
R16907 VSS.n7769 VSS.n2496 2.64086
R16908 VSS.n7875 VSS.n2454 2.64086
R16909 VSS.n7981 VSS.n2412 2.64086
R16910 VSS.n8087 VSS.n2370 2.64086
R16911 VSS.n8193 VSS.n2328 2.64086
R16912 VSS.n8710 VSS.n78 1.90326
R16913 VSS.n8807 VSS.n8588 2.64086
R16914 VSS.n8913 VSS.n8546 2.64086
R16915 VSS.n9019 VSS.n8504 2.64086
R16916 VSS.n9125 VSS.n8462 2.64086
R16917 VSS.n9231 VSS.n8420 2.64086
R16918 VSS.n77 VSS.n10059 1.90326
R16919 VSS.n9902 VSS.n1962 2.64086
R16920 VSS.n9801 VSS.n2012 2.64086
R16921 VSS.n9700 VSS.n2062 2.64086
R16922 VSS.n9599 VSS.n2112 2.64086
R16923 VSS.n9498 VSS.n2162 2.64086
R16924 VSS.n76 VSS.n11101 1.90326
R16925 VSS.n10944 VSS.n10116 2.64086
R16926 VSS.n10843 VSS.n10166 2.64086
R16927 VSS.n10742 VSS.n10216 2.64086
R16928 VSS.n10641 VSS.n10266 2.64086
R16929 VSS.n10540 VSS.n10316 2.64086
R16930 VSS.n75 VSS.n11187 1.90326
R16931 VSS.n11289 VSS.n1874 2.64086
R16932 VSS.n11395 VSS.n1832 2.64086
R16933 VSS.n11501 VSS.n1790 2.64086
R16934 VSS.n11607 VSS.n1748 2.64086
R16935 VSS.n11713 VSS.n1706 2.64086
R16936 VSS.n12230 VSS.n74 1.90326
R16937 VSS.n12327 VSS.n12108 2.64086
R16938 VSS.n12433 VSS.n12066 2.64086
R16939 VSS.n12539 VSS.n12024 2.64086
R16940 VSS.n12645 VSS.n11982 2.64086
R16941 VSS.n12751 VSS.n11940 2.64086
R16942 VSS.n73 VSS.n13579 1.90326
R16943 VSS.n13422 VSS.n1321 2.64086
R16944 VSS.n13321 VSS.n1371 2.64086
R16945 VSS.n13220 VSS.n1421 2.64086
R16946 VSS.n13119 VSS.n1471 2.64086
R16947 VSS.n13018 VSS.n1521 2.64086
R16948 VSS.n72 VSS.n14544 1.90326
R16949 VSS.n14387 VSS.n13636 2.64086
R16950 VSS.n14269 VSS.t4304 2.64086
R16951 VSS.n14128 VSS.n13753 2.64086
R16952 VSS.n14027 VSS.n13803 2.64086
R16953 VSS.n71 VSS.n14627 1.90326
R16954 VSS.t3115 VSS.n15290 2.63064
R16955 VSS.t3118 VSS.n15280 2.63064
R16956 VSS.t392 VSS.n491 2.63064
R16957 VSS.n507 VSS.t386 2.63064
R16958 VSS.t383 VSS.n462 2.63064
R16959 VSS.n1240 VSS.t377 2.63064
R16960 VSS.n1174 VSS.t368 2.63064
R16961 VSS.n1151 VSS.t365 2.63064
R16962 VSS.t353 VSS.n1077 2.63064
R16963 VSS.n1099 VSS.t350 2.63064
R16964 VSS.n1014 VSS.t347 2.63064
R16965 VSS.t338 VSS.n962 2.63064
R16966 VSS.n984 VSS.t335 2.63064
R16967 VSS.t329 VSS.n589 2.63064
R16968 VSS.t323 VSS.n850 2.63064
R16969 VSS.n872 VSS.t320 2.63064
R16970 VSS.n790 VSS.t314 2.63064
R16971 VSS.n764 VSS.t311 2.63064
R16972 VSS.n735 VSS.t305 2.63064
R16973 VSS.n712 VSS.t302 2.63064
R16974 VSS.t299 VSS.n635 2.63064
R16975 VSS.n650 VSS.t287 2.63064
R16976 VSS.n15250 VSS.t284 2.63064
R16977 VSS.t3005 VSS.n3754 2.63064
R16978 VSS.n4341 VSS.t2985 2.63064
R16979 VSS.n4240 VSS.t2970 2.63064
R16980 VSS.n4139 VSS.t2955 2.63064
R16981 VSS.n4038 VSS.t2940 2.63064
R16982 VSS.n3937 VSS.t2925 2.63064
R16983 VSS.n3836 VSS.t2910 2.63064
R16984 VSS.n5085 VSS.t2770 2.63064
R16985 VSS.n5043 VSS.t2755 2.63064
R16986 VSS.n5001 VSS.t2740 2.63064
R16987 VSS.n4959 VSS.t2725 2.63064
R16988 VSS.n4917 VSS.t2710 2.63064
R16989 VSS.n4875 VSS.t2695 2.63064
R16990 VSS.n6422 VSS.t2555 2.63064
R16991 VSS.n6321 VSS.t2540 2.63064
R16992 VSS.n6220 VSS.t2525 2.63064
R16993 VSS.n6119 VSS.t2510 2.63064
R16994 VSS.n6018 VSS.t2495 2.63064
R16995 VSS.n5917 VSS.t2480 2.63064
R16996 VSS.n7464 VSS.t2340 2.63064
R16997 VSS.n7363 VSS.t2325 2.63064
R16998 VSS.n7262 VSS.t2310 2.63064
R16999 VSS.n7161 VSS.t2295 2.63064
R17000 VSS.n7060 VSS.t2280 2.63064
R17001 VSS.n6959 VSS.t2265 2.63064
R17002 VSS.n2513 VSS.t2125 2.63064
R17003 VSS.n2471 VSS.t2110 2.63064
R17004 VSS.n2429 VSS.t2095 2.63064
R17005 VSS.n2387 VSS.t2080 2.63064
R17006 VSS.n2345 VSS.t2065 2.63064
R17007 VSS.n2303 VSS.t2050 2.63064
R17008 VSS.n8605 VSS.t1910 2.63064
R17009 VSS.n8563 VSS.t1895 2.63064
R17010 VSS.n8521 VSS.t1880 2.63064
R17011 VSS.n8479 VSS.t1865 2.63064
R17012 VSS.n8437 VSS.t1850 2.63064
R17013 VSS.n8395 VSS.t1835 2.63064
R17014 VSS.t1712 VSS.n2224 2.63064
R17015 VSS.n9942 VSS.t1692 2.63064
R17016 VSS.n9841 VSS.t1677 2.63064
R17017 VSS.n9740 VSS.t1662 2.63064
R17018 VSS.n9639 VSS.t1647 2.63064
R17019 VSS.n9538 VSS.t1632 2.63064
R17020 VSS.n9437 VSS.t1617 2.63064
R17021 VSS.n10984 VSS.t1477 2.63064
R17022 VSS.n10883 VSS.t1462 2.63064
R17023 VSS.n10782 VSS.t1447 2.63064
R17024 VSS.n10681 VSS.t1432 2.63064
R17025 VSS.n10580 VSS.t1417 2.63064
R17026 VSS.n10479 VSS.t1402 2.63064
R17027 VSS.n1891 VSS.t1262 2.63064
R17028 VSS.n1849 VSS.t1247 2.63064
R17029 VSS.n1807 VSS.t1232 2.63064
R17030 VSS.n1765 VSS.t1217 2.63064
R17031 VSS.n1723 VSS.t1202 2.63064
R17032 VSS.n1681 VSS.t1187 2.63064
R17033 VSS.n12125 VSS.t1047 2.63064
R17034 VSS.n12083 VSS.t1032 2.63064
R17035 VSS.n12041 VSS.t1017 2.63064
R17036 VSS.n11999 VSS.t1002 2.63064
R17037 VSS.n11957 VSS.t987 2.63064
R17038 VSS.n11915 VSS.t972 2.63064
R17039 VSS.n13462 VSS.t832 2.63064
R17040 VSS.n13361 VSS.t817 2.63064
R17041 VSS.n13260 VSS.t802 2.63064
R17042 VSS.n13159 VSS.t787 2.63064
R17043 VSS.n13058 VSS.t772 2.63064
R17044 VSS.n12957 VSS.t757 2.63064
R17045 VSS.n14427 VSS.t622 2.63064
R17046 VSS.n13656 VSS.t710 2.63064
R17047 VSS.n14319 VSS.t707 2.63064
R17048 VSS.n14297 VSS.t698 2.63064
R17049 VSS.t693 VSS.n13725 2.63064
R17050 VSS.n14067 VSS.t577 2.63064
R17051 VSS.n13966 VSS.t562 2.63064
R17052 VSS.n15238 VSS.t477 2.63064
R17053 VSS.n439 VSS.t452 2.63064
R17054 VSS.n14709 VSS.t449 2.63064
R17055 VSS.n14728 VSS.t446 2.63064
R17056 VSS.t443 VSS.n14746 2.63064
R17057 VSS.n14903 VSS.t501 2.63064
R17058 VSS.t418 VSS.n14945 2.63064
R17059 VSS.t491 VSS.n15059 2.63064
R17060 VSS.n260 VSS.t278 2.63064
R17061 VSS.n15346 VSS.t3121 2.63064
R17062 VSS.n2889 VSS.t3124 2.63064
R17063 VSS.n2577 VSS.t3237 2.63064
R17064 VSS.n2587 VSS.t3231 2.63064
R17065 VSS.t3228 VSS.n2536 2.63064
R17066 VSS.t3222 VSS.n2651 2.63064
R17067 VSS.n2673 VSS.t3219 2.63064
R17068 VSS.n3400 VSS.t3213 2.63064
R17069 VSS.n3377 VSS.t3210 2.63064
R17070 VSS.n3348 VSS.t3204 2.63064
R17071 VSS.n3325 VSS.t3201 2.63064
R17072 VSS.n3296 VSS.t3195 2.63064
R17073 VSS.n3273 VSS.t3192 2.63064
R17074 VSS.n3244 VSS.t3186 2.63064
R17075 VSS.n3221 VSS.t3183 2.63064
R17076 VSS.n3192 VSS.t3177 2.63064
R17077 VSS.n3169 VSS.t3174 2.63064
R17078 VSS.n3140 VSS.t3168 2.63064
R17079 VSS.n3117 VSS.t3165 2.63064
R17080 VSS.n3088 VSS.t3159 2.63064
R17081 VSS.n3065 VSS.t3156 2.63064
R17082 VSS.n3036 VSS.t3150 2.63064
R17083 VSS.n3013 VSS.t3147 2.63064
R17084 VSS.n2984 VSS.t3141 2.63064
R17085 VSS.n2961 VSS.t3138 2.63064
R17086 VSS.n2932 VSS.t3132 2.63064
R17087 VSS.n2909 VSS.t3129 2.63064
R17088 VSS.n14921 VSS.t82 2.50485
R17089 VSS.n3785 VSS.n3784 2.47068
R17090 VSS.n2255 VSS.n2254 2.47068
R17091 VSS.n3783 VSS.n3744 2.43325
R17092 VSS.n4329 VSS.t3093 2.43325
R17093 VSS.n3470 VSS.n3468 2.43325
R17094 VSS.n4228 VSS.t3078 2.43325
R17095 VSS.n3520 VSS.n3518 2.43325
R17096 VSS.n4127 VSS.t3063 2.43325
R17097 VSS.n3570 VSS.n3568 2.43325
R17098 VSS.n4026 VSS.t3048 2.43325
R17099 VSS.n3620 VSS.n3618 2.43325
R17100 VSS.n3925 VSS.t3033 2.43325
R17101 VSS.n3670 VSS.n3668 2.43325
R17102 VSS.n3824 VSS.t3018 2.43325
R17103 VSS.n3720 VSS.n3718 2.43325
R17104 VSS.n3806 VSS.n3805 2.43325
R17105 VSS.n3797 VSS.n3796 2.43325
R17106 VSS.t2875 VSS.n5253 2.43325
R17107 VSS.n5249 VSS.n5248 2.43325
R17108 VSS.t2860 VSS.n5359 2.43325
R17109 VSS.n5355 VSS.n5354 2.43325
R17110 VSS.t2845 VSS.n5465 2.43325
R17111 VSS.n5461 VSS.n5460 2.43325
R17112 VSS.t2830 VSS.n5571 2.43325
R17113 VSS.n5567 VSS.n5566 2.43325
R17114 VSS.t2815 VSS.n5677 2.43325
R17115 VSS.n5673 VSS.n5672 2.43325
R17116 VSS.t2800 VSS.n5784 2.43325
R17117 VSS.n5779 VSS.n5778 2.43325
R17118 VSS.n4859 VSS.n4858 2.43325
R17119 VSS.n5872 VSS.n4847 2.43325
R17120 VSS.n6410 VSS.t2660 2.43325
R17121 VSS.n4493 VSS.n4491 2.43325
R17122 VSS.n6309 VSS.t2645 2.43325
R17123 VSS.n4543 VSS.n4541 2.43325
R17124 VSS.n6208 VSS.t2630 2.43325
R17125 VSS.n4593 VSS.n4591 2.43325
R17126 VSS.n6107 VSS.t2615 2.43325
R17127 VSS.n4643 VSS.n4641 2.43325
R17128 VSS.n6006 VSS.t2600 2.43325
R17129 VSS.n4693 VSS.n4691 2.43325
R17130 VSS.n5905 VSS.t2585 2.43325
R17131 VSS.n4743 VSS.n4741 2.43325
R17132 VSS.n5887 VSS.n5886 2.43325
R17133 VSS.n4839 VSS.n4838 2.43325
R17134 VSS.n7452 VSS.t2445 2.43325
R17135 VSS.n6574 VSS.n6572 2.43325
R17136 VSS.n7351 VSS.t2430 2.43325
R17137 VSS.n6624 VSS.n6622 2.43325
R17138 VSS.n7250 VSS.t2415 2.43325
R17139 VSS.n6674 VSS.n6672 2.43325
R17140 VSS.n7149 VSS.t2400 2.43325
R17141 VSS.n6724 VSS.n6722 2.43325
R17142 VSS.n7048 VSS.t2385 2.43325
R17143 VSS.n6774 VSS.n6772 2.43325
R17144 VSS.n6947 VSS.t2370 2.43325
R17145 VSS.n6824 VSS.n6822 2.43325
R17146 VSS.n6929 VSS.n6928 2.43325
R17147 VSS.n6920 VSS.n6919 2.43325
R17148 VSS.t2230 VSS.n7735 2.43325
R17149 VSS.n7731 VSS.n7730 2.43325
R17150 VSS.t2215 VSS.n7841 2.43325
R17151 VSS.n7837 VSS.n7836 2.43325
R17152 VSS.t2200 VSS.n7947 2.43325
R17153 VSS.n7943 VSS.n7942 2.43325
R17154 VSS.t2185 VSS.n8053 2.43325
R17155 VSS.n8049 VSS.n8048 2.43325
R17156 VSS.t2170 VSS.n8159 2.43325
R17157 VSS.n8155 VSS.n8154 2.43325
R17158 VSS.t2155 VSS.n8266 2.43325
R17159 VSS.n8261 VSS.n8260 2.43325
R17160 VSS.n2287 VSS.n2286 2.43325
R17161 VSS.n8354 VSS.n2275 2.43325
R17162 VSS.t2015 VSS.n8773 2.43325
R17163 VSS.n8769 VSS.n8768 2.43325
R17164 VSS.t2000 VSS.n8879 2.43325
R17165 VSS.n8875 VSS.n8874 2.43325
R17166 VSS.t1985 VSS.n8985 2.43325
R17167 VSS.n8981 VSS.n8980 2.43325
R17168 VSS.t1970 VSS.n9091 2.43325
R17169 VSS.n9087 VSS.n9086 2.43325
R17170 VSS.t1955 VSS.n9197 2.43325
R17171 VSS.n9193 VSS.n9192 2.43325
R17172 VSS.t1940 VSS.n9304 2.43325
R17173 VSS.n9299 VSS.n9298 2.43325
R17174 VSS.n8379 VSS.n8378 2.43325
R17175 VSS.n9392 VSS.n8367 2.43325
R17176 VSS.n2253 VSS.n2214 2.43325
R17177 VSS.n9930 VSS.t1800 2.43325
R17178 VSS.n1940 VSS.n1938 2.43325
R17179 VSS.n9829 VSS.t1785 2.43325
R17180 VSS.n1990 VSS.n1988 2.43325
R17181 VSS.n9728 VSS.t1770 2.43325
R17182 VSS.n2040 VSS.n2038 2.43325
R17183 VSS.n9627 VSS.t1755 2.43325
R17184 VSS.n2090 VSS.n2088 2.43325
R17185 VSS.n9526 VSS.t1740 2.43325
R17186 VSS.n2140 VSS.n2138 2.43325
R17187 VSS.n9425 VSS.t1725 2.43325
R17188 VSS.n2190 VSS.n2188 2.43325
R17189 VSS.n9407 VSS.n9406 2.43325
R17190 VSS.n2267 VSS.n2266 2.43325
R17191 VSS.n10972 VSS.t1582 2.43325
R17192 VSS.n10094 VSS.n10092 2.43325
R17193 VSS.n10871 VSS.t1567 2.43325
R17194 VSS.n10144 VSS.n10142 2.43325
R17195 VSS.n10770 VSS.t1552 2.43325
R17196 VSS.n10194 VSS.n10192 2.43325
R17197 VSS.n10669 VSS.t1537 2.43325
R17198 VSS.n10244 VSS.n10242 2.43325
R17199 VSS.n10568 VSS.t1522 2.43325
R17200 VSS.n10294 VSS.n10292 2.43325
R17201 VSS.n10467 VSS.t1507 2.43325
R17202 VSS.n10344 VSS.n10342 2.43325
R17203 VSS.n10449 VSS.n10448 2.43325
R17204 VSS.n10440 VSS.n10439 2.43325
R17205 VSS.t1367 VSS.n11255 2.43325
R17206 VSS.n11251 VSS.n11250 2.43325
R17207 VSS.t1352 VSS.n11361 2.43325
R17208 VSS.n11357 VSS.n11356 2.43325
R17209 VSS.t1337 VSS.n11467 2.43325
R17210 VSS.n11463 VSS.n11462 2.43325
R17211 VSS.t1322 VSS.n11573 2.43325
R17212 VSS.n11569 VSS.n11568 2.43325
R17213 VSS.t1307 VSS.n11679 2.43325
R17214 VSS.n11675 VSS.n11674 2.43325
R17215 VSS.t1292 VSS.n11786 2.43325
R17216 VSS.n11781 VSS.n11780 2.43325
R17217 VSS.n1665 VSS.n1664 2.43325
R17218 VSS.n11874 VSS.n1653 2.43325
R17219 VSS.t1152 VSS.n12293 2.43325
R17220 VSS.n12289 VSS.n12288 2.43325
R17221 VSS.t1137 VSS.n12399 2.43325
R17222 VSS.n12395 VSS.n12394 2.43325
R17223 VSS.t1122 VSS.n12505 2.43325
R17224 VSS.n12501 VSS.n12500 2.43325
R17225 VSS.t1107 VSS.n12611 2.43325
R17226 VSS.n12607 VSS.n12606 2.43325
R17227 VSS.t1092 VSS.n12717 2.43325
R17228 VSS.n12713 VSS.n12712 2.43325
R17229 VSS.t1077 VSS.n12824 2.43325
R17230 VSS.n12819 VSS.n12818 2.43325
R17231 VSS.n11899 VSS.n11898 2.43325
R17232 VSS.n12912 VSS.n11887 2.43325
R17233 VSS.n13450 VSS.t937 2.43325
R17234 VSS.n1299 VSS.n1297 2.43325
R17235 VSS.n13349 VSS.t922 2.43325
R17236 VSS.n1349 VSS.n1347 2.43325
R17237 VSS.n13248 VSS.t907 2.43325
R17238 VSS.n1399 VSS.n1397 2.43325
R17239 VSS.n13147 VSS.t892 2.43325
R17240 VSS.n1449 VSS.n1447 2.43325
R17241 VSS.n13046 VSS.t877 2.43325
R17242 VSS.n1499 VSS.n1497 2.43325
R17243 VSS.n12945 VSS.t862 2.43325
R17244 VSS.n1549 VSS.n1547 2.43325
R17245 VSS.n12927 VSS.n12926 2.43325
R17246 VSS.n1645 VSS.n1644 2.43325
R17247 VSS.n14415 VSS.t722 2.43325
R17248 VSS.n13614 VSS.n13612 2.43325
R17249 VSS.n14055 VSS.t667 2.43325
R17250 VSS.n13781 VSS.n13779 2.43325
R17251 VSS.n13954 VSS.t652 2.43325
R17252 VSS.n13831 VSS.n13829 2.43325
R17253 VSS.n13936 VSS.n13935 2.43325
R17254 VSS.n13927 VSS.n13926 2.43325
R17255 VSS.t527 VSS.n14695 2.43325
R17256 VSS.n14691 VSS.n14690 2.43325
R17257 VSS.t524 VSS.n14720 2.43325
R17258 VSS.t521 VSS.n14739 2.43325
R17259 VSS.n15028 VSS.t409 2.43325
R17260 VSS.t3 VSS.n14873 2.41146
R17261 VSS.t3010 VSS.t3520 2.36572
R17262 VSS.t3590 VSS.t2792 2.36572
R17263 VSS.t2577 VSS.t3660 2.36572
R17264 VSS.t2362 VSS.t3730 2.36572
R17265 VSS.t3800 VSS.t2147 2.36572
R17266 VSS.t3870 VSS.t1932 2.36572
R17267 VSS.t1717 VSS.t3940 2.36572
R17268 VSS.t1499 VSS.t4010 2.36572
R17269 VSS.t4080 VSS.t1284 2.36572
R17270 VSS.t4150 VSS.t1069 2.36572
R17271 VSS.t854 VSS.t4220 2.36572
R17272 VSS.t644 VSS.t4289 2.36572
R17273 VSS.t4336 VSS.t494 2.36572
R17274 VSS.n3769 VSS.n3750 2.35386
R17275 VSS.n3774 VSS.n3748 2.35386
R17276 VSS.n4427 VSS.n4426 2.35386
R17277 VSS.n4422 VSS.n4421 2.35386
R17278 VSS.n4456 VSS.n59 2.35386
R17279 VSS.n4455 VSS.n4451 2.35386
R17280 VSS.n4391 VSS.n4376 2.35386
R17281 VSS.n4386 VSS.n4378 2.35386
R17282 VSS.n4355 VSS.n3457 2.35386
R17283 VSS.n4360 VSS.n3456 2.35386
R17284 VSS.n4302 VSS.n3489 2.35386
R17285 VSS.n4307 VSS.n3488 2.35386
R17286 VSS.n4280 VSS.n3497 2.35386
R17287 VSS.n4284 VSS.n3495 2.35386
R17288 VSS.n4254 VSS.n3507 2.35386
R17289 VSS.n4259 VSS.n3506 2.35386
R17290 VSS.n4201 VSS.n3539 2.35386
R17291 VSS.n4206 VSS.n3538 2.35386
R17292 VSS.n4179 VSS.n3547 2.35386
R17293 VSS.n4183 VSS.n3545 2.35386
R17294 VSS.n4153 VSS.n3557 2.35386
R17295 VSS.n4158 VSS.n3556 2.35386
R17296 VSS.n4100 VSS.n3589 2.35386
R17297 VSS.n4105 VSS.n3588 2.35386
R17298 VSS.n4078 VSS.n3597 2.35386
R17299 VSS.n4082 VSS.n3595 2.35386
R17300 VSS.n4052 VSS.n3607 2.35386
R17301 VSS.n4057 VSS.n3606 2.35386
R17302 VSS.n3999 VSS.n3639 2.35386
R17303 VSS.n4004 VSS.n3638 2.35386
R17304 VSS.n3977 VSS.n3647 2.35386
R17305 VSS.n3981 VSS.n3645 2.35386
R17306 VSS.n3951 VSS.n3657 2.35386
R17307 VSS.n3956 VSS.n3656 2.35386
R17308 VSS.n3898 VSS.n3689 2.35386
R17309 VSS.n3903 VSS.n3688 2.35386
R17310 VSS.n3876 VSS.n3697 2.35386
R17311 VSS.n3880 VSS.n3695 2.35386
R17312 VSS.n3850 VSS.n3707 2.35386
R17313 VSS.n3855 VSS.n3706 2.35386
R17314 VSS.n5159 VSS.n5158 2.35386
R17315 VSS.n5154 VSS.n5153 2.35386
R17316 VSS.n5188 VSS.n5187 2.35386
R17317 VSS.n5186 VSS.n5185 2.35386
R17318 VSS.n5202 VSS.n5101 2.35386
R17319 VSS.n5197 VSS.n5103 2.35386
R17320 VSS.n5223 VSS.n5090 2.35386
R17321 VSS.n5218 VSS.n5092 2.35386
R17322 VSS.n5288 VSS.n5070 2.35386
R17323 VSS.n5283 VSS.n5279 2.35386
R17324 VSS.n5308 VSS.n5059 2.35386
R17325 VSS.n5303 VSS.n5061 2.35386
R17326 VSS.n5329 VSS.n5048 2.35386
R17327 VSS.n5324 VSS.n5050 2.35386
R17328 VSS.n5394 VSS.n5028 2.35386
R17329 VSS.n5389 VSS.n5385 2.35386
R17330 VSS.n5414 VSS.n5017 2.35386
R17331 VSS.n5409 VSS.n5019 2.35386
R17332 VSS.n5435 VSS.n5006 2.35386
R17333 VSS.n5430 VSS.n5008 2.35386
R17334 VSS.n5500 VSS.n4986 2.35386
R17335 VSS.n5495 VSS.n5491 2.35386
R17336 VSS.n5520 VSS.n4975 2.35386
R17337 VSS.n5515 VSS.n4977 2.35386
R17338 VSS.n5541 VSS.n4964 2.35386
R17339 VSS.n5536 VSS.n4966 2.35386
R17340 VSS.n5606 VSS.n4944 2.35386
R17341 VSS.n5601 VSS.n5597 2.35386
R17342 VSS.n5626 VSS.n4933 2.35386
R17343 VSS.n5621 VSS.n4935 2.35386
R17344 VSS.n5647 VSS.n4922 2.35386
R17345 VSS.n5642 VSS.n4924 2.35386
R17346 VSS.n5712 VSS.n4902 2.35386
R17347 VSS.n5707 VSS.n5703 2.35386
R17348 VSS.n5732 VSS.n4891 2.35386
R17349 VSS.n5727 VSS.n4893 2.35386
R17350 VSS.n5753 VSS.n4880 2.35386
R17351 VSS.n5748 VSS.n4882 2.35386
R17352 VSS.n6508 VSS.n6507 2.35386
R17353 VSS.n6503 VSS.n6502 2.35386
R17354 VSS.n6537 VSS.n60 2.35386
R17355 VSS.n6536 VSS.n6532 2.35386
R17356 VSS.n6472 VSS.n6457 2.35386
R17357 VSS.n6467 VSS.n6459 2.35386
R17358 VSS.n6436 VSS.n4480 2.35386
R17359 VSS.n6441 VSS.n4479 2.35386
R17360 VSS.n6383 VSS.n4512 2.35386
R17361 VSS.n6388 VSS.n4511 2.35386
R17362 VSS.n6361 VSS.n4520 2.35386
R17363 VSS.n6365 VSS.n4518 2.35386
R17364 VSS.n6335 VSS.n4530 2.35386
R17365 VSS.n6340 VSS.n4529 2.35386
R17366 VSS.n6282 VSS.n4562 2.35386
R17367 VSS.n6287 VSS.n4561 2.35386
R17368 VSS.n6260 VSS.n4570 2.35386
R17369 VSS.n6264 VSS.n4568 2.35386
R17370 VSS.n6234 VSS.n4580 2.35386
R17371 VSS.n6239 VSS.n4579 2.35386
R17372 VSS.n6181 VSS.n4612 2.35386
R17373 VSS.n6186 VSS.n4611 2.35386
R17374 VSS.n6159 VSS.n4620 2.35386
R17375 VSS.n6163 VSS.n4618 2.35386
R17376 VSS.n6133 VSS.n4630 2.35386
R17377 VSS.n6138 VSS.n4629 2.35386
R17378 VSS.n6080 VSS.n4662 2.35386
R17379 VSS.n6085 VSS.n4661 2.35386
R17380 VSS.n6058 VSS.n4670 2.35386
R17381 VSS.n6062 VSS.n4668 2.35386
R17382 VSS.n6032 VSS.n4680 2.35386
R17383 VSS.n6037 VSS.n4679 2.35386
R17384 VSS.n5979 VSS.n4712 2.35386
R17385 VSS.n5984 VSS.n4711 2.35386
R17386 VSS.n5957 VSS.n4720 2.35386
R17387 VSS.n5961 VSS.n4718 2.35386
R17388 VSS.n5931 VSS.n4730 2.35386
R17389 VSS.n5936 VSS.n4729 2.35386
R17390 VSS.n7550 VSS.n7549 2.35386
R17391 VSS.n7545 VSS.n7544 2.35386
R17392 VSS.n7579 VSS.n61 2.35386
R17393 VSS.n7578 VSS.n7574 2.35386
R17394 VSS.n7514 VSS.n7499 2.35386
R17395 VSS.n7509 VSS.n7501 2.35386
R17396 VSS.n7478 VSS.n6561 2.35386
R17397 VSS.n7483 VSS.n6560 2.35386
R17398 VSS.n7425 VSS.n6593 2.35386
R17399 VSS.n7430 VSS.n6592 2.35386
R17400 VSS.n7403 VSS.n6601 2.35386
R17401 VSS.n7407 VSS.n6599 2.35386
R17402 VSS.n7377 VSS.n6611 2.35386
R17403 VSS.n7382 VSS.n6610 2.35386
R17404 VSS.n7324 VSS.n6643 2.35386
R17405 VSS.n7329 VSS.n6642 2.35386
R17406 VSS.n7302 VSS.n6651 2.35386
R17407 VSS.n7306 VSS.n6649 2.35386
R17408 VSS.n7276 VSS.n6661 2.35386
R17409 VSS.n7281 VSS.n6660 2.35386
R17410 VSS.n7223 VSS.n6693 2.35386
R17411 VSS.n7228 VSS.n6692 2.35386
R17412 VSS.n7201 VSS.n6701 2.35386
R17413 VSS.n7205 VSS.n6699 2.35386
R17414 VSS.n7175 VSS.n6711 2.35386
R17415 VSS.n7180 VSS.n6710 2.35386
R17416 VSS.n7122 VSS.n6743 2.35386
R17417 VSS.n7127 VSS.n6742 2.35386
R17418 VSS.n7100 VSS.n6751 2.35386
R17419 VSS.n7104 VSS.n6749 2.35386
R17420 VSS.n7074 VSS.n6761 2.35386
R17421 VSS.n7079 VSS.n6760 2.35386
R17422 VSS.n7021 VSS.n6793 2.35386
R17423 VSS.n7026 VSS.n6792 2.35386
R17424 VSS.n6999 VSS.n6801 2.35386
R17425 VSS.n7003 VSS.n6799 2.35386
R17426 VSS.n6973 VSS.n6811 2.35386
R17427 VSS.n6978 VSS.n6810 2.35386
R17428 VSS.n7636 VSS.n7635 2.35386
R17429 VSS.n7631 VSS.n7630 2.35386
R17430 VSS.n7665 VSS.n62 2.35386
R17431 VSS.n7664 VSS.n7660 2.35386
R17432 VSS.n7684 VSS.n2529 2.35386
R17433 VSS.n7679 VSS.n2531 2.35386
R17434 VSS.n7705 VSS.n2518 2.35386
R17435 VSS.n7700 VSS.n2520 2.35386
R17436 VSS.n7770 VSS.n2498 2.35386
R17437 VSS.n7765 VSS.n7761 2.35386
R17438 VSS.n7790 VSS.n2487 2.35386
R17439 VSS.n7785 VSS.n2489 2.35386
R17440 VSS.n7811 VSS.n2476 2.35386
R17441 VSS.n7806 VSS.n2478 2.35386
R17442 VSS.n7876 VSS.n2456 2.35386
R17443 VSS.n7871 VSS.n7867 2.35386
R17444 VSS.n7896 VSS.n2445 2.35386
R17445 VSS.n7891 VSS.n2447 2.35386
R17446 VSS.n7917 VSS.n2434 2.35386
R17447 VSS.n7912 VSS.n2436 2.35386
R17448 VSS.n7982 VSS.n2414 2.35386
R17449 VSS.n7977 VSS.n7973 2.35386
R17450 VSS.n8002 VSS.n2403 2.35386
R17451 VSS.n7997 VSS.n2405 2.35386
R17452 VSS.n8023 VSS.n2392 2.35386
R17453 VSS.n8018 VSS.n2394 2.35386
R17454 VSS.n8088 VSS.n2372 2.35386
R17455 VSS.n8083 VSS.n8079 2.35386
R17456 VSS.n8108 VSS.n2361 2.35386
R17457 VSS.n8103 VSS.n2363 2.35386
R17458 VSS.n8129 VSS.n2350 2.35386
R17459 VSS.n8124 VSS.n2352 2.35386
R17460 VSS.n8194 VSS.n2330 2.35386
R17461 VSS.n8189 VSS.n8185 2.35386
R17462 VSS.n8214 VSS.n2319 2.35386
R17463 VSS.n8209 VSS.n2321 2.35386
R17464 VSS.n8235 VSS.n2308 2.35386
R17465 VSS.n8230 VSS.n2310 2.35386
R17466 VSS.n8679 VSS.n8678 2.35386
R17467 VSS.n8674 VSS.n8673 2.35386
R17468 VSS.n8708 VSS.n8707 2.35386
R17469 VSS.n8706 VSS.n8705 2.35386
R17470 VSS.n8722 VSS.n8621 2.35386
R17471 VSS.n8717 VSS.n8623 2.35386
R17472 VSS.n8743 VSS.n8610 2.35386
R17473 VSS.n8738 VSS.n8612 2.35386
R17474 VSS.n8808 VSS.n8590 2.35386
R17475 VSS.n8803 VSS.n8799 2.35386
R17476 VSS.n8828 VSS.n8579 2.35386
R17477 VSS.n8823 VSS.n8581 2.35386
R17478 VSS.n8849 VSS.n8568 2.35386
R17479 VSS.n8844 VSS.n8570 2.35386
R17480 VSS.n8914 VSS.n8548 2.35386
R17481 VSS.n8909 VSS.n8905 2.35386
R17482 VSS.n8934 VSS.n8537 2.35386
R17483 VSS.n8929 VSS.n8539 2.35386
R17484 VSS.n8955 VSS.n8526 2.35386
R17485 VSS.n8950 VSS.n8528 2.35386
R17486 VSS.n9020 VSS.n8506 2.35386
R17487 VSS.n9015 VSS.n9011 2.35386
R17488 VSS.n9040 VSS.n8495 2.35386
R17489 VSS.n9035 VSS.n8497 2.35386
R17490 VSS.n9061 VSS.n8484 2.35386
R17491 VSS.n9056 VSS.n8486 2.35386
R17492 VSS.n9126 VSS.n8464 2.35386
R17493 VSS.n9121 VSS.n9117 2.35386
R17494 VSS.n9146 VSS.n8453 2.35386
R17495 VSS.n9141 VSS.n8455 2.35386
R17496 VSS.n9167 VSS.n8442 2.35386
R17497 VSS.n9162 VSS.n8444 2.35386
R17498 VSS.n9232 VSS.n8422 2.35386
R17499 VSS.n9227 VSS.n9223 2.35386
R17500 VSS.n9252 VSS.n8411 2.35386
R17501 VSS.n9247 VSS.n8413 2.35386
R17502 VSS.n9273 VSS.n8400 2.35386
R17503 VSS.n9268 VSS.n8402 2.35386
R17504 VSS.n2239 VSS.n2220 2.35386
R17505 VSS.n2244 VSS.n2218 2.35386
R17506 VSS.n10028 VSS.n10027 2.35386
R17507 VSS.n10023 VSS.n10022 2.35386
R17508 VSS.n10057 VSS.n63 2.35386
R17509 VSS.n10056 VSS.n10052 2.35386
R17510 VSS.n9992 VSS.n9977 2.35386
R17511 VSS.n9987 VSS.n9979 2.35386
R17512 VSS.n9956 VSS.n1927 2.35386
R17513 VSS.n9961 VSS.n1926 2.35386
R17514 VSS.n9903 VSS.n1959 2.35386
R17515 VSS.n9908 VSS.n1958 2.35386
R17516 VSS.n9881 VSS.n1967 2.35386
R17517 VSS.n9885 VSS.n1965 2.35386
R17518 VSS.n9855 VSS.n1977 2.35386
R17519 VSS.n9860 VSS.n1976 2.35386
R17520 VSS.n9802 VSS.n2009 2.35386
R17521 VSS.n9807 VSS.n2008 2.35386
R17522 VSS.n9780 VSS.n2017 2.35386
R17523 VSS.n9784 VSS.n2015 2.35386
R17524 VSS.n9754 VSS.n2027 2.35386
R17525 VSS.n9759 VSS.n2026 2.35386
R17526 VSS.n9701 VSS.n2059 2.35386
R17527 VSS.n9706 VSS.n2058 2.35386
R17528 VSS.n9679 VSS.n2067 2.35386
R17529 VSS.n9683 VSS.n2065 2.35386
R17530 VSS.n9653 VSS.n2077 2.35386
R17531 VSS.n9658 VSS.n2076 2.35386
R17532 VSS.n9600 VSS.n2109 2.35386
R17533 VSS.n9605 VSS.n2108 2.35386
R17534 VSS.n9578 VSS.n2117 2.35386
R17535 VSS.n9582 VSS.n2115 2.35386
R17536 VSS.n9552 VSS.n2127 2.35386
R17537 VSS.n9557 VSS.n2126 2.35386
R17538 VSS.n9499 VSS.n2159 2.35386
R17539 VSS.n9504 VSS.n2158 2.35386
R17540 VSS.n9477 VSS.n2167 2.35386
R17541 VSS.n9481 VSS.n2165 2.35386
R17542 VSS.n9451 VSS.n2177 2.35386
R17543 VSS.n9456 VSS.n2176 2.35386
R17544 VSS.n11070 VSS.n11069 2.35386
R17545 VSS.n11065 VSS.n11064 2.35386
R17546 VSS.n11099 VSS.n64 2.35386
R17547 VSS.n11098 VSS.n11094 2.35386
R17548 VSS.n11034 VSS.n11019 2.35386
R17549 VSS.n11029 VSS.n11021 2.35386
R17550 VSS.n10998 VSS.n10081 2.35386
R17551 VSS.n11003 VSS.n10080 2.35386
R17552 VSS.n10945 VSS.n10113 2.35386
R17553 VSS.n10950 VSS.n10112 2.35386
R17554 VSS.n10923 VSS.n10121 2.35386
R17555 VSS.n10927 VSS.n10119 2.35386
R17556 VSS.n10897 VSS.n10131 2.35386
R17557 VSS.n10902 VSS.n10130 2.35386
R17558 VSS.n10844 VSS.n10163 2.35386
R17559 VSS.n10849 VSS.n10162 2.35386
R17560 VSS.n10822 VSS.n10171 2.35386
R17561 VSS.n10826 VSS.n10169 2.35386
R17562 VSS.n10796 VSS.n10181 2.35386
R17563 VSS.n10801 VSS.n10180 2.35386
R17564 VSS.n10743 VSS.n10213 2.35386
R17565 VSS.n10748 VSS.n10212 2.35386
R17566 VSS.n10721 VSS.n10221 2.35386
R17567 VSS.n10725 VSS.n10219 2.35386
R17568 VSS.n10695 VSS.n10231 2.35386
R17569 VSS.n10700 VSS.n10230 2.35386
R17570 VSS.n10642 VSS.n10263 2.35386
R17571 VSS.n10647 VSS.n10262 2.35386
R17572 VSS.n10620 VSS.n10271 2.35386
R17573 VSS.n10624 VSS.n10269 2.35386
R17574 VSS.n10594 VSS.n10281 2.35386
R17575 VSS.n10599 VSS.n10280 2.35386
R17576 VSS.n10541 VSS.n10313 2.35386
R17577 VSS.n10546 VSS.n10312 2.35386
R17578 VSS.n10519 VSS.n10321 2.35386
R17579 VSS.n10523 VSS.n10319 2.35386
R17580 VSS.n10493 VSS.n10331 2.35386
R17581 VSS.n10498 VSS.n10330 2.35386
R17582 VSS.n11156 VSS.n11155 2.35386
R17583 VSS.n11151 VSS.n11150 2.35386
R17584 VSS.n11185 VSS.n65 2.35386
R17585 VSS.n11184 VSS.n11180 2.35386
R17586 VSS.n11204 VSS.n1907 2.35386
R17587 VSS.n11199 VSS.n1909 2.35386
R17588 VSS.n11225 VSS.n1896 2.35386
R17589 VSS.n11220 VSS.n1898 2.35386
R17590 VSS.n11290 VSS.n1876 2.35386
R17591 VSS.n11285 VSS.n11281 2.35386
R17592 VSS.n11310 VSS.n1865 2.35386
R17593 VSS.n11305 VSS.n1867 2.35386
R17594 VSS.n11331 VSS.n1854 2.35386
R17595 VSS.n11326 VSS.n1856 2.35386
R17596 VSS.n11396 VSS.n1834 2.35386
R17597 VSS.n11391 VSS.n11387 2.35386
R17598 VSS.n11416 VSS.n1823 2.35386
R17599 VSS.n11411 VSS.n1825 2.35386
R17600 VSS.n11437 VSS.n1812 2.35386
R17601 VSS.n11432 VSS.n1814 2.35386
R17602 VSS.n11502 VSS.n1792 2.35386
R17603 VSS.n11497 VSS.n11493 2.35386
R17604 VSS.n11522 VSS.n1781 2.35386
R17605 VSS.n11517 VSS.n1783 2.35386
R17606 VSS.n11543 VSS.n1770 2.35386
R17607 VSS.n11538 VSS.n1772 2.35386
R17608 VSS.n11608 VSS.n1750 2.35386
R17609 VSS.n11603 VSS.n11599 2.35386
R17610 VSS.n11628 VSS.n1739 2.35386
R17611 VSS.n11623 VSS.n1741 2.35386
R17612 VSS.n11649 VSS.n1728 2.35386
R17613 VSS.n11644 VSS.n1730 2.35386
R17614 VSS.n11714 VSS.n1708 2.35386
R17615 VSS.n11709 VSS.n11705 2.35386
R17616 VSS.n11734 VSS.n1697 2.35386
R17617 VSS.n11729 VSS.n1699 2.35386
R17618 VSS.n11755 VSS.n1686 2.35386
R17619 VSS.n11750 VSS.n1688 2.35386
R17620 VSS.n12199 VSS.n12198 2.35386
R17621 VSS.n12194 VSS.n12193 2.35386
R17622 VSS.n12228 VSS.n12227 2.35386
R17623 VSS.n12226 VSS.n12225 2.35386
R17624 VSS.n12242 VSS.n12141 2.35386
R17625 VSS.n12237 VSS.n12143 2.35386
R17626 VSS.n12263 VSS.n12130 2.35386
R17627 VSS.n12258 VSS.n12132 2.35386
R17628 VSS.n12328 VSS.n12110 2.35386
R17629 VSS.n12323 VSS.n12319 2.35386
R17630 VSS.n12348 VSS.n12099 2.35386
R17631 VSS.n12343 VSS.n12101 2.35386
R17632 VSS.n12369 VSS.n12088 2.35386
R17633 VSS.n12364 VSS.n12090 2.35386
R17634 VSS.n12434 VSS.n12068 2.35386
R17635 VSS.n12429 VSS.n12425 2.35386
R17636 VSS.n12454 VSS.n12057 2.35386
R17637 VSS.n12449 VSS.n12059 2.35386
R17638 VSS.n12475 VSS.n12046 2.35386
R17639 VSS.n12470 VSS.n12048 2.35386
R17640 VSS.n12540 VSS.n12026 2.35386
R17641 VSS.n12535 VSS.n12531 2.35386
R17642 VSS.n12560 VSS.n12015 2.35386
R17643 VSS.n12555 VSS.n12017 2.35386
R17644 VSS.n12581 VSS.n12004 2.35386
R17645 VSS.n12576 VSS.n12006 2.35386
R17646 VSS.n12646 VSS.n11984 2.35386
R17647 VSS.n12641 VSS.n12637 2.35386
R17648 VSS.n12666 VSS.n11973 2.35386
R17649 VSS.n12661 VSS.n11975 2.35386
R17650 VSS.n12687 VSS.n11962 2.35386
R17651 VSS.n12682 VSS.n11964 2.35386
R17652 VSS.n12752 VSS.n11942 2.35386
R17653 VSS.n12747 VSS.n12743 2.35386
R17654 VSS.n12772 VSS.n11931 2.35386
R17655 VSS.n12767 VSS.n11933 2.35386
R17656 VSS.n12793 VSS.n11920 2.35386
R17657 VSS.n12788 VSS.n11922 2.35386
R17658 VSS.n13548 VSS.n13547 2.35386
R17659 VSS.n13543 VSS.n13542 2.35386
R17660 VSS.n13577 VSS.n66 2.35386
R17661 VSS.n13576 VSS.n13572 2.35386
R17662 VSS.n13512 VSS.n13497 2.35386
R17663 VSS.n13507 VSS.n13499 2.35386
R17664 VSS.n13476 VSS.n1286 2.35386
R17665 VSS.n13481 VSS.n1285 2.35386
R17666 VSS.n13423 VSS.n1318 2.35386
R17667 VSS.n13428 VSS.n1317 2.35386
R17668 VSS.n13401 VSS.n1326 2.35386
R17669 VSS.n13405 VSS.n1324 2.35386
R17670 VSS.n13375 VSS.n1336 2.35386
R17671 VSS.n13380 VSS.n1335 2.35386
R17672 VSS.n13322 VSS.n1368 2.35386
R17673 VSS.n13327 VSS.n1367 2.35386
R17674 VSS.n13300 VSS.n1376 2.35386
R17675 VSS.n13304 VSS.n1374 2.35386
R17676 VSS.n13274 VSS.n1386 2.35386
R17677 VSS.n13279 VSS.n1385 2.35386
R17678 VSS.n13221 VSS.n1418 2.35386
R17679 VSS.n13226 VSS.n1417 2.35386
R17680 VSS.n13199 VSS.n1426 2.35386
R17681 VSS.n13203 VSS.n1424 2.35386
R17682 VSS.n13173 VSS.n1436 2.35386
R17683 VSS.n13178 VSS.n1435 2.35386
R17684 VSS.n13120 VSS.n1468 2.35386
R17685 VSS.n13125 VSS.n1467 2.35386
R17686 VSS.n13098 VSS.n1476 2.35386
R17687 VSS.n13102 VSS.n1474 2.35386
R17688 VSS.n13072 VSS.n1486 2.35386
R17689 VSS.n13077 VSS.n1485 2.35386
R17690 VSS.n13019 VSS.n1518 2.35386
R17691 VSS.n13024 VSS.n1517 2.35386
R17692 VSS.n12997 VSS.n1526 2.35386
R17693 VSS.n13001 VSS.n1524 2.35386
R17694 VSS.n12971 VSS.n1536 2.35386
R17695 VSS.n12976 VSS.n1535 2.35386
R17696 VSS.n14513 VSS.n14512 2.35386
R17697 VSS.n14508 VSS.n14507 2.35386
R17698 VSS.n14542 VSS.n67 2.35386
R17699 VSS.n14541 VSS.n14537 2.35386
R17700 VSS.n14477 VSS.n14462 2.35386
R17701 VSS.n14472 VSS.n14464 2.35386
R17702 VSS.n14441 VSS.n13601 2.35386
R17703 VSS.n14446 VSS.n13600 2.35386
R17704 VSS.n14388 VSS.n13633 2.35386
R17705 VSS.n14393 VSS.n13632 2.35386
R17706 VSS.n14366 VSS.n13641 2.35386
R17707 VSS.n14370 VSS.n13639 2.35386
R17708 VSS.n14350 VSS.n13650 2.35386
R17709 VSS.n14272 VSS.n13717 2.35386
R17710 VSS.t601 VSS.n13715 2.35386
R17711 VSS.n14222 VSS.n13735 2.35386
R17712 VSS.n14227 VSS.n13734 2.35386
R17713 VSS.n14196 VSS.n14150 2.35386
R17714 VSS.n14191 VSS.n14152 2.35386
R17715 VSS.n14129 VSS.n13750 2.35386
R17716 VSS.n14134 VSS.n13749 2.35386
R17717 VSS.n14107 VSS.n13758 2.35386
R17718 VSS.n14111 VSS.n13756 2.35386
R17719 VSS.n14081 VSS.n13768 2.35386
R17720 VSS.n14086 VSS.n13767 2.35386
R17721 VSS.n14028 VSS.n13800 2.35386
R17722 VSS.n14033 VSS.n13799 2.35386
R17723 VSS.n14006 VSS.n13808 2.35386
R17724 VSS.n14010 VSS.n13806 2.35386
R17725 VSS.n13980 VSS.n13818 2.35386
R17726 VSS.n13985 VSS.n13817 2.35386
R17727 VSS.n14596 VSS.n14595 2.35386
R17728 VSS.n14591 VSS.n14590 2.35386
R17729 VSS.n14625 VSS.n68 2.35386
R17730 VSS.n14624 VSS.n14620 2.35386
R17731 VSS.n14644 VSS.n455 2.35386
R17732 VSS.n14639 VSS.n457 2.35386
R17733 VSS.n14665 VSS.n444 2.35386
R17734 VSS.n14660 VSS.n446 2.35386
R17735 VSS.n13655 VSS.n13653 2.32379
R17736 VSS.n14901 VSS.n14900 2.32379
R17737 VSS.n13674 VSS.n13673 2.31412
R17738 VSS.n13697 VSS.n13696 2.31412
R17739 VSS.t610 VSS.n14346 2.29383
R17740 VSS.n14287 VSS.t183 2.25932
R17741 VSS.t121 VSS.n14242 2.25932
R17742 VSS.n58 VSS.t251 7.32134
R17743 VSS.t113 VSS.n14752 2.25932
R17744 VSS.n15024 VSS.t57 2.25932
R17745 VSS.n3782 VSS.n3781 2.25312
R17746 VSS.n3795 VSS.n3794 2.25312
R17747 VSS.n3886 VSS.n3693 2.25312
R17748 VSS.n3987 VSS.n3643 2.25312
R17749 VSS.n4088 VSS.n3593 2.25312
R17750 VSS.n4189 VSS.n3543 2.25312
R17751 VSS.n4290 VSS.n3493 2.25312
R17752 VSS.n5871 VSS.n4848 2.25312
R17753 VSS.n5720 VSS.n4895 2.25312
R17754 VSS.n5614 VSS.n4937 2.25312
R17755 VSS.n5508 VSS.n4979 2.25312
R17756 VSS.n5402 VSS.n5021 2.25312
R17757 VSS.n5296 VSS.n5063 2.25312
R17758 VSS.n4837 VSS.n4836 2.25312
R17759 VSS.n5967 VSS.n4716 2.25312
R17760 VSS.n6068 VSS.n4666 2.25312
R17761 VSS.n6169 VSS.n4616 2.25312
R17762 VSS.n6270 VSS.n4566 2.25312
R17763 VSS.n6371 VSS.n4516 2.25312
R17764 VSS.n6918 VSS.n6917 2.25312
R17765 VSS.n7009 VSS.n6797 2.25312
R17766 VSS.n7110 VSS.n6747 2.25312
R17767 VSS.n7211 VSS.n6697 2.25312
R17768 VSS.n7312 VSS.n6647 2.25312
R17769 VSS.n7413 VSS.n6597 2.25312
R17770 VSS.n8353 VSS.n2276 2.25312
R17771 VSS.n8202 VSS.n2323 2.25312
R17772 VSS.n8096 VSS.n2365 2.25312
R17773 VSS.n7990 VSS.n2407 2.25312
R17774 VSS.n7884 VSS.n2449 2.25312
R17775 VSS.n7778 VSS.n2491 2.25312
R17776 VSS.n9391 VSS.n8368 2.25312
R17777 VSS.n9240 VSS.n8415 2.25312
R17778 VSS.n9134 VSS.n8457 2.25312
R17779 VSS.n9028 VSS.n8499 2.25312
R17780 VSS.n8922 VSS.n8541 2.25312
R17781 VSS.n8816 VSS.n8583 2.25312
R17782 VSS.n2252 VSS.n2251 2.25312
R17783 VSS.n2265 VSS.n2264 2.25312
R17784 VSS.n9487 VSS.n2163 2.25312
R17785 VSS.n9588 VSS.n2113 2.25312
R17786 VSS.n9689 VSS.n2063 2.25312
R17787 VSS.n9790 VSS.n2013 2.25312
R17788 VSS.n9891 VSS.n1963 2.25312
R17789 VSS.n10438 VSS.n10437 2.25312
R17790 VSS.n10529 VSS.n10317 2.25312
R17791 VSS.n10630 VSS.n10267 2.25312
R17792 VSS.n10731 VSS.n10217 2.25312
R17793 VSS.n10832 VSS.n10167 2.25312
R17794 VSS.n10933 VSS.n10117 2.25312
R17795 VSS.n11873 VSS.n1654 2.25312
R17796 VSS.n11722 VSS.n1701 2.25312
R17797 VSS.n11616 VSS.n1743 2.25312
R17798 VSS.n11510 VSS.n1785 2.25312
R17799 VSS.n11404 VSS.n1827 2.25312
R17800 VSS.n11298 VSS.n1869 2.25312
R17801 VSS.n12911 VSS.n11888 2.25312
R17802 VSS.n12760 VSS.n11935 2.25312
R17803 VSS.n12654 VSS.n11977 2.25312
R17804 VSS.n12548 VSS.n12019 2.25312
R17805 VSS.n12442 VSS.n12061 2.25312
R17806 VSS.n12336 VSS.n12103 2.25312
R17807 VSS.n1643 VSS.n1642 2.25312
R17808 VSS.n13007 VSS.n1522 2.25312
R17809 VSS.n13108 VSS.n1472 2.25312
R17810 VSS.n13209 VSS.n1422 2.25312
R17811 VSS.n13310 VSS.n1372 2.25312
R17812 VSS.n13411 VSS.n1322 2.25312
R17813 VSS.n13925 VSS.n13924 2.25312
R17814 VSS.n14016 VSS.n13804 2.25312
R17815 VSS.n14117 VSS.n13754 2.25312
R17816 VSS.n14376 VSS.n13637 2.25312
R17817 VSS.t409 VSS.n15003 2.25293
R17818 VSS.n3733 VSS.t3015 2.14815
R17819 VSS.n4854 VSS.t2797 2.14815
R17820 VSS.n4756 VSS.t2582 2.14815
R17821 VSS.n6837 VSS.t2367 2.14815
R17822 VSS.n2282 VSS.t2152 2.14815
R17823 VSS.n8374 VSS.t1937 2.14815
R17824 VSS.n2203 VSS.t1722 2.14815
R17825 VSS.n10357 VSS.t1504 2.14815
R17826 VSS.n1660 VSS.t1289 2.14815
R17827 VSS.n11894 VSS.t1074 2.14815
R17828 VSS.n1562 VSS.t859 2.14815
R17829 VSS.n13844 VSS.t649 2.14815
R17830 VSS.n5828 VSS.n5827 2.14159
R17831 VSS.n5851 VSS.n5850 2.14159
R17832 VSS.n4794 VSS.n4791 2.14159
R17833 VSS.n4816 VSS.n4777 2.14159
R17834 VSS.n6875 VSS.n6872 2.14159
R17835 VSS.n6897 VSS.n6858 2.14159
R17836 VSS.n8310 VSS.n8309 2.14159
R17837 VSS.n8333 VSS.n8332 2.14159
R17838 VSS.n9348 VSS.n9347 2.14159
R17839 VSS.n9371 VSS.n9370 2.14159
R17840 VSS.n10395 VSS.n10392 2.14159
R17841 VSS.n10417 VSS.n10378 2.14159
R17842 VSS.n11830 VSS.n11829 2.14159
R17843 VSS.n11853 VSS.n11852 2.14159
R17844 VSS.n12868 VSS.n12867 2.14159
R17845 VSS.n12891 VSS.n12890 2.14159
R17846 VSS.n1600 VSS.n1597 2.14159
R17847 VSS.n1622 VSS.n1583 2.14159
R17848 VSS.n13882 VSS.n13879 2.14159
R17849 VSS.n13904 VSS.n13865 2.14159
R17850 VSS.n15178 VSS.n15175 2.14159
R17851 VSS.n15200 VSS.n15161 2.14159
R17852 VSS.n14970 VSS.n328 2.14159
R17853 VSS.n14999 VSS.n320 2.14159
R17854 VSS.n4343 VSS.t3094 2.06077
R17855 VSS.n4242 VSS.t3079 2.06077
R17856 VSS.n4141 VSS.t3064 2.06077
R17857 VSS.n4040 VSS.t3049 2.06077
R17858 VSS.n3939 VSS.t3034 2.06077
R17859 VSS.n3838 VSS.t3019 2.06077
R17860 VSS.t2876 VSS.n5084 2.06077
R17861 VSS.t2861 VSS.n5042 2.06077
R17862 VSS.t2846 VSS.n5000 2.06077
R17863 VSS.t2831 VSS.n4958 2.06077
R17864 VSS.t2816 VSS.n4916 2.06077
R17865 VSS.t2801 VSS.n4874 2.06077
R17866 VSS.n6424 VSS.t2661 2.06077
R17867 VSS.n6323 VSS.t2646 2.06077
R17868 VSS.n6222 VSS.t2631 2.06077
R17869 VSS.n6121 VSS.t2616 2.06077
R17870 VSS.n6020 VSS.t2601 2.06077
R17871 VSS.n5919 VSS.t2586 2.06077
R17872 VSS.n7466 VSS.t2446 2.06077
R17873 VSS.n7365 VSS.t2431 2.06077
R17874 VSS.n7264 VSS.t2416 2.06077
R17875 VSS.n7163 VSS.t2401 2.06077
R17876 VSS.n7062 VSS.t2386 2.06077
R17877 VSS.n6961 VSS.t2371 2.06077
R17878 VSS.t2231 VSS.n2512 2.06077
R17879 VSS.t2216 VSS.n2470 2.06077
R17880 VSS.t2201 VSS.n2428 2.06077
R17881 VSS.t2186 VSS.n2386 2.06077
R17882 VSS.t2171 VSS.n2344 2.06077
R17883 VSS.t2156 VSS.n2302 2.06077
R17884 VSS.t2016 VSS.n8604 2.06077
R17885 VSS.t2001 VSS.n8562 2.06077
R17886 VSS.t1986 VSS.n8520 2.06077
R17887 VSS.t1971 VSS.n8478 2.06077
R17888 VSS.t1956 VSS.n8436 2.06077
R17889 VSS.t1941 VSS.n8394 2.06077
R17890 VSS.n9944 VSS.t1801 2.06077
R17891 VSS.n9843 VSS.t1786 2.06077
R17892 VSS.n9742 VSS.t1771 2.06077
R17893 VSS.n9641 VSS.t1756 2.06077
R17894 VSS.n9540 VSS.t1741 2.06077
R17895 VSS.n9439 VSS.t1726 2.06077
R17896 VSS.n10986 VSS.t1583 2.06077
R17897 VSS.n10885 VSS.t1568 2.06077
R17898 VSS.n10784 VSS.t1553 2.06077
R17899 VSS.n10683 VSS.t1538 2.06077
R17900 VSS.n10582 VSS.t1523 2.06077
R17901 VSS.n10481 VSS.t1508 2.06077
R17902 VSS.t1368 VSS.n1890 2.06077
R17903 VSS.t1353 VSS.n1848 2.06077
R17904 VSS.t1338 VSS.n1806 2.06077
R17905 VSS.t1323 VSS.n1764 2.06077
R17906 VSS.t1308 VSS.n1722 2.06077
R17907 VSS.t1293 VSS.n1680 2.06077
R17908 VSS.t1153 VSS.n12124 2.06077
R17909 VSS.t1138 VSS.n12082 2.06077
R17910 VSS.t1123 VSS.n12040 2.06077
R17911 VSS.t1108 VSS.n11998 2.06077
R17912 VSS.t1093 VSS.n11956 2.06077
R17913 VSS.t1078 VSS.n11914 2.06077
R17914 VSS.n13464 VSS.t938 2.06077
R17915 VSS.n13363 VSS.t923 2.06077
R17916 VSS.n13262 VSS.t908 2.06077
R17917 VSS.n13161 VSS.t893 2.06077
R17918 VSS.n13060 VSS.t878 2.06077
R17919 VSS.n12959 VSS.t863 2.06077
R17920 VSS.n14429 VSS.t723 2.06077
R17921 VSS.n14069 VSS.t668 2.06077
R17922 VSS.n13968 VSS.t653 2.06077
R17923 VSS.t528 VSS.n438 2.06077
R17924 VSS.t3358 VSS.n14937 2.06077
R17925 VSS.t165 VSS.n14926 2.04305
R17926 VSS.n14923 VSS.t162 2.02075
R17927 VSS.n15305 VSS.n15288 2.01694
R17928 VSS.n15306 VSS.n15305 2.01694
R17929 VSS.n15327 VSS.n15278 2.01694
R17930 VSS.n15328 VSS.n15327 2.01694
R17931 VSS.n509 VSS.n508 2.01694
R17932 VSS.n509 VSS.n55 2.01694
R17933 VSS.n1268 VSS.n460 2.01694
R17934 VSS.n1269 VSS.n1268 2.01694
R17935 VSS.n1237 VSS.n1207 2.01694
R17936 VSS.n1234 VSS.n1207 2.01694
R17937 VSS.n1180 VSS.n1179 2.01694
R17938 VSS.n1180 VSS.n532 2.01694
R17939 VSS.n1157 VSS.n1156 2.01694
R17940 VSS.n1157 VSS.n541 2.01694
R17941 VSS.n1068 VSS.n1045 2.01694
R17942 VSS.n1069 VSS.n1068 2.01694
R17943 VSS.n1096 VSS.n1038 2.01694
R17944 VSS.n1093 VSS.n1038 2.01694
R17945 VSS.n1020 VSS.n1019 2.01694
R17946 VSS.n1020 VSS.n564 2.01694
R17947 VSS.n953 VSS.n931 2.01694
R17948 VSS.n954 VSS.n953 2.01694
R17949 VSS.n981 VSS.n924 2.01694
R17950 VSS.n978 VSS.n924 2.01694
R17951 VSS.n841 VSS.n818 2.01694
R17952 VSS.n842 VSS.n841 2.01694
R17953 VSS.n869 VSS.n811 2.01694
R17954 VSS.n866 VSS.n811 2.01694
R17955 VSS.n770 VSS.n769 2.01694
R17956 VSS.n770 VSS.n605 2.01694
R17957 VSS.n741 VSS.n740 2.01694
R17958 VSS.n741 VSS.n616 2.01694
R17959 VSS.n718 VSS.n717 2.01694
R17960 VSS.n718 VSS.n625 2.01694
R17961 VSS.n652 VSS.n651 2.01694
R17962 VSS.n652 VSS.n84 2.01694
R17963 VSS.n15247 VSS.n300 2.01694
R17964 VSS.n15244 VSS.n300 2.01694
R17965 VSS.n4434 VSS.n4398 2.01694
R17966 VSS.n4435 VSS.n4434 2.01694
R17967 VSS.n4347 VSS.n4346 2.01694
R17968 VSS.n4347 VSS.n3463 2.01694
R17969 VSS.n4324 VSS.n3473 2.01694
R17970 VSS.n4327 VSS.n3473 2.01694
R17971 VSS.n4246 VSS.n4245 2.01694
R17972 VSS.n4246 VSS.n3513 2.01694
R17973 VSS.n4223 VSS.n3523 2.01694
R17974 VSS.n4226 VSS.n3523 2.01694
R17975 VSS.n4145 VSS.n4144 2.01694
R17976 VSS.n4145 VSS.n3563 2.01694
R17977 VSS.n4122 VSS.n3573 2.01694
R17978 VSS.n4125 VSS.n3573 2.01694
R17979 VSS.n4044 VSS.n4043 2.01694
R17980 VSS.n4044 VSS.n3613 2.01694
R17981 VSS.n4021 VSS.n3623 2.01694
R17982 VSS.n4024 VSS.n3623 2.01694
R17983 VSS.n3943 VSS.n3942 2.01694
R17984 VSS.n3943 VSS.n3663 2.01694
R17985 VSS.n3920 VSS.n3673 2.01694
R17986 VSS.n3923 VSS.n3673 2.01694
R17987 VSS.n3842 VSS.n3841 2.01694
R17988 VSS.n3842 VSS.n3713 2.01694
R17989 VSS.n3819 VSS.n3723 2.01694
R17990 VSS.n3822 VSS.n3723 2.01694
R17991 VSS.n5166 VSS.n5130 2.01694
R17992 VSS.n5167 VSS.n5166 2.01694
R17993 VSS.n5237 VSS.n5087 2.01694
R17994 VSS.n5229 VSS.n5087 2.01694
R17995 VSS.n5258 VSS.n5078 2.01694
R17996 VSS.n5259 VSS.n5258 2.01694
R17997 VSS.n5343 VSS.n5045 2.01694
R17998 VSS.n5335 VSS.n5045 2.01694
R17999 VSS.n5364 VSS.n5036 2.01694
R18000 VSS.n5365 VSS.n5364 2.01694
R18001 VSS.n5449 VSS.n5003 2.01694
R18002 VSS.n5441 VSS.n5003 2.01694
R18003 VSS.n5470 VSS.n4994 2.01694
R18004 VSS.n5471 VSS.n5470 2.01694
R18005 VSS.n5555 VSS.n4961 2.01694
R18006 VSS.n5547 VSS.n4961 2.01694
R18007 VSS.n5576 VSS.n4952 2.01694
R18008 VSS.n5577 VSS.n5576 2.01694
R18009 VSS.n5661 VSS.n4919 2.01694
R18010 VSS.n5653 VSS.n4919 2.01694
R18011 VSS.n5682 VSS.n4910 2.01694
R18012 VSS.n5683 VSS.n5682 2.01694
R18013 VSS.n5767 VSS.n4877 2.01694
R18014 VSS.n5759 VSS.n4877 2.01694
R18015 VSS.n5796 VSS.n4849 2.01694
R18016 VSS.n4869 VSS.n4849 2.01694
R18017 VSS.n6515 VSS.n6479 2.01694
R18018 VSS.n6516 VSS.n6515 2.01694
R18019 VSS.n6428 VSS.n6427 2.01694
R18020 VSS.n6428 VSS.n4486 2.01694
R18021 VSS.n6405 VSS.n4496 2.01694
R18022 VSS.n6408 VSS.n4496 2.01694
R18023 VSS.n6327 VSS.n6326 2.01694
R18024 VSS.n6327 VSS.n4536 2.01694
R18025 VSS.n6304 VSS.n4546 2.01694
R18026 VSS.n6307 VSS.n4546 2.01694
R18027 VSS.n6226 VSS.n6225 2.01694
R18028 VSS.n6226 VSS.n4586 2.01694
R18029 VSS.n6203 VSS.n4596 2.01694
R18030 VSS.n6206 VSS.n4596 2.01694
R18031 VSS.n6125 VSS.n6124 2.01694
R18032 VSS.n6125 VSS.n4636 2.01694
R18033 VSS.n6102 VSS.n4646 2.01694
R18034 VSS.n6105 VSS.n4646 2.01694
R18035 VSS.n6024 VSS.n6023 2.01694
R18036 VSS.n6024 VSS.n4686 2.01694
R18037 VSS.n6001 VSS.n4696 2.01694
R18038 VSS.n6004 VSS.n4696 2.01694
R18039 VSS.n5923 VSS.n5922 2.01694
R18040 VSS.n5923 VSS.n4736 2.01694
R18041 VSS.n5900 VSS.n4746 2.01694
R18042 VSS.n5903 VSS.n4746 2.01694
R18043 VSS.n7557 VSS.n7521 2.01694
R18044 VSS.n7558 VSS.n7557 2.01694
R18045 VSS.n7470 VSS.n7469 2.01694
R18046 VSS.n7470 VSS.n6567 2.01694
R18047 VSS.n7447 VSS.n6577 2.01694
R18048 VSS.n7450 VSS.n6577 2.01694
R18049 VSS.n7369 VSS.n7368 2.01694
R18050 VSS.n7369 VSS.n6617 2.01694
R18051 VSS.n7346 VSS.n6627 2.01694
R18052 VSS.n7349 VSS.n6627 2.01694
R18053 VSS.n7268 VSS.n7267 2.01694
R18054 VSS.n7268 VSS.n6667 2.01694
R18055 VSS.n7245 VSS.n6677 2.01694
R18056 VSS.n7248 VSS.n6677 2.01694
R18057 VSS.n7167 VSS.n7166 2.01694
R18058 VSS.n7167 VSS.n6717 2.01694
R18059 VSS.n7144 VSS.n6727 2.01694
R18060 VSS.n7147 VSS.n6727 2.01694
R18061 VSS.n7066 VSS.n7065 2.01694
R18062 VSS.n7066 VSS.n6767 2.01694
R18063 VSS.n7043 VSS.n6777 2.01694
R18064 VSS.n7046 VSS.n6777 2.01694
R18065 VSS.n6965 VSS.n6964 2.01694
R18066 VSS.n6965 VSS.n6817 2.01694
R18067 VSS.n6942 VSS.n6827 2.01694
R18068 VSS.n6945 VSS.n6827 2.01694
R18069 VSS.n7643 VSS.n7607 2.01694
R18070 VSS.n7644 VSS.n7643 2.01694
R18071 VSS.n7719 VSS.n2515 2.01694
R18072 VSS.n7711 VSS.n2515 2.01694
R18073 VSS.n7740 VSS.n2506 2.01694
R18074 VSS.n7741 VSS.n7740 2.01694
R18075 VSS.n7825 VSS.n2473 2.01694
R18076 VSS.n7817 VSS.n2473 2.01694
R18077 VSS.n7846 VSS.n2464 2.01694
R18078 VSS.n7847 VSS.n7846 2.01694
R18079 VSS.n7931 VSS.n2431 2.01694
R18080 VSS.n7923 VSS.n2431 2.01694
R18081 VSS.n7952 VSS.n2422 2.01694
R18082 VSS.n7953 VSS.n7952 2.01694
R18083 VSS.n8037 VSS.n2389 2.01694
R18084 VSS.n8029 VSS.n2389 2.01694
R18085 VSS.n8058 VSS.n2380 2.01694
R18086 VSS.n8059 VSS.n8058 2.01694
R18087 VSS.n8143 VSS.n2347 2.01694
R18088 VSS.n8135 VSS.n2347 2.01694
R18089 VSS.n8164 VSS.n2338 2.01694
R18090 VSS.n8165 VSS.n8164 2.01694
R18091 VSS.n8249 VSS.n2305 2.01694
R18092 VSS.n8241 VSS.n2305 2.01694
R18093 VSS.n8278 VSS.n2277 2.01694
R18094 VSS.n2297 VSS.n2277 2.01694
R18095 VSS.n8686 VSS.n8650 2.01694
R18096 VSS.n8687 VSS.n8686 2.01694
R18097 VSS.n8757 VSS.n8607 2.01694
R18098 VSS.n8749 VSS.n8607 2.01694
R18099 VSS.n8778 VSS.n8598 2.01694
R18100 VSS.n8779 VSS.n8778 2.01694
R18101 VSS.n8863 VSS.n8565 2.01694
R18102 VSS.n8855 VSS.n8565 2.01694
R18103 VSS.n8884 VSS.n8556 2.01694
R18104 VSS.n8885 VSS.n8884 2.01694
R18105 VSS.n8969 VSS.n8523 2.01694
R18106 VSS.n8961 VSS.n8523 2.01694
R18107 VSS.n8990 VSS.n8514 2.01694
R18108 VSS.n8991 VSS.n8990 2.01694
R18109 VSS.n9075 VSS.n8481 2.01694
R18110 VSS.n9067 VSS.n8481 2.01694
R18111 VSS.n9096 VSS.n8472 2.01694
R18112 VSS.n9097 VSS.n9096 2.01694
R18113 VSS.n9181 VSS.n8439 2.01694
R18114 VSS.n9173 VSS.n8439 2.01694
R18115 VSS.n9202 VSS.n8430 2.01694
R18116 VSS.n9203 VSS.n9202 2.01694
R18117 VSS.n9287 VSS.n8397 2.01694
R18118 VSS.n9279 VSS.n8397 2.01694
R18119 VSS.n9316 VSS.n8369 2.01694
R18120 VSS.n8389 VSS.n8369 2.01694
R18121 VSS.n10035 VSS.n9999 2.01694
R18122 VSS.n10036 VSS.n10035 2.01694
R18123 VSS.n9948 VSS.n9947 2.01694
R18124 VSS.n9948 VSS.n1933 2.01694
R18125 VSS.n9925 VSS.n1943 2.01694
R18126 VSS.n9928 VSS.n1943 2.01694
R18127 VSS.n9847 VSS.n9846 2.01694
R18128 VSS.n9847 VSS.n1983 2.01694
R18129 VSS.n9824 VSS.n1993 2.01694
R18130 VSS.n9827 VSS.n1993 2.01694
R18131 VSS.n9746 VSS.n9745 2.01694
R18132 VSS.n9746 VSS.n2033 2.01694
R18133 VSS.n9723 VSS.n2043 2.01694
R18134 VSS.n9726 VSS.n2043 2.01694
R18135 VSS.n9645 VSS.n9644 2.01694
R18136 VSS.n9645 VSS.n2083 2.01694
R18137 VSS.n9622 VSS.n2093 2.01694
R18138 VSS.n9625 VSS.n2093 2.01694
R18139 VSS.n9544 VSS.n9543 2.01694
R18140 VSS.n9544 VSS.n2133 2.01694
R18141 VSS.n9521 VSS.n2143 2.01694
R18142 VSS.n9524 VSS.n2143 2.01694
R18143 VSS.n9443 VSS.n9442 2.01694
R18144 VSS.n9443 VSS.n2183 2.01694
R18145 VSS.n9420 VSS.n2193 2.01694
R18146 VSS.n9423 VSS.n2193 2.01694
R18147 VSS.n11077 VSS.n11041 2.01694
R18148 VSS.n11078 VSS.n11077 2.01694
R18149 VSS.n10990 VSS.n10989 2.01694
R18150 VSS.n10990 VSS.n10087 2.01694
R18151 VSS.n10967 VSS.n10097 2.01694
R18152 VSS.n10970 VSS.n10097 2.01694
R18153 VSS.n10889 VSS.n10888 2.01694
R18154 VSS.n10889 VSS.n10137 2.01694
R18155 VSS.n10866 VSS.n10147 2.01694
R18156 VSS.n10869 VSS.n10147 2.01694
R18157 VSS.n10788 VSS.n10787 2.01694
R18158 VSS.n10788 VSS.n10187 2.01694
R18159 VSS.n10765 VSS.n10197 2.01694
R18160 VSS.n10768 VSS.n10197 2.01694
R18161 VSS.n10687 VSS.n10686 2.01694
R18162 VSS.n10687 VSS.n10237 2.01694
R18163 VSS.n10664 VSS.n10247 2.01694
R18164 VSS.n10667 VSS.n10247 2.01694
R18165 VSS.n10586 VSS.n10585 2.01694
R18166 VSS.n10586 VSS.n10287 2.01694
R18167 VSS.n10563 VSS.n10297 2.01694
R18168 VSS.n10566 VSS.n10297 2.01694
R18169 VSS.n10485 VSS.n10484 2.01694
R18170 VSS.n10485 VSS.n10337 2.01694
R18171 VSS.n10462 VSS.n10347 2.01694
R18172 VSS.n10465 VSS.n10347 2.01694
R18173 VSS.n11163 VSS.n11127 2.01694
R18174 VSS.n11164 VSS.n11163 2.01694
R18175 VSS.n11239 VSS.n1893 2.01694
R18176 VSS.n11231 VSS.n1893 2.01694
R18177 VSS.n11260 VSS.n1884 2.01694
R18178 VSS.n11261 VSS.n11260 2.01694
R18179 VSS.n11345 VSS.n1851 2.01694
R18180 VSS.n11337 VSS.n1851 2.01694
R18181 VSS.n11366 VSS.n1842 2.01694
R18182 VSS.n11367 VSS.n11366 2.01694
R18183 VSS.n11451 VSS.n1809 2.01694
R18184 VSS.n11443 VSS.n1809 2.01694
R18185 VSS.n11472 VSS.n1800 2.01694
R18186 VSS.n11473 VSS.n11472 2.01694
R18187 VSS.n11557 VSS.n1767 2.01694
R18188 VSS.n11549 VSS.n1767 2.01694
R18189 VSS.n11578 VSS.n1758 2.01694
R18190 VSS.n11579 VSS.n11578 2.01694
R18191 VSS.n11663 VSS.n1725 2.01694
R18192 VSS.n11655 VSS.n1725 2.01694
R18193 VSS.n11684 VSS.n1716 2.01694
R18194 VSS.n11685 VSS.n11684 2.01694
R18195 VSS.n11769 VSS.n1683 2.01694
R18196 VSS.n11761 VSS.n1683 2.01694
R18197 VSS.n11798 VSS.n1655 2.01694
R18198 VSS.n1675 VSS.n1655 2.01694
R18199 VSS.n12206 VSS.n12170 2.01694
R18200 VSS.n12207 VSS.n12206 2.01694
R18201 VSS.n12277 VSS.n12127 2.01694
R18202 VSS.n12269 VSS.n12127 2.01694
R18203 VSS.n12298 VSS.n12118 2.01694
R18204 VSS.n12299 VSS.n12298 2.01694
R18205 VSS.n12383 VSS.n12085 2.01694
R18206 VSS.n12375 VSS.n12085 2.01694
R18207 VSS.n12404 VSS.n12076 2.01694
R18208 VSS.n12405 VSS.n12404 2.01694
R18209 VSS.n12489 VSS.n12043 2.01694
R18210 VSS.n12481 VSS.n12043 2.01694
R18211 VSS.n12510 VSS.n12034 2.01694
R18212 VSS.n12511 VSS.n12510 2.01694
R18213 VSS.n12595 VSS.n12001 2.01694
R18214 VSS.n12587 VSS.n12001 2.01694
R18215 VSS.n12616 VSS.n11992 2.01694
R18216 VSS.n12617 VSS.n12616 2.01694
R18217 VSS.n12701 VSS.n11959 2.01694
R18218 VSS.n12693 VSS.n11959 2.01694
R18219 VSS.n12722 VSS.n11950 2.01694
R18220 VSS.n12723 VSS.n12722 2.01694
R18221 VSS.n12807 VSS.n11917 2.01694
R18222 VSS.n12799 VSS.n11917 2.01694
R18223 VSS.n12836 VSS.n11889 2.01694
R18224 VSS.n11909 VSS.n11889 2.01694
R18225 VSS.n13555 VSS.n13519 2.01694
R18226 VSS.n13556 VSS.n13555 2.01694
R18227 VSS.n13468 VSS.n13467 2.01694
R18228 VSS.n13468 VSS.n1292 2.01694
R18229 VSS.n13445 VSS.n1302 2.01694
R18230 VSS.n13448 VSS.n1302 2.01694
R18231 VSS.n13367 VSS.n13366 2.01694
R18232 VSS.n13367 VSS.n1342 2.01694
R18233 VSS.n13344 VSS.n1352 2.01694
R18234 VSS.n13347 VSS.n1352 2.01694
R18235 VSS.n13266 VSS.n13265 2.01694
R18236 VSS.n13266 VSS.n1392 2.01694
R18237 VSS.n13243 VSS.n1402 2.01694
R18238 VSS.n13246 VSS.n1402 2.01694
R18239 VSS.n13165 VSS.n13164 2.01694
R18240 VSS.n13165 VSS.n1442 2.01694
R18241 VSS.n13142 VSS.n1452 2.01694
R18242 VSS.n13145 VSS.n1452 2.01694
R18243 VSS.n13064 VSS.n13063 2.01694
R18244 VSS.n13064 VSS.n1492 2.01694
R18245 VSS.n13041 VSS.n1502 2.01694
R18246 VSS.n13044 VSS.n1502 2.01694
R18247 VSS.n12963 VSS.n12962 2.01694
R18248 VSS.n12963 VSS.n1542 2.01694
R18249 VSS.n12940 VSS.n1552 2.01694
R18250 VSS.n12943 VSS.n1552 2.01694
R18251 VSS.n14520 VSS.n14484 2.01694
R18252 VSS.n14521 VSS.n14520 2.01694
R18253 VSS.n14433 VSS.n14432 2.01694
R18254 VSS.n14433 VSS.n13607 2.01694
R18255 VSS.n14410 VSS.n13617 2.01694
R18256 VSS.n14413 VSS.n13617 2.01694
R18257 VSS.n14325 VSS.n14324 2.01694
R18258 VSS.n14325 VSS.n13661 2.01694
R18259 VSS.n14303 VSS.n14302 2.01694
R18260 VSS.n14175 VSS.n14174 2.01694
R18261 VSS.n14214 VSS.n13740 2.01694
R18262 VSS.n14202 VSS.n13740 2.01694
R18263 VSS.n14073 VSS.n14072 2.01694
R18264 VSS.n14073 VSS.n13774 2.01694
R18265 VSS.n14050 VSS.n13784 2.01694
R18266 VSS.n14053 VSS.n13784 2.01694
R18267 VSS.n13972 VSS.n13971 2.01694
R18268 VSS.n13972 VSS.n13824 2.01694
R18269 VSS.n13949 VSS.n13834 2.01694
R18270 VSS.n13952 VSS.n13834 2.01694
R18271 VSS.n15234 VSS.n15233 2.01694
R18272 VSS.n15233 VSS.n216 2.01694
R18273 VSS.n14603 VSS.n14567 2.01694
R18274 VSS.n14604 VSS.n14603 2.01694
R18275 VSS.n14679 VSS.n441 2.01694
R18276 VSS.n14671 VSS.n441 2.01694
R18277 VSS.n14700 VSS.n432 2.01694
R18278 VSS.n14701 VSS.n14700 2.01694
R18279 VSS.n419 VSS.n414 2.01694
R18280 VSS.n401 VSS.n396 2.01694
R18281 VSS.n14937 VSS.n337 2.01694
R18282 VSS.n15117 VSS.n15116 2.01694
R18283 VSS.n15117 VSS.n15086 2.01694
R18284 VSS.n266 VSS.n265 2.01694
R18285 VSS.n266 VSS.n248 2.01694
R18286 VSS.n15352 VSS.n15351 2.01694
R18287 VSS.n15352 VSS.n235 2.01694
R18288 VSS.n2893 VSS.n2892 2.01694
R18289 VSS.n2893 VSS.n85 2.01694
R18290 VSS.n2574 VSS.n2545 2.01694
R18291 VSS.n2571 VSS.n2545 2.01694
R18292 VSS.n2589 VSS.n2588 2.01694
R18293 VSS.n2589 VSS.n54 2.01694
R18294 VSS.n3439 VSS.n2534 2.01694
R18295 VSS.n3440 VSS.n3439 2.01694
R18296 VSS.n2642 VSS.n2619 2.01694
R18297 VSS.n2643 VSS.n2642 2.01694
R18298 VSS.n2670 VSS.n2612 2.01694
R18299 VSS.n2667 VSS.n2612 2.01694
R18300 VSS.n3406 VSS.n3405 2.01694
R18301 VSS.n3406 VSS.n2681 2.01694
R18302 VSS.n3383 VSS.n3382 2.01694
R18303 VSS.n3383 VSS.n2690 2.01694
R18304 VSS.n3354 VSS.n3353 2.01694
R18305 VSS.n3354 VSS.n2701 2.01694
R18306 VSS.n3331 VSS.n3330 2.01694
R18307 VSS.n3331 VSS.n2710 2.01694
R18308 VSS.n3302 VSS.n3301 2.01694
R18309 VSS.n3302 VSS.n2721 2.01694
R18310 VSS.n3279 VSS.n3278 2.01694
R18311 VSS.n3279 VSS.n2730 2.01694
R18312 VSS.n3250 VSS.n3249 2.01694
R18313 VSS.n3250 VSS.n2741 2.01694
R18314 VSS.n3227 VSS.n3226 2.01694
R18315 VSS.n3227 VSS.n2750 2.01694
R18316 VSS.n3198 VSS.n3197 2.01694
R18317 VSS.n3198 VSS.n2761 2.01694
R18318 VSS.n3175 VSS.n3174 2.01694
R18319 VSS.n3175 VSS.n2770 2.01694
R18320 VSS.n3146 VSS.n3145 2.01694
R18321 VSS.n3146 VSS.n2781 2.01694
R18322 VSS.n3123 VSS.n3122 2.01694
R18323 VSS.n3123 VSS.n2790 2.01694
R18324 VSS.n3094 VSS.n3093 2.01694
R18325 VSS.n3094 VSS.n2801 2.01694
R18326 VSS.n3071 VSS.n3070 2.01694
R18327 VSS.n3071 VSS.n2810 2.01694
R18328 VSS.n3042 VSS.n3041 2.01694
R18329 VSS.n3042 VSS.n2821 2.01694
R18330 VSS.n3019 VSS.n3018 2.01694
R18331 VSS.n3019 VSS.n2830 2.01694
R18332 VSS.n2990 VSS.n2989 2.01694
R18333 VSS.n2990 VSS.n2841 2.01694
R18334 VSS.n2967 VSS.n2966 2.01694
R18335 VSS.n2967 VSS.n2850 2.01694
R18336 VSS.n2938 VSS.n2937 2.01694
R18337 VSS.n2938 VSS.n2861 2.01694
R18338 VSS.n2915 VSS.n2914 2.01694
R18339 VSS.n2915 VSS.n2870 2.01694
R18340 VSS.n221 VSS.n401 2.01694
R18341 VSS.n219 VSS.n419 2.01694
R18342 VSS.t2904 VSS.n3804 2.00532
R18343 VSS.t2901 VSS.n3795 2.00532
R18344 VSS.n5882 VSS.t2689 2.00532
R18345 VSS.t2686 VSS.n5871 2.00532
R18346 VSS.t2474 VSS.n5885 2.00532
R18347 VSS.t2471 VSS.n4837 2.00532
R18348 VSS.t2259 VSS.n6927 2.00532
R18349 VSS.t2256 VSS.n6918 2.00532
R18350 VSS.n8364 VSS.t2044 2.00532
R18351 VSS.t2041 VSS.n8353 2.00532
R18352 VSS.n9402 VSS.t1829 2.00532
R18353 VSS.t1826 VSS.n9391 2.00532
R18354 VSS.t1611 VSS.n9405 2.00532
R18355 VSS.t1608 VSS.n2265 2.00532
R18356 VSS.t1396 VSS.n10447 2.00532
R18357 VSS.t1393 VSS.n10438 2.00532
R18358 VSS.n11884 VSS.t1181 2.00532
R18359 VSS.t1178 VSS.n11873 2.00532
R18360 VSS.n12922 VSS.t966 2.00532
R18361 VSS.t963 VSS.n12911 2.00532
R18362 VSS.t751 VSS.n12925 2.00532
R18363 VSS.t748 VSS.n1643 2.00532
R18364 VSS.t556 VSS.n13934 2.00532
R18365 VSS.t553 VSS.n13925 2.00532
R18366 VSS.t207 VSS.n14889 1.97497
R18367 VSS.n4435 VSS.n4400 1.9731
R18368 VSS.t3094 VSS.n4342 1.9731
R18369 VSS.n3463 VSS.n3461 1.9731
R18370 VSS.n4328 VSS.n4327 1.9731
R18371 VSS.t3079 VSS.n4241 1.9731
R18372 VSS.n3513 VSS.n3511 1.9731
R18373 VSS.n4227 VSS.n4226 1.9731
R18374 VSS.t3064 VSS.n4140 1.9731
R18375 VSS.n3563 VSS.n3561 1.9731
R18376 VSS.n4126 VSS.n4125 1.9731
R18377 VSS.t3049 VSS.n4039 1.9731
R18378 VSS.n3613 VSS.n3611 1.9731
R18379 VSS.n4025 VSS.n4024 1.9731
R18380 VSS.t3034 VSS.n3938 1.9731
R18381 VSS.n3663 VSS.n3661 1.9731
R18382 VSS.n3924 VSS.n3923 1.9731
R18383 VSS.t3019 VSS.n3837 1.9731
R18384 VSS.n3713 VSS.n3711 1.9731
R18385 VSS.n3823 VSS.n3822 1.9731
R18386 VSS.n5167 VSS.n5132 1.9731
R18387 VSS.t2876 VSS.n5241 1.9731
R18388 VSS.n5230 VSS.n5229 1.9731
R18389 VSS.n5259 VSS.n130 1.9731
R18390 VSS.t2861 VSS.n5347 1.9731
R18391 VSS.n5336 VSS.n5335 1.9731
R18392 VSS.n5365 VSS.n131 1.9731
R18393 VSS.t2846 VSS.n5453 1.9731
R18394 VSS.n5442 VSS.n5441 1.9731
R18395 VSS.n5471 VSS.n132 1.9731
R18396 VSS.t2831 VSS.n5559 1.9731
R18397 VSS.n5548 VSS.n5547 1.9731
R18398 VSS.n5577 VSS.n133 1.9731
R18399 VSS.t2816 VSS.n5665 1.9731
R18400 VSS.n5654 VSS.n5653 1.9731
R18401 VSS.n5683 VSS.n134 1.9731
R18402 VSS.t2801 VSS.n5771 1.9731
R18403 VSS.n5760 VSS.n5759 1.9731
R18404 VSS.n5785 VSS.n4869 1.9731
R18405 VSS.n6516 VSS.n6481 1.9731
R18406 VSS.t2661 VSS.n6423 1.9731
R18407 VSS.n4486 VSS.n4484 1.9731
R18408 VSS.n6409 VSS.n6408 1.9731
R18409 VSS.t2646 VSS.n6322 1.9731
R18410 VSS.n4536 VSS.n4534 1.9731
R18411 VSS.n6308 VSS.n6307 1.9731
R18412 VSS.t2631 VSS.n6221 1.9731
R18413 VSS.n4586 VSS.n4584 1.9731
R18414 VSS.n6207 VSS.n6206 1.9731
R18415 VSS.t2616 VSS.n6120 1.9731
R18416 VSS.n4636 VSS.n4634 1.9731
R18417 VSS.n6106 VSS.n6105 1.9731
R18418 VSS.t2601 VSS.n6019 1.9731
R18419 VSS.n4686 VSS.n4684 1.9731
R18420 VSS.n6005 VSS.n6004 1.9731
R18421 VSS.t2586 VSS.n5918 1.9731
R18422 VSS.n4736 VSS.n4734 1.9731
R18423 VSS.n5904 VSS.n5903 1.9731
R18424 VSS.n7558 VSS.n7523 1.9731
R18425 VSS.t2446 VSS.n7465 1.9731
R18426 VSS.n6567 VSS.n6565 1.9731
R18427 VSS.n7451 VSS.n7450 1.9731
R18428 VSS.t2431 VSS.n7364 1.9731
R18429 VSS.n6617 VSS.n6615 1.9731
R18430 VSS.n7350 VSS.n7349 1.9731
R18431 VSS.t2416 VSS.n7263 1.9731
R18432 VSS.n6667 VSS.n6665 1.9731
R18433 VSS.n7249 VSS.n7248 1.9731
R18434 VSS.t2401 VSS.n7162 1.9731
R18435 VSS.n6717 VSS.n6715 1.9731
R18436 VSS.n7148 VSS.n7147 1.9731
R18437 VSS.t2386 VSS.n7061 1.9731
R18438 VSS.n6767 VSS.n6765 1.9731
R18439 VSS.n7047 VSS.n7046 1.9731
R18440 VSS.t2371 VSS.n6960 1.9731
R18441 VSS.n6817 VSS.n6815 1.9731
R18442 VSS.n6946 VSS.n6945 1.9731
R18443 VSS.n7644 VSS.n7609 1.9731
R18444 VSS.t2231 VSS.n7723 1.9731
R18445 VSS.n7712 VSS.n7711 1.9731
R18446 VSS.n7741 VSS.n136 1.9731
R18447 VSS.t2216 VSS.n7829 1.9731
R18448 VSS.n7818 VSS.n7817 1.9731
R18449 VSS.n7847 VSS.n137 1.9731
R18450 VSS.t2201 VSS.n7935 1.9731
R18451 VSS.n7924 VSS.n7923 1.9731
R18452 VSS.n7953 VSS.n138 1.9731
R18453 VSS.t2186 VSS.n8041 1.9731
R18454 VSS.n8030 VSS.n8029 1.9731
R18455 VSS.n8059 VSS.n139 1.9731
R18456 VSS.t2171 VSS.n8147 1.9731
R18457 VSS.n8136 VSS.n8135 1.9731
R18458 VSS.n8165 VSS.n140 1.9731
R18459 VSS.t2156 VSS.n8253 1.9731
R18460 VSS.n8242 VSS.n8241 1.9731
R18461 VSS.n8267 VSS.n2297 1.9731
R18462 VSS.n8687 VSS.n8652 1.9731
R18463 VSS.t2016 VSS.n8761 1.9731
R18464 VSS.n8750 VSS.n8749 1.9731
R18465 VSS.n8779 VSS.n142 1.9731
R18466 VSS.t2001 VSS.n8867 1.9731
R18467 VSS.n8856 VSS.n8855 1.9731
R18468 VSS.n8885 VSS.n143 1.9731
R18469 VSS.t1986 VSS.n8973 1.9731
R18470 VSS.n8962 VSS.n8961 1.9731
R18471 VSS.n8991 VSS.n144 1.9731
R18472 VSS.t1971 VSS.n9079 1.9731
R18473 VSS.n9068 VSS.n9067 1.9731
R18474 VSS.n9097 VSS.n145 1.9731
R18475 VSS.t1956 VSS.n9185 1.9731
R18476 VSS.n9174 VSS.n9173 1.9731
R18477 VSS.n9203 VSS.n146 1.9731
R18478 VSS.t1941 VSS.n9291 1.9731
R18479 VSS.n9280 VSS.n9279 1.9731
R18480 VSS.n9305 VSS.n8389 1.9731
R18481 VSS.n10036 VSS.n10001 1.9731
R18482 VSS.t1801 VSS.n9943 1.9731
R18483 VSS.n1933 VSS.n1931 1.9731
R18484 VSS.n9929 VSS.n9928 1.9731
R18485 VSS.t1786 VSS.n9842 1.9731
R18486 VSS.n1983 VSS.n1981 1.9731
R18487 VSS.n9828 VSS.n9827 1.9731
R18488 VSS.t1771 VSS.n9741 1.9731
R18489 VSS.n2033 VSS.n2031 1.9731
R18490 VSS.n9727 VSS.n9726 1.9731
R18491 VSS.t1756 VSS.n9640 1.9731
R18492 VSS.n2083 VSS.n2081 1.9731
R18493 VSS.n9626 VSS.n9625 1.9731
R18494 VSS.t1741 VSS.n9539 1.9731
R18495 VSS.n2133 VSS.n2131 1.9731
R18496 VSS.n9525 VSS.n9524 1.9731
R18497 VSS.t1726 VSS.n9438 1.9731
R18498 VSS.n2183 VSS.n2181 1.9731
R18499 VSS.n9424 VSS.n9423 1.9731
R18500 VSS.n11078 VSS.n11043 1.9731
R18501 VSS.t1583 VSS.n10985 1.9731
R18502 VSS.n10087 VSS.n10085 1.9731
R18503 VSS.n10971 VSS.n10970 1.9731
R18504 VSS.t1568 VSS.n10884 1.9731
R18505 VSS.n10137 VSS.n10135 1.9731
R18506 VSS.n10870 VSS.n10869 1.9731
R18507 VSS.t1553 VSS.n10783 1.9731
R18508 VSS.n10187 VSS.n10185 1.9731
R18509 VSS.n10769 VSS.n10768 1.9731
R18510 VSS.t1538 VSS.n10682 1.9731
R18511 VSS.n10237 VSS.n10235 1.9731
R18512 VSS.n10668 VSS.n10667 1.9731
R18513 VSS.t1523 VSS.n10581 1.9731
R18514 VSS.n10287 VSS.n10285 1.9731
R18515 VSS.n10567 VSS.n10566 1.9731
R18516 VSS.t1508 VSS.n10480 1.9731
R18517 VSS.n10337 VSS.n10335 1.9731
R18518 VSS.n10466 VSS.n10465 1.9731
R18519 VSS.n11164 VSS.n11129 1.9731
R18520 VSS.t1368 VSS.n11243 1.9731
R18521 VSS.n11232 VSS.n11231 1.9731
R18522 VSS.n11261 VSS.n148 1.9731
R18523 VSS.t1353 VSS.n11349 1.9731
R18524 VSS.n11338 VSS.n11337 1.9731
R18525 VSS.n11367 VSS.n149 1.9731
R18526 VSS.t1338 VSS.n11455 1.9731
R18527 VSS.n11444 VSS.n11443 1.9731
R18528 VSS.n11473 VSS.n150 1.9731
R18529 VSS.t1323 VSS.n11561 1.9731
R18530 VSS.n11550 VSS.n11549 1.9731
R18531 VSS.n11579 VSS.n151 1.9731
R18532 VSS.t1308 VSS.n11667 1.9731
R18533 VSS.n11656 VSS.n11655 1.9731
R18534 VSS.n11685 VSS.n152 1.9731
R18535 VSS.t1293 VSS.n11773 1.9731
R18536 VSS.n11762 VSS.n11761 1.9731
R18537 VSS.n11787 VSS.n1675 1.9731
R18538 VSS.n12207 VSS.n12172 1.9731
R18539 VSS.t1153 VSS.n12281 1.9731
R18540 VSS.n12270 VSS.n12269 1.9731
R18541 VSS.n12299 VSS.n154 1.9731
R18542 VSS.t1138 VSS.n12387 1.9731
R18543 VSS.n12376 VSS.n12375 1.9731
R18544 VSS.n12405 VSS.n155 1.9731
R18545 VSS.t1123 VSS.n12493 1.9731
R18546 VSS.n12482 VSS.n12481 1.9731
R18547 VSS.n12511 VSS.n156 1.9731
R18548 VSS.t1108 VSS.n12599 1.9731
R18549 VSS.n12588 VSS.n12587 1.9731
R18550 VSS.n12617 VSS.n157 1.9731
R18551 VSS.t1093 VSS.n12705 1.9731
R18552 VSS.n12694 VSS.n12693 1.9731
R18553 VSS.n12723 VSS.n158 1.9731
R18554 VSS.t1078 VSS.n12811 1.9731
R18555 VSS.n12800 VSS.n12799 1.9731
R18556 VSS.n12825 VSS.n11909 1.9731
R18557 VSS.n13556 VSS.n13521 1.9731
R18558 VSS.t938 VSS.n13463 1.9731
R18559 VSS.n1292 VSS.n1290 1.9731
R18560 VSS.n13449 VSS.n13448 1.9731
R18561 VSS.t923 VSS.n13362 1.9731
R18562 VSS.n1342 VSS.n1340 1.9731
R18563 VSS.n13348 VSS.n13347 1.9731
R18564 VSS.t908 VSS.n13261 1.9731
R18565 VSS.n1392 VSS.n1390 1.9731
R18566 VSS.n13247 VSS.n13246 1.9731
R18567 VSS.t893 VSS.n13160 1.9731
R18568 VSS.n1442 VSS.n1440 1.9731
R18569 VSS.n13146 VSS.n13145 1.9731
R18570 VSS.t878 VSS.n13059 1.9731
R18571 VSS.n1492 VSS.n1490 1.9731
R18572 VSS.n13045 VSS.n13044 1.9731
R18573 VSS.t863 VSS.n12958 1.9731
R18574 VSS.n1542 VSS.n1540 1.9731
R18575 VSS.n12944 VSS.n12943 1.9731
R18576 VSS.n14521 VSS.n14486 1.9731
R18577 VSS.t723 VSS.n14428 1.9731
R18578 VSS.n13607 VSS.n13605 1.9731
R18579 VSS.n14414 VSS.n14413 1.9731
R18580 VSS.n14203 VSS.n14202 1.9731
R18581 VSS.t668 VSS.n14068 1.9731
R18582 VSS.n13774 VSS.n13772 1.9731
R18583 VSS.n14054 VSS.n14053 1.9731
R18584 VSS.t653 VSS.n13967 1.9731
R18585 VSS.n13824 VSS.n13822 1.9731
R18586 VSS.n13953 VSS.n13952 1.9731
R18587 VSS.n14604 VSS.n14569 1.9731
R18588 VSS.t528 VSS.n14683 1.9731
R18589 VSS.n14672 VSS.n14671 1.9731
R18590 VSS.n14701 VSS.n160 1.9731
R18591 VSS.n5831 VSS.n5820 1.90886
R18592 VSS.n5835 VSS.n5817 1.90886
R18593 VSS.n5854 VSS.n5807 1.90886
R18594 VSS.n5858 VSS.n5804 1.90886
R18595 VSS.n4795 VSS.n4785 1.90886
R18596 VSS.n4800 VSS.n4783 1.90886
R18597 VSS.n4817 VSS.n4771 1.90886
R18598 VSS.n4822 VSS.n4769 1.90886
R18599 VSS.n6876 VSS.n6866 1.90886
R18600 VSS.n6881 VSS.n6864 1.90886
R18601 VSS.n6898 VSS.n6852 1.90886
R18602 VSS.n6903 VSS.n6850 1.90886
R18603 VSS.n8313 VSS.n8302 1.90886
R18604 VSS.n8317 VSS.n8299 1.90886
R18605 VSS.n8336 VSS.n8289 1.90886
R18606 VSS.n8340 VSS.n8286 1.90886
R18607 VSS.n9351 VSS.n9340 1.90886
R18608 VSS.n9355 VSS.n9337 1.90886
R18609 VSS.n9374 VSS.n9327 1.90886
R18610 VSS.n9378 VSS.n9324 1.90886
R18611 VSS.n10396 VSS.n10386 1.90886
R18612 VSS.n10401 VSS.n10384 1.90886
R18613 VSS.n10418 VSS.n10372 1.90886
R18614 VSS.n10423 VSS.n10370 1.90886
R18615 VSS.n11833 VSS.n11822 1.90886
R18616 VSS.n11837 VSS.n11819 1.90886
R18617 VSS.n11856 VSS.n11809 1.90886
R18618 VSS.n11860 VSS.n11806 1.90886
R18619 VSS.n12871 VSS.n12860 1.90886
R18620 VSS.n12875 VSS.n12857 1.90886
R18621 VSS.n12894 VSS.n12847 1.90886
R18622 VSS.n12898 VSS.n12844 1.90886
R18623 VSS.n1601 VSS.n1591 1.90886
R18624 VSS.n1606 VSS.n1589 1.90886
R18625 VSS.n1623 VSS.n1577 1.90886
R18626 VSS.n1628 VSS.n1575 1.90886
R18627 VSS.n13883 VSS.n13873 1.90886
R18628 VSS.n13888 VSS.n13871 1.90886
R18629 VSS.n13905 VSS.n13859 1.90886
R18630 VSS.n13910 VSS.n13857 1.90886
R18631 VSS.n15179 VSS.n15169 1.90886
R18632 VSS.n15184 VSS.n15167 1.90886
R18633 VSS.n15201 VSS.n15155 1.90886
R18634 VSS.n15206 VSS.n15153 1.90886
R18635 VSS.n14971 VSS.n331 1.90886
R18636 VSS.n14965 VSS.n14958 1.90886
R18637 VSS.n14996 VSS.n14995 1.90886
R18638 VSS.n14992 VSS.n14991 1.90886
R18639 VSS.t72 VSS.t705 1.90688
R18640 VSS.n196 VSS.n195 0.0276343
R18641 VSS.t162 VSS.n14922 1.90313
R18642 VSS.t20 VSS.n14878 1.88285
R18643 VSS.t170 VSS.t4356 1.87876
R18644 VSS.n3768 VSS.n3752 1.86597
R18645 VSS.n4429 VSS.n4401 1.86597
R18646 VSS.n4392 VSS.n4374 1.86597
R18647 VSS.n4354 VSS.n3459 1.86597
R18648 VSS.n4277 VSS.n4276 1.86597
R18649 VSS.n4253 VSS.n3509 1.86597
R18650 VSS.n4176 VSS.n4175 1.86597
R18651 VSS.n4152 VSS.n3559 1.86597
R18652 VSS.n4075 VSS.n4074 1.86597
R18653 VSS.n4051 VSS.n3609 1.86597
R18654 VSS.n3974 VSS.n3973 1.86597
R18655 VSS.n3950 VSS.n3659 1.86597
R18656 VSS.n3873 VSS.n3872 1.86597
R18657 VSS.n3849 VSS.n3709 1.86597
R18658 VSS.n5161 VSS.n5133 1.86597
R18659 VSS.n5203 VSS.n5098 1.86597
R18660 VSS.n5228 VSS.n5227 1.86597
R18661 VSS.n5309 VSS.n5056 1.86597
R18662 VSS.n5334 VSS.n5333 1.86597
R18663 VSS.n5415 VSS.n5014 1.86597
R18664 VSS.n5440 VSS.n5439 1.86597
R18665 VSS.n5521 VSS.n4972 1.86597
R18666 VSS.n5546 VSS.n5545 1.86597
R18667 VSS.n5627 VSS.n4930 1.86597
R18668 VSS.n5652 VSS.n5651 1.86597
R18669 VSS.n5733 VSS.n4888 1.86597
R18670 VSS.n5758 VSS.n5757 1.86597
R18671 VSS.n6510 VSS.n6482 1.86597
R18672 VSS.n6473 VSS.n6455 1.86597
R18673 VSS.n6435 VSS.n4482 1.86597
R18674 VSS.n6358 VSS.n6357 1.86597
R18675 VSS.n6334 VSS.n4532 1.86597
R18676 VSS.n6257 VSS.n6256 1.86597
R18677 VSS.n6233 VSS.n4582 1.86597
R18678 VSS.n6156 VSS.n6155 1.86597
R18679 VSS.n6132 VSS.n4632 1.86597
R18680 VSS.n6055 VSS.n6054 1.86597
R18681 VSS.n6031 VSS.n4682 1.86597
R18682 VSS.n5954 VSS.n5953 1.86597
R18683 VSS.n5930 VSS.n4732 1.86597
R18684 VSS.n7552 VSS.n7524 1.86597
R18685 VSS.n7515 VSS.n7497 1.86597
R18686 VSS.n7477 VSS.n6563 1.86597
R18687 VSS.n7400 VSS.n7399 1.86597
R18688 VSS.n7376 VSS.n6613 1.86597
R18689 VSS.n7299 VSS.n7298 1.86597
R18690 VSS.n7275 VSS.n6663 1.86597
R18691 VSS.n7198 VSS.n7197 1.86597
R18692 VSS.n7174 VSS.n6713 1.86597
R18693 VSS.n7097 VSS.n7096 1.86597
R18694 VSS.n7073 VSS.n6763 1.86597
R18695 VSS.n6996 VSS.n6995 1.86597
R18696 VSS.n6972 VSS.n6813 1.86597
R18697 VSS.n7638 VSS.n7610 1.86597
R18698 VSS.n7685 VSS.n2526 1.86597
R18699 VSS.n7710 VSS.n7709 1.86597
R18700 VSS.n7791 VSS.n2484 1.86597
R18701 VSS.n7816 VSS.n7815 1.86597
R18702 VSS.n7897 VSS.n2442 1.86597
R18703 VSS.n7922 VSS.n7921 1.86597
R18704 VSS.n8003 VSS.n2400 1.86597
R18705 VSS.n8028 VSS.n8027 1.86597
R18706 VSS.n8109 VSS.n2358 1.86597
R18707 VSS.n8134 VSS.n8133 1.86597
R18708 VSS.n8215 VSS.n2316 1.86597
R18709 VSS.n8240 VSS.n8239 1.86597
R18710 VSS.n8681 VSS.n8653 1.86597
R18711 VSS.n8723 VSS.n8618 1.86597
R18712 VSS.n8748 VSS.n8747 1.86597
R18713 VSS.n8829 VSS.n8576 1.86597
R18714 VSS.n8854 VSS.n8853 1.86597
R18715 VSS.n8935 VSS.n8534 1.86597
R18716 VSS.n8960 VSS.n8959 1.86597
R18717 VSS.n9041 VSS.n8492 1.86597
R18718 VSS.n9066 VSS.n9065 1.86597
R18719 VSS.n9147 VSS.n8450 1.86597
R18720 VSS.n9172 VSS.n9171 1.86597
R18721 VSS.n9253 VSS.n8408 1.86597
R18722 VSS.n9278 VSS.n9277 1.86597
R18723 VSS.n2238 VSS.n2222 1.86597
R18724 VSS.n10030 VSS.n10002 1.86597
R18725 VSS.n9993 VSS.n9975 1.86597
R18726 VSS.n9955 VSS.n1929 1.86597
R18727 VSS.n9878 VSS.n9877 1.86597
R18728 VSS.n9854 VSS.n1979 1.86597
R18729 VSS.n9777 VSS.n9776 1.86597
R18730 VSS.n9753 VSS.n2029 1.86597
R18731 VSS.n9676 VSS.n9675 1.86597
R18732 VSS.n9652 VSS.n2079 1.86597
R18733 VSS.n9575 VSS.n9574 1.86597
R18734 VSS.n9551 VSS.n2129 1.86597
R18735 VSS.n9474 VSS.n9473 1.86597
R18736 VSS.n9450 VSS.n2179 1.86597
R18737 VSS.n11072 VSS.n11044 1.86597
R18738 VSS.n11035 VSS.n11017 1.86597
R18739 VSS.n10997 VSS.n10083 1.86597
R18740 VSS.n10920 VSS.n10919 1.86597
R18741 VSS.n10896 VSS.n10133 1.86597
R18742 VSS.n10819 VSS.n10818 1.86597
R18743 VSS.n10795 VSS.n10183 1.86597
R18744 VSS.n10718 VSS.n10717 1.86597
R18745 VSS.n10694 VSS.n10233 1.86597
R18746 VSS.n10617 VSS.n10616 1.86597
R18747 VSS.n10593 VSS.n10283 1.86597
R18748 VSS.n10516 VSS.n10515 1.86597
R18749 VSS.n10492 VSS.n10333 1.86597
R18750 VSS.n11158 VSS.n11130 1.86597
R18751 VSS.n11205 VSS.n1904 1.86597
R18752 VSS.n11230 VSS.n11229 1.86597
R18753 VSS.n11311 VSS.n1862 1.86597
R18754 VSS.n11336 VSS.n11335 1.86597
R18755 VSS.n11417 VSS.n1820 1.86597
R18756 VSS.n11442 VSS.n11441 1.86597
R18757 VSS.n11523 VSS.n1778 1.86597
R18758 VSS.n11548 VSS.n11547 1.86597
R18759 VSS.n11629 VSS.n1736 1.86597
R18760 VSS.n11654 VSS.n11653 1.86597
R18761 VSS.n11735 VSS.n1694 1.86597
R18762 VSS.n11760 VSS.n11759 1.86597
R18763 VSS.n12201 VSS.n12173 1.86597
R18764 VSS.n12243 VSS.n12138 1.86597
R18765 VSS.n12268 VSS.n12267 1.86597
R18766 VSS.n12349 VSS.n12096 1.86597
R18767 VSS.n12374 VSS.n12373 1.86597
R18768 VSS.n12455 VSS.n12054 1.86597
R18769 VSS.n12480 VSS.n12479 1.86597
R18770 VSS.n12561 VSS.n12012 1.86597
R18771 VSS.n12586 VSS.n12585 1.86597
R18772 VSS.n12667 VSS.n11970 1.86597
R18773 VSS.n12692 VSS.n12691 1.86597
R18774 VSS.n12773 VSS.n11928 1.86597
R18775 VSS.n12798 VSS.n12797 1.86597
R18776 VSS.n13550 VSS.n13522 1.86597
R18777 VSS.n13513 VSS.n13495 1.86597
R18778 VSS.n13475 VSS.n1288 1.86597
R18779 VSS.n13398 VSS.n13397 1.86597
R18780 VSS.n13374 VSS.n1338 1.86597
R18781 VSS.n13297 VSS.n13296 1.86597
R18782 VSS.n13273 VSS.n1388 1.86597
R18783 VSS.n13196 VSS.n13195 1.86597
R18784 VSS.n13172 VSS.n1438 1.86597
R18785 VSS.n13095 VSS.n13094 1.86597
R18786 VSS.n13071 VSS.n1488 1.86597
R18787 VSS.n12994 VSS.n12993 1.86597
R18788 VSS.n12970 VSS.n1538 1.86597
R18789 VSS.n14515 VSS.n14487 1.86597
R18790 VSS.n14478 VSS.n14460 1.86597
R18791 VSS.n14440 VSS.n13603 1.86597
R18792 VSS.n14363 VSS.n14362 1.86597
R18793 VSS.n14346 VSS.n13651 1.86597
R18794 VSS.n14221 VSS.n13737 1.86597
R18795 VSS.n14201 VSS.n14200 1.86597
R18796 VSS.n14104 VSS.n14103 1.86597
R18797 VSS.n14080 VSS.n13770 1.86597
R18798 VSS.n14003 VSS.n14002 1.86597
R18799 VSS.n13979 VSS.n13820 1.86597
R18800 VSS.n14598 VSS.n14570 1.86597
R18801 VSS.n14645 VSS.n452 1.86597
R18802 VSS.n14670 VSS.n14669 1.86597
R18803 VSS.n14330 VSS.t3316 1.8388
R18804 VSS.t4265 VSS.t713 1.80631
R18805 VSS.n13672 VSS.t607 1.80631
R18806 VSS.t604 VSS.n13698 1.80631
R18807 VSS.t4306 VSS.t595 1.80631
R18808 VSS.t4274 VSS.t688 1.79885
R18809 VSS.n14804 VSS.t4354 1.79699
R18810 VSS.t4355 VSS.n14826 1.79699
R18811 VSS.n14863 VSS.t4357 1.79699
R18812 VSS.n13696 VSS.n13669 1.76897
R18813 VSS.n13687 VSS.n13674 1.76897
R18814 VSS.t4329 VSS.n14803 1.75956
R18815 VSS.t3106 VSS.t2998 1.75392
R18816 VSS.t3091 VSS.t2982 1.75392
R18817 VSS.t3076 VSS.t2967 1.75392
R18818 VSS.t3061 VSS.t2952 1.75392
R18819 VSS.t3046 VSS.t2937 1.75392
R18820 VSS.t3031 VSS.t2922 1.75392
R18821 VSS.t3016 VSS.t2907 1.75392
R18822 VSS.t2888 VSS.t2783 1.75392
R18823 VSS.t2873 VSS.t2767 1.75392
R18824 VSS.t2858 VSS.t2752 1.75392
R18825 VSS.t2843 VSS.t2737 1.75392
R18826 VSS.t2828 VSS.t2722 1.75392
R18827 VSS.t2813 VSS.t2707 1.75392
R18828 VSS.t2798 VSS.t2692 1.75392
R18829 VSS.t2673 VSS.t2568 1.75392
R18830 VSS.t2658 VSS.t2552 1.75392
R18831 VSS.t2643 VSS.t2537 1.75392
R18832 VSS.t2628 VSS.t2522 1.75392
R18833 VSS.t2613 VSS.t2507 1.75392
R18834 VSS.t2598 VSS.t2492 1.75392
R18835 VSS.t2583 VSS.t2477 1.75392
R18836 VSS.t2458 VSS.t2353 1.75392
R18837 VSS.t2443 VSS.t2337 1.75392
R18838 VSS.t2428 VSS.t2322 1.75392
R18839 VSS.t2413 VSS.t2307 1.75392
R18840 VSS.t2398 VSS.t2292 1.75392
R18841 VSS.t2383 VSS.t2277 1.75392
R18842 VSS.t2368 VSS.t2262 1.75392
R18843 VSS.t2243 VSS.t2138 1.75392
R18844 VSS.t2228 VSS.t2122 1.75392
R18845 VSS.t2213 VSS.t2107 1.75392
R18846 VSS.t2198 VSS.t2092 1.75392
R18847 VSS.t2183 VSS.t2077 1.75392
R18848 VSS.t2168 VSS.t2062 1.75392
R18849 VSS.t2153 VSS.t2047 1.75392
R18850 VSS.t2028 VSS.t1923 1.75392
R18851 VSS.t2013 VSS.t1907 1.75392
R18852 VSS.t1998 VSS.t1892 1.75392
R18853 VSS.t1983 VSS.t1877 1.75392
R18854 VSS.t1968 VSS.t1862 1.75392
R18855 VSS.t1953 VSS.t1847 1.75392
R18856 VSS.t1938 VSS.t1832 1.75392
R18857 VSS.t1813 VSS.t1705 1.75392
R18858 VSS.t1798 VSS.t1689 1.75392
R18859 VSS.t1783 VSS.t1674 1.75392
R18860 VSS.t1768 VSS.t1659 1.75392
R18861 VSS.t1753 VSS.t1644 1.75392
R18862 VSS.t1738 VSS.t1629 1.75392
R18863 VSS.t1723 VSS.t1614 1.75392
R18864 VSS.t1595 VSS.t1490 1.75392
R18865 VSS.t1580 VSS.t1474 1.75392
R18866 VSS.t1565 VSS.t1459 1.75392
R18867 VSS.t1550 VSS.t1444 1.75392
R18868 VSS.t1535 VSS.t1429 1.75392
R18869 VSS.t1520 VSS.t1414 1.75392
R18870 VSS.t1505 VSS.t1399 1.75392
R18871 VSS.t1380 VSS.t1275 1.75392
R18872 VSS.t1365 VSS.t1259 1.75392
R18873 VSS.t1350 VSS.t1244 1.75392
R18874 VSS.t1335 VSS.t1229 1.75392
R18875 VSS.t1320 VSS.t1214 1.75392
R18876 VSS.t1305 VSS.t1199 1.75392
R18877 VSS.t1290 VSS.t1184 1.75392
R18878 VSS.t1165 VSS.t1060 1.75392
R18879 VSS.t1150 VSS.t1044 1.75392
R18880 VSS.t1135 VSS.t1029 1.75392
R18881 VSS.t1120 VSS.t1014 1.75392
R18882 VSS.t1105 VSS.t999 1.75392
R18883 VSS.t1090 VSS.t984 1.75392
R18884 VSS.t1075 VSS.t969 1.75392
R18885 VSS.t950 VSS.t845 1.75392
R18886 VSS.t935 VSS.t829 1.75392
R18887 VSS.t920 VSS.t814 1.75392
R18888 VSS.t905 VSS.t799 1.75392
R18889 VSS.t890 VSS.t784 1.75392
R18890 VSS.t875 VSS.t769 1.75392
R18891 VSS.t860 VSS.t754 1.75392
R18892 VSS.t735 VSS.t635 1.75392
R18893 VSS.t720 VSS.t619 1.75392
R18894 VSS.t680 VSS.t589 1.75392
R18895 VSS.t665 VSS.t574 1.75392
R18896 VSS.t650 VSS.t559 1.75392
R18897 VSS.t540 VSS.t465 1.75392
R18898 VSS.n14847 VSS.t3411 1.7528
R18899 VSS.n14268 VSS.t602 1.72247
R18900 VSS.t4273 VSS.n13730 1.72214
R18901 VSS.n15111 VSS.t3319 1.71009
R18902 VSS VSS.n35 2.57056
R18903 VSS.n15240 VSS.n4 2.57505
R18904 VSS.n124 VSS.n225 1.65197
R18905 VSS.n12924 VSS.n122 1.65197
R18906 VSS.n12923 VSS.n120 1.65197
R18907 VSS.n11885 VSS.n118 1.65197
R18908 VSS.n116 VSS.n226 1.65197
R18909 VSS.n9404 VSS.n114 1.65197
R18910 VSS.n9403 VSS.n112 1.65197
R18911 VSS.n8365 VSS.n110 1.65197
R18912 VSS.n108 VSS.n227 1.65197
R18913 VSS.n5884 VSS.n106 1.65197
R18914 VSS.n5883 VSS.n104 1.65197
R18915 VSS.n102 VSS.n228 1.65197
R18916 VSS VSS.n0 2.57505
R18917 VSS.n14804 VSS.t4329 1.68471
R18918 VSS.n14899 VSS.n353 1.68471
R18919 VSS.n14807 VSS.t4354 1.64728
R18920 VSS.n14827 VSS.t4355 1.64728
R18921 VSS.n14866 VSS.t4357 1.64728
R18922 VSS.n4431 VSS.n4400 1.62242
R18923 VSS.n4350 VSS.n3461 1.62242
R18924 VSS.n4328 VSS.n3472 1.62242
R18925 VSS.n4249 VSS.n3511 1.62242
R18926 VSS.n4227 VSS.n3522 1.62242
R18927 VSS.n4148 VSS.n3561 1.62242
R18928 VSS.n4126 VSS.n3572 1.62242
R18929 VSS.n4047 VSS.n3611 1.62242
R18930 VSS.n4025 VSS.n3622 1.62242
R18931 VSS.n3946 VSS.n3661 1.62242
R18932 VSS.n3924 VSS.n3672 1.62242
R18933 VSS.n3845 VSS.n3711 1.62242
R18934 VSS.n3823 VSS.n3722 1.62242
R18935 VSS.n5163 VSS.n5132 1.62242
R18936 VSS.n5231 VSS.n5230 1.62242
R18937 VSS.n5255 VSS.n130 1.62242
R18938 VSS.n5337 VSS.n5336 1.62242
R18939 VSS.n5361 VSS.n131 1.62242
R18940 VSS.n5443 VSS.n5442 1.62242
R18941 VSS.n5467 VSS.n132 1.62242
R18942 VSS.n5549 VSS.n5548 1.62242
R18943 VSS.n5573 VSS.n133 1.62242
R18944 VSS.n5655 VSS.n5654 1.62242
R18945 VSS.n5679 VSS.n134 1.62242
R18946 VSS.n5761 VSS.n5760 1.62242
R18947 VSS.n5786 VSS.n5785 1.62242
R18948 VSS.n6512 VSS.n6481 1.62242
R18949 VSS.n6431 VSS.n4484 1.62242
R18950 VSS.n6409 VSS.n4495 1.62242
R18951 VSS.n6330 VSS.n4534 1.62242
R18952 VSS.n6308 VSS.n4545 1.62242
R18953 VSS.n6229 VSS.n4584 1.62242
R18954 VSS.n6207 VSS.n4595 1.62242
R18955 VSS.n6128 VSS.n4634 1.62242
R18956 VSS.n6106 VSS.n4645 1.62242
R18957 VSS.n6027 VSS.n4684 1.62242
R18958 VSS.n6005 VSS.n4695 1.62242
R18959 VSS.n5926 VSS.n4734 1.62242
R18960 VSS.n5904 VSS.n4745 1.62242
R18961 VSS.n7554 VSS.n7523 1.62242
R18962 VSS.n7473 VSS.n6565 1.62242
R18963 VSS.n7451 VSS.n6576 1.62242
R18964 VSS.n7372 VSS.n6615 1.62242
R18965 VSS.n7350 VSS.n6626 1.62242
R18966 VSS.n7271 VSS.n6665 1.62242
R18967 VSS.n7249 VSS.n6676 1.62242
R18968 VSS.n7170 VSS.n6715 1.62242
R18969 VSS.n7148 VSS.n6726 1.62242
R18970 VSS.n7069 VSS.n6765 1.62242
R18971 VSS.n7047 VSS.n6776 1.62242
R18972 VSS.n6968 VSS.n6815 1.62242
R18973 VSS.n6946 VSS.n6826 1.62242
R18974 VSS.n7640 VSS.n7609 1.62242
R18975 VSS.n7713 VSS.n7712 1.62242
R18976 VSS.n7737 VSS.n136 1.62242
R18977 VSS.n7819 VSS.n7818 1.62242
R18978 VSS.n7843 VSS.n137 1.62242
R18979 VSS.n7925 VSS.n7924 1.62242
R18980 VSS.n7949 VSS.n138 1.62242
R18981 VSS.n8031 VSS.n8030 1.62242
R18982 VSS.n8055 VSS.n139 1.62242
R18983 VSS.n8137 VSS.n8136 1.62242
R18984 VSS.n8161 VSS.n140 1.62242
R18985 VSS.n8243 VSS.n8242 1.62242
R18986 VSS.n8268 VSS.n8267 1.62242
R18987 VSS.n8683 VSS.n8652 1.62242
R18988 VSS.n8751 VSS.n8750 1.62242
R18989 VSS.n8775 VSS.n142 1.62242
R18990 VSS.n8857 VSS.n8856 1.62242
R18991 VSS.n8881 VSS.n143 1.62242
R18992 VSS.n8963 VSS.n8962 1.62242
R18993 VSS.n8987 VSS.n144 1.62242
R18994 VSS.n9069 VSS.n9068 1.62242
R18995 VSS.n9093 VSS.n145 1.62242
R18996 VSS.n9175 VSS.n9174 1.62242
R18997 VSS.n9199 VSS.n146 1.62242
R18998 VSS.n9281 VSS.n9280 1.62242
R18999 VSS.n9306 VSS.n9305 1.62242
R19000 VSS.n10032 VSS.n10001 1.62242
R19001 VSS.n9951 VSS.n1931 1.62242
R19002 VSS.n9929 VSS.n1942 1.62242
R19003 VSS.n9850 VSS.n1981 1.62242
R19004 VSS.n9828 VSS.n1992 1.62242
R19005 VSS.n9749 VSS.n2031 1.62242
R19006 VSS.n9727 VSS.n2042 1.62242
R19007 VSS.n9648 VSS.n2081 1.62242
R19008 VSS.n9626 VSS.n2092 1.62242
R19009 VSS.n9547 VSS.n2131 1.62242
R19010 VSS.n9525 VSS.n2142 1.62242
R19011 VSS.n9446 VSS.n2181 1.62242
R19012 VSS.n9424 VSS.n2192 1.62242
R19013 VSS.n11074 VSS.n11043 1.62242
R19014 VSS.n10993 VSS.n10085 1.62242
R19015 VSS.n10971 VSS.n10096 1.62242
R19016 VSS.n10892 VSS.n10135 1.62242
R19017 VSS.n10870 VSS.n10146 1.62242
R19018 VSS.n10791 VSS.n10185 1.62242
R19019 VSS.n10769 VSS.n10196 1.62242
R19020 VSS.n10690 VSS.n10235 1.62242
R19021 VSS.n10668 VSS.n10246 1.62242
R19022 VSS.n10589 VSS.n10285 1.62242
R19023 VSS.n10567 VSS.n10296 1.62242
R19024 VSS.n10488 VSS.n10335 1.62242
R19025 VSS.n10466 VSS.n10346 1.62242
R19026 VSS.n11160 VSS.n11129 1.62242
R19027 VSS.n11233 VSS.n11232 1.62242
R19028 VSS.n11257 VSS.n148 1.62242
R19029 VSS.n11339 VSS.n11338 1.62242
R19030 VSS.n11363 VSS.n149 1.62242
R19031 VSS.n11445 VSS.n11444 1.62242
R19032 VSS.n11469 VSS.n150 1.62242
R19033 VSS.n11551 VSS.n11550 1.62242
R19034 VSS.n11575 VSS.n151 1.62242
R19035 VSS.n11657 VSS.n11656 1.62242
R19036 VSS.n11681 VSS.n152 1.62242
R19037 VSS.n11763 VSS.n11762 1.62242
R19038 VSS.n11788 VSS.n11787 1.62242
R19039 VSS.n12203 VSS.n12172 1.62242
R19040 VSS.n12271 VSS.n12270 1.62242
R19041 VSS.n12295 VSS.n154 1.62242
R19042 VSS.n12377 VSS.n12376 1.62242
R19043 VSS.n12401 VSS.n155 1.62242
R19044 VSS.n12483 VSS.n12482 1.62242
R19045 VSS.n12507 VSS.n156 1.62242
R19046 VSS.n12589 VSS.n12588 1.62242
R19047 VSS.n12613 VSS.n157 1.62242
R19048 VSS.n12695 VSS.n12694 1.62242
R19049 VSS.n12719 VSS.n158 1.62242
R19050 VSS.n12801 VSS.n12800 1.62242
R19051 VSS.n12826 VSS.n12825 1.62242
R19052 VSS.n13552 VSS.n13521 1.62242
R19053 VSS.n13471 VSS.n1290 1.62242
R19054 VSS.n13449 VSS.n1301 1.62242
R19055 VSS.n13370 VSS.n1340 1.62242
R19056 VSS.n13348 VSS.n1351 1.62242
R19057 VSS.n13269 VSS.n1390 1.62242
R19058 VSS.n13247 VSS.n1401 1.62242
R19059 VSS.n13168 VSS.n1440 1.62242
R19060 VSS.n13146 VSS.n1451 1.62242
R19061 VSS.n13067 VSS.n1490 1.62242
R19062 VSS.n13045 VSS.n1501 1.62242
R19063 VSS.n12966 VSS.n1540 1.62242
R19064 VSS.n12944 VSS.n1551 1.62242
R19065 VSS.n14517 VSS.n14486 1.62242
R19066 VSS.n14436 VSS.n13605 1.62242
R19067 VSS.n14414 VSS.n13616 1.62242
R19068 VSS.n14204 VSS.n14203 1.62242
R19069 VSS.n14076 VSS.n13772 1.62242
R19070 VSS.n14054 VSS.n13783 1.62242
R19071 VSS.n13975 VSS.n13822 1.62242
R19072 VSS.n13953 VSS.n13833 1.62242
R19073 VSS.n14600 VSS.n14569 1.62242
R19074 VSS.n14673 VSS.n14672 1.62242
R19075 VSS.n14697 VSS.n160 1.62242
R19076 VSS.t173 VSS.n14852 1.50638
R19077 VSS.n15021 VSS.t118 1.50638
R19078 VSS.t691 VSS.t4273 1.49758
R19079 VSS.n14303 VSS.t3396 1.49091
R19080 VSS.t433 VSS.n14831 1.44096
R19081 VSS.n5826 VSS.t2681 1.39686
R19082 VSS.n5849 VSS.t2684 1.39686
R19083 VSS.t2466 VSS.n4787 1.39686
R19084 VSS.t2469 VSS.n4773 1.39686
R19085 VSS.t2251 VSS.n6868 1.39686
R19086 VSS.t2254 VSS.n6854 1.39686
R19087 VSS.n8308 VSS.t2036 1.39686
R19088 VSS.n8331 VSS.t2039 1.39686
R19089 VSS.n9346 VSS.t1821 1.39686
R19090 VSS.n9369 VSS.t1824 1.39686
R19091 VSS.t1388 VSS.n10388 1.39686
R19092 VSS.t1391 VSS.n10374 1.39686
R19093 VSS.n11828 VSS.t1173 1.39686
R19094 VSS.n11851 VSS.t1176 1.39686
R19095 VSS.n12866 VSS.t958 1.39686
R19096 VSS.n12889 VSS.t961 1.39686
R19097 VSS.t743 VSS.n1593 1.39686
R19098 VSS.t746 VSS.n1579 1.39686
R19099 VSS.t548 VSS.n13875 1.39686
R19100 VSS.t551 VSS.n13861 1.39686
R19101 VSS.t400 VSS.n15171 1.39686
R19102 VSS.t403 VSS.n15157 1.39686
R19103 VSS.t415 VSS.n14973 1.39686
R19104 VSS.n14998 VSS.t412 1.39686
R19105 VSS.n3773 VSS.n3750 1.32068
R19106 VSS.n3774 VSS.n3773 1.32068
R19107 VSS.n4426 VSS.n4403 1.32068
R19108 VSS.n4422 VSS.n4403 1.32068
R19109 VSS.n4454 VSS.n59 1.32068
R19110 VSS.n4455 VSS.n4454 1.32068
R19111 VSS.n4387 VSS.n4376 1.32068
R19112 VSS.n4387 VSS.n4386 1.32068
R19113 VSS.n4359 VSS.n3457 1.32068
R19114 VSS.n4360 VSS.n4359 1.32068
R19115 VSS.n4306 VSS.n3489 1.32068
R19116 VSS.n4307 VSS.n4306 1.32068
R19117 VSS.n4281 VSS.n4280 1.32068
R19118 VSS.n4281 VSS.n3495 1.32068
R19119 VSS.n4258 VSS.n3507 1.32068
R19120 VSS.n4259 VSS.n4258 1.32068
R19121 VSS.n4205 VSS.n3539 1.32068
R19122 VSS.n4206 VSS.n4205 1.32068
R19123 VSS.n4180 VSS.n4179 1.32068
R19124 VSS.n4180 VSS.n3545 1.32068
R19125 VSS.n4157 VSS.n3557 1.32068
R19126 VSS.n4158 VSS.n4157 1.32068
R19127 VSS.n4104 VSS.n3589 1.32068
R19128 VSS.n4105 VSS.n4104 1.32068
R19129 VSS.n4079 VSS.n4078 1.32068
R19130 VSS.n4079 VSS.n3595 1.32068
R19131 VSS.n4056 VSS.n3607 1.32068
R19132 VSS.n4057 VSS.n4056 1.32068
R19133 VSS.n4003 VSS.n3639 1.32068
R19134 VSS.n4004 VSS.n4003 1.32068
R19135 VSS.n3978 VSS.n3977 1.32068
R19136 VSS.n3978 VSS.n3645 1.32068
R19137 VSS.n3955 VSS.n3657 1.32068
R19138 VSS.n3956 VSS.n3955 1.32068
R19139 VSS.n3902 VSS.n3689 1.32068
R19140 VSS.n3903 VSS.n3902 1.32068
R19141 VSS.n3877 VSS.n3876 1.32068
R19142 VSS.n3877 VSS.n3695 1.32068
R19143 VSS.n3854 VSS.n3707 1.32068
R19144 VSS.n3855 VSS.n3854 1.32068
R19145 VSS.n5158 VSS.n5135 1.32068
R19146 VSS.n5154 VSS.n5135 1.32068
R19147 VSS.n5187 VSS.n5113 1.32068
R19148 VSS.n5186 VSS.n5113 1.32068
R19149 VSS.n5198 VSS.n5101 1.32068
R19150 VSS.n5198 VSS.n5197 1.32068
R19151 VSS.n5223 VSS.n5222 1.32068
R19152 VSS.n5222 VSS.n5092 1.32068
R19153 VSS.n5282 VSS.n5070 1.32068
R19154 VSS.n5283 VSS.n5282 1.32068
R19155 VSS.n5304 VSS.n5059 1.32068
R19156 VSS.n5304 VSS.n5303 1.32068
R19157 VSS.n5329 VSS.n5328 1.32068
R19158 VSS.n5328 VSS.n5050 1.32068
R19159 VSS.n5388 VSS.n5028 1.32068
R19160 VSS.n5389 VSS.n5388 1.32068
R19161 VSS.n5410 VSS.n5017 1.32068
R19162 VSS.n5410 VSS.n5409 1.32068
R19163 VSS.n5435 VSS.n5434 1.32068
R19164 VSS.n5434 VSS.n5008 1.32068
R19165 VSS.n5494 VSS.n4986 1.32068
R19166 VSS.n5495 VSS.n5494 1.32068
R19167 VSS.n5516 VSS.n4975 1.32068
R19168 VSS.n5516 VSS.n5515 1.32068
R19169 VSS.n5541 VSS.n5540 1.32068
R19170 VSS.n5540 VSS.n4966 1.32068
R19171 VSS.n5600 VSS.n4944 1.32068
R19172 VSS.n5601 VSS.n5600 1.32068
R19173 VSS.n5622 VSS.n4933 1.32068
R19174 VSS.n5622 VSS.n5621 1.32068
R19175 VSS.n5647 VSS.n5646 1.32068
R19176 VSS.n5646 VSS.n4924 1.32068
R19177 VSS.n5706 VSS.n4902 1.32068
R19178 VSS.n5707 VSS.n5706 1.32068
R19179 VSS.n5728 VSS.n4891 1.32068
R19180 VSS.n5728 VSS.n5727 1.32068
R19181 VSS.n5753 VSS.n5752 1.32068
R19182 VSS.n5752 VSS.n4882 1.32068
R19183 VSS.n6507 VSS.n6484 1.32068
R19184 VSS.n6503 VSS.n6484 1.32068
R19185 VSS.n6535 VSS.n60 1.32068
R19186 VSS.n6536 VSS.n6535 1.32068
R19187 VSS.n6468 VSS.n6457 1.32068
R19188 VSS.n6468 VSS.n6467 1.32068
R19189 VSS.n6440 VSS.n4480 1.32068
R19190 VSS.n6441 VSS.n6440 1.32068
R19191 VSS.n6387 VSS.n4512 1.32068
R19192 VSS.n6388 VSS.n6387 1.32068
R19193 VSS.n6362 VSS.n6361 1.32068
R19194 VSS.n6362 VSS.n4518 1.32068
R19195 VSS.n6339 VSS.n4530 1.32068
R19196 VSS.n6340 VSS.n6339 1.32068
R19197 VSS.n6286 VSS.n4562 1.32068
R19198 VSS.n6287 VSS.n6286 1.32068
R19199 VSS.n6261 VSS.n6260 1.32068
R19200 VSS.n6261 VSS.n4568 1.32068
R19201 VSS.n6238 VSS.n4580 1.32068
R19202 VSS.n6239 VSS.n6238 1.32068
R19203 VSS.n6185 VSS.n4612 1.32068
R19204 VSS.n6186 VSS.n6185 1.32068
R19205 VSS.n6160 VSS.n6159 1.32068
R19206 VSS.n6160 VSS.n4618 1.32068
R19207 VSS.n6137 VSS.n4630 1.32068
R19208 VSS.n6138 VSS.n6137 1.32068
R19209 VSS.n6084 VSS.n4662 1.32068
R19210 VSS.n6085 VSS.n6084 1.32068
R19211 VSS.n6059 VSS.n6058 1.32068
R19212 VSS.n6059 VSS.n4668 1.32068
R19213 VSS.n6036 VSS.n4680 1.32068
R19214 VSS.n6037 VSS.n6036 1.32068
R19215 VSS.n5983 VSS.n4712 1.32068
R19216 VSS.n5984 VSS.n5983 1.32068
R19217 VSS.n5958 VSS.n5957 1.32068
R19218 VSS.n5958 VSS.n4718 1.32068
R19219 VSS.n5935 VSS.n4730 1.32068
R19220 VSS.n5936 VSS.n5935 1.32068
R19221 VSS.n7549 VSS.n7526 1.32068
R19222 VSS.n7545 VSS.n7526 1.32068
R19223 VSS.n7577 VSS.n61 1.32068
R19224 VSS.n7578 VSS.n7577 1.32068
R19225 VSS.n7510 VSS.n7499 1.32068
R19226 VSS.n7510 VSS.n7509 1.32068
R19227 VSS.n7482 VSS.n6561 1.32068
R19228 VSS.n7483 VSS.n7482 1.32068
R19229 VSS.n7429 VSS.n6593 1.32068
R19230 VSS.n7430 VSS.n7429 1.32068
R19231 VSS.n7404 VSS.n7403 1.32068
R19232 VSS.n7404 VSS.n6599 1.32068
R19233 VSS.n7381 VSS.n6611 1.32068
R19234 VSS.n7382 VSS.n7381 1.32068
R19235 VSS.n7328 VSS.n6643 1.32068
R19236 VSS.n7329 VSS.n7328 1.32068
R19237 VSS.n7303 VSS.n7302 1.32068
R19238 VSS.n7303 VSS.n6649 1.32068
R19239 VSS.n7280 VSS.n6661 1.32068
R19240 VSS.n7281 VSS.n7280 1.32068
R19241 VSS.n7227 VSS.n6693 1.32068
R19242 VSS.n7228 VSS.n7227 1.32068
R19243 VSS.n7202 VSS.n7201 1.32068
R19244 VSS.n7202 VSS.n6699 1.32068
R19245 VSS.n7179 VSS.n6711 1.32068
R19246 VSS.n7180 VSS.n7179 1.32068
R19247 VSS.n7126 VSS.n6743 1.32068
R19248 VSS.n7127 VSS.n7126 1.32068
R19249 VSS.n7101 VSS.n7100 1.32068
R19250 VSS.n7101 VSS.n6749 1.32068
R19251 VSS.n7078 VSS.n6761 1.32068
R19252 VSS.n7079 VSS.n7078 1.32068
R19253 VSS.n7025 VSS.n6793 1.32068
R19254 VSS.n7026 VSS.n7025 1.32068
R19255 VSS.n7000 VSS.n6999 1.32068
R19256 VSS.n7000 VSS.n6799 1.32068
R19257 VSS.n6977 VSS.n6811 1.32068
R19258 VSS.n6978 VSS.n6977 1.32068
R19259 VSS.n7635 VSS.n7612 1.32068
R19260 VSS.n7631 VSS.n7612 1.32068
R19261 VSS.n7663 VSS.n62 1.32068
R19262 VSS.n7664 VSS.n7663 1.32068
R19263 VSS.n7680 VSS.n2529 1.32068
R19264 VSS.n7680 VSS.n7679 1.32068
R19265 VSS.n7705 VSS.n7704 1.32068
R19266 VSS.n7704 VSS.n2520 1.32068
R19267 VSS.n7764 VSS.n2498 1.32068
R19268 VSS.n7765 VSS.n7764 1.32068
R19269 VSS.n7786 VSS.n2487 1.32068
R19270 VSS.n7786 VSS.n7785 1.32068
R19271 VSS.n7811 VSS.n7810 1.32068
R19272 VSS.n7810 VSS.n2478 1.32068
R19273 VSS.n7870 VSS.n2456 1.32068
R19274 VSS.n7871 VSS.n7870 1.32068
R19275 VSS.n7892 VSS.n2445 1.32068
R19276 VSS.n7892 VSS.n7891 1.32068
R19277 VSS.n7917 VSS.n7916 1.32068
R19278 VSS.n7916 VSS.n2436 1.32068
R19279 VSS.n7976 VSS.n2414 1.32068
R19280 VSS.n7977 VSS.n7976 1.32068
R19281 VSS.n7998 VSS.n2403 1.32068
R19282 VSS.n7998 VSS.n7997 1.32068
R19283 VSS.n8023 VSS.n8022 1.32068
R19284 VSS.n8022 VSS.n2394 1.32068
R19285 VSS.n8082 VSS.n2372 1.32068
R19286 VSS.n8083 VSS.n8082 1.32068
R19287 VSS.n8104 VSS.n2361 1.32068
R19288 VSS.n8104 VSS.n8103 1.32068
R19289 VSS.n8129 VSS.n8128 1.32068
R19290 VSS.n8128 VSS.n2352 1.32068
R19291 VSS.n8188 VSS.n2330 1.32068
R19292 VSS.n8189 VSS.n8188 1.32068
R19293 VSS.n8210 VSS.n2319 1.32068
R19294 VSS.n8210 VSS.n8209 1.32068
R19295 VSS.n8235 VSS.n8234 1.32068
R19296 VSS.n8234 VSS.n2310 1.32068
R19297 VSS.n8678 VSS.n8655 1.32068
R19298 VSS.n8674 VSS.n8655 1.32068
R19299 VSS.n8707 VSS.n8633 1.32068
R19300 VSS.n8706 VSS.n8633 1.32068
R19301 VSS.n8718 VSS.n8621 1.32068
R19302 VSS.n8718 VSS.n8717 1.32068
R19303 VSS.n8743 VSS.n8742 1.32068
R19304 VSS.n8742 VSS.n8612 1.32068
R19305 VSS.n8802 VSS.n8590 1.32068
R19306 VSS.n8803 VSS.n8802 1.32068
R19307 VSS.n8824 VSS.n8579 1.32068
R19308 VSS.n8824 VSS.n8823 1.32068
R19309 VSS.n8849 VSS.n8848 1.32068
R19310 VSS.n8848 VSS.n8570 1.32068
R19311 VSS.n8908 VSS.n8548 1.32068
R19312 VSS.n8909 VSS.n8908 1.32068
R19313 VSS.n8930 VSS.n8537 1.32068
R19314 VSS.n8930 VSS.n8929 1.32068
R19315 VSS.n8955 VSS.n8954 1.32068
R19316 VSS.n8954 VSS.n8528 1.32068
R19317 VSS.n9014 VSS.n8506 1.32068
R19318 VSS.n9015 VSS.n9014 1.32068
R19319 VSS.n9036 VSS.n8495 1.32068
R19320 VSS.n9036 VSS.n9035 1.32068
R19321 VSS.n9061 VSS.n9060 1.32068
R19322 VSS.n9060 VSS.n8486 1.32068
R19323 VSS.n9120 VSS.n8464 1.32068
R19324 VSS.n9121 VSS.n9120 1.32068
R19325 VSS.n9142 VSS.n8453 1.32068
R19326 VSS.n9142 VSS.n9141 1.32068
R19327 VSS.n9167 VSS.n9166 1.32068
R19328 VSS.n9166 VSS.n8444 1.32068
R19329 VSS.n9226 VSS.n8422 1.32068
R19330 VSS.n9227 VSS.n9226 1.32068
R19331 VSS.n9248 VSS.n8411 1.32068
R19332 VSS.n9248 VSS.n9247 1.32068
R19333 VSS.n9273 VSS.n9272 1.32068
R19334 VSS.n9272 VSS.n8402 1.32068
R19335 VSS.n2243 VSS.n2220 1.32068
R19336 VSS.n2244 VSS.n2243 1.32068
R19337 VSS.n10027 VSS.n10004 1.32068
R19338 VSS.n10023 VSS.n10004 1.32068
R19339 VSS.n10055 VSS.n63 1.32068
R19340 VSS.n10056 VSS.n10055 1.32068
R19341 VSS.n9988 VSS.n9977 1.32068
R19342 VSS.n9988 VSS.n9987 1.32068
R19343 VSS.n9960 VSS.n1927 1.32068
R19344 VSS.n9961 VSS.n9960 1.32068
R19345 VSS.n9907 VSS.n1959 1.32068
R19346 VSS.n9908 VSS.n9907 1.32068
R19347 VSS.n9882 VSS.n9881 1.32068
R19348 VSS.n9882 VSS.n1965 1.32068
R19349 VSS.n9859 VSS.n1977 1.32068
R19350 VSS.n9860 VSS.n9859 1.32068
R19351 VSS.n9806 VSS.n2009 1.32068
R19352 VSS.n9807 VSS.n9806 1.32068
R19353 VSS.n9781 VSS.n9780 1.32068
R19354 VSS.n9781 VSS.n2015 1.32068
R19355 VSS.n9758 VSS.n2027 1.32068
R19356 VSS.n9759 VSS.n9758 1.32068
R19357 VSS.n9705 VSS.n2059 1.32068
R19358 VSS.n9706 VSS.n9705 1.32068
R19359 VSS.n9680 VSS.n9679 1.32068
R19360 VSS.n9680 VSS.n2065 1.32068
R19361 VSS.n9657 VSS.n2077 1.32068
R19362 VSS.n9658 VSS.n9657 1.32068
R19363 VSS.n9604 VSS.n2109 1.32068
R19364 VSS.n9605 VSS.n9604 1.32068
R19365 VSS.n9579 VSS.n9578 1.32068
R19366 VSS.n9579 VSS.n2115 1.32068
R19367 VSS.n9556 VSS.n2127 1.32068
R19368 VSS.n9557 VSS.n9556 1.32068
R19369 VSS.n9503 VSS.n2159 1.32068
R19370 VSS.n9504 VSS.n9503 1.32068
R19371 VSS.n9478 VSS.n9477 1.32068
R19372 VSS.n9478 VSS.n2165 1.32068
R19373 VSS.n9455 VSS.n2177 1.32068
R19374 VSS.n9456 VSS.n9455 1.32068
R19375 VSS.n11069 VSS.n11046 1.32068
R19376 VSS.n11065 VSS.n11046 1.32068
R19377 VSS.n11097 VSS.n64 1.32068
R19378 VSS.n11098 VSS.n11097 1.32068
R19379 VSS.n11030 VSS.n11019 1.32068
R19380 VSS.n11030 VSS.n11029 1.32068
R19381 VSS.n11002 VSS.n10081 1.32068
R19382 VSS.n11003 VSS.n11002 1.32068
R19383 VSS.n10949 VSS.n10113 1.32068
R19384 VSS.n10950 VSS.n10949 1.32068
R19385 VSS.n10924 VSS.n10923 1.32068
R19386 VSS.n10924 VSS.n10119 1.32068
R19387 VSS.n10901 VSS.n10131 1.32068
R19388 VSS.n10902 VSS.n10901 1.32068
R19389 VSS.n10848 VSS.n10163 1.32068
R19390 VSS.n10849 VSS.n10848 1.32068
R19391 VSS.n10823 VSS.n10822 1.32068
R19392 VSS.n10823 VSS.n10169 1.32068
R19393 VSS.n10800 VSS.n10181 1.32068
R19394 VSS.n10801 VSS.n10800 1.32068
R19395 VSS.n10747 VSS.n10213 1.32068
R19396 VSS.n10748 VSS.n10747 1.32068
R19397 VSS.n10722 VSS.n10721 1.32068
R19398 VSS.n10722 VSS.n10219 1.32068
R19399 VSS.n10699 VSS.n10231 1.32068
R19400 VSS.n10700 VSS.n10699 1.32068
R19401 VSS.n10646 VSS.n10263 1.32068
R19402 VSS.n10647 VSS.n10646 1.32068
R19403 VSS.n10621 VSS.n10620 1.32068
R19404 VSS.n10621 VSS.n10269 1.32068
R19405 VSS.n10598 VSS.n10281 1.32068
R19406 VSS.n10599 VSS.n10598 1.32068
R19407 VSS.n10545 VSS.n10313 1.32068
R19408 VSS.n10546 VSS.n10545 1.32068
R19409 VSS.n10520 VSS.n10519 1.32068
R19410 VSS.n10520 VSS.n10319 1.32068
R19411 VSS.n10497 VSS.n10331 1.32068
R19412 VSS.n10498 VSS.n10497 1.32068
R19413 VSS.n11155 VSS.n11132 1.32068
R19414 VSS.n11151 VSS.n11132 1.32068
R19415 VSS.n11183 VSS.n65 1.32068
R19416 VSS.n11184 VSS.n11183 1.32068
R19417 VSS.n11200 VSS.n1907 1.32068
R19418 VSS.n11200 VSS.n11199 1.32068
R19419 VSS.n11225 VSS.n11224 1.32068
R19420 VSS.n11224 VSS.n1898 1.32068
R19421 VSS.n11284 VSS.n1876 1.32068
R19422 VSS.n11285 VSS.n11284 1.32068
R19423 VSS.n11306 VSS.n1865 1.32068
R19424 VSS.n11306 VSS.n11305 1.32068
R19425 VSS.n11331 VSS.n11330 1.32068
R19426 VSS.n11330 VSS.n1856 1.32068
R19427 VSS.n11390 VSS.n1834 1.32068
R19428 VSS.n11391 VSS.n11390 1.32068
R19429 VSS.n11412 VSS.n1823 1.32068
R19430 VSS.n11412 VSS.n11411 1.32068
R19431 VSS.n11437 VSS.n11436 1.32068
R19432 VSS.n11436 VSS.n1814 1.32068
R19433 VSS.n11496 VSS.n1792 1.32068
R19434 VSS.n11497 VSS.n11496 1.32068
R19435 VSS.n11518 VSS.n1781 1.32068
R19436 VSS.n11518 VSS.n11517 1.32068
R19437 VSS.n11543 VSS.n11542 1.32068
R19438 VSS.n11542 VSS.n1772 1.32068
R19439 VSS.n11602 VSS.n1750 1.32068
R19440 VSS.n11603 VSS.n11602 1.32068
R19441 VSS.n11624 VSS.n1739 1.32068
R19442 VSS.n11624 VSS.n11623 1.32068
R19443 VSS.n11649 VSS.n11648 1.32068
R19444 VSS.n11648 VSS.n1730 1.32068
R19445 VSS.n11708 VSS.n1708 1.32068
R19446 VSS.n11709 VSS.n11708 1.32068
R19447 VSS.n11730 VSS.n1697 1.32068
R19448 VSS.n11730 VSS.n11729 1.32068
R19449 VSS.n11755 VSS.n11754 1.32068
R19450 VSS.n11754 VSS.n1688 1.32068
R19451 VSS.n12198 VSS.n12175 1.32068
R19452 VSS.n12194 VSS.n12175 1.32068
R19453 VSS.n12227 VSS.n12153 1.32068
R19454 VSS.n12226 VSS.n12153 1.32068
R19455 VSS.n12238 VSS.n12141 1.32068
R19456 VSS.n12238 VSS.n12237 1.32068
R19457 VSS.n12263 VSS.n12262 1.32068
R19458 VSS.n12262 VSS.n12132 1.32068
R19459 VSS.n12322 VSS.n12110 1.32068
R19460 VSS.n12323 VSS.n12322 1.32068
R19461 VSS.n12344 VSS.n12099 1.32068
R19462 VSS.n12344 VSS.n12343 1.32068
R19463 VSS.n12369 VSS.n12368 1.32068
R19464 VSS.n12368 VSS.n12090 1.32068
R19465 VSS.n12428 VSS.n12068 1.32068
R19466 VSS.n12429 VSS.n12428 1.32068
R19467 VSS.n12450 VSS.n12057 1.32068
R19468 VSS.n12450 VSS.n12449 1.32068
R19469 VSS.n12475 VSS.n12474 1.32068
R19470 VSS.n12474 VSS.n12048 1.32068
R19471 VSS.n12534 VSS.n12026 1.32068
R19472 VSS.n12535 VSS.n12534 1.32068
R19473 VSS.n12556 VSS.n12015 1.32068
R19474 VSS.n12556 VSS.n12555 1.32068
R19475 VSS.n12581 VSS.n12580 1.32068
R19476 VSS.n12580 VSS.n12006 1.32068
R19477 VSS.n12640 VSS.n11984 1.32068
R19478 VSS.n12641 VSS.n12640 1.32068
R19479 VSS.n12662 VSS.n11973 1.32068
R19480 VSS.n12662 VSS.n12661 1.32068
R19481 VSS.n12687 VSS.n12686 1.32068
R19482 VSS.n12686 VSS.n11964 1.32068
R19483 VSS.n12746 VSS.n11942 1.32068
R19484 VSS.n12747 VSS.n12746 1.32068
R19485 VSS.n12768 VSS.n11931 1.32068
R19486 VSS.n12768 VSS.n12767 1.32068
R19487 VSS.n12793 VSS.n12792 1.32068
R19488 VSS.n12792 VSS.n11922 1.32068
R19489 VSS.n13547 VSS.n13524 1.32068
R19490 VSS.n13543 VSS.n13524 1.32068
R19491 VSS.n13575 VSS.n66 1.32068
R19492 VSS.n13576 VSS.n13575 1.32068
R19493 VSS.n13508 VSS.n13497 1.32068
R19494 VSS.n13508 VSS.n13507 1.32068
R19495 VSS.n13480 VSS.n1286 1.32068
R19496 VSS.n13481 VSS.n13480 1.32068
R19497 VSS.n13427 VSS.n1318 1.32068
R19498 VSS.n13428 VSS.n13427 1.32068
R19499 VSS.n13402 VSS.n13401 1.32068
R19500 VSS.n13402 VSS.n1324 1.32068
R19501 VSS.n13379 VSS.n1336 1.32068
R19502 VSS.n13380 VSS.n13379 1.32068
R19503 VSS.n13326 VSS.n1368 1.32068
R19504 VSS.n13327 VSS.n13326 1.32068
R19505 VSS.n13301 VSS.n13300 1.32068
R19506 VSS.n13301 VSS.n1374 1.32068
R19507 VSS.n13278 VSS.n1386 1.32068
R19508 VSS.n13279 VSS.n13278 1.32068
R19509 VSS.n13225 VSS.n1418 1.32068
R19510 VSS.n13226 VSS.n13225 1.32068
R19511 VSS.n13200 VSS.n13199 1.32068
R19512 VSS.n13200 VSS.n1424 1.32068
R19513 VSS.n13177 VSS.n1436 1.32068
R19514 VSS.n13178 VSS.n13177 1.32068
R19515 VSS.n13124 VSS.n1468 1.32068
R19516 VSS.n13125 VSS.n13124 1.32068
R19517 VSS.n13099 VSS.n13098 1.32068
R19518 VSS.n13099 VSS.n1474 1.32068
R19519 VSS.n13076 VSS.n1486 1.32068
R19520 VSS.n13077 VSS.n13076 1.32068
R19521 VSS.n13023 VSS.n1518 1.32068
R19522 VSS.n13024 VSS.n13023 1.32068
R19523 VSS.n12998 VSS.n12997 1.32068
R19524 VSS.n12998 VSS.n1524 1.32068
R19525 VSS.n12975 VSS.n1536 1.32068
R19526 VSS.n12976 VSS.n12975 1.32068
R19527 VSS.n14512 VSS.n14489 1.32068
R19528 VSS.n14508 VSS.n14489 1.32068
R19529 VSS.n14540 VSS.n67 1.32068
R19530 VSS.n14541 VSS.n14540 1.32068
R19531 VSS.n14473 VSS.n14462 1.32068
R19532 VSS.n14473 VSS.n14472 1.32068
R19533 VSS.n14445 VSS.n13601 1.32068
R19534 VSS.n14446 VSS.n14445 1.32068
R19535 VSS.n14392 VSS.n13633 1.32068
R19536 VSS.n14393 VSS.n14392 1.32068
R19537 VSS.n14367 VSS.n14366 1.32068
R19538 VSS.n14367 VSS.n13639 1.32068
R19539 VSS.n14349 VSS.n13651 1.32068
R19540 VSS.n14350 VSS.n14349 1.32068
R19541 VSS.n14273 VSS.n14272 1.32068
R19542 VSS.n14273 VSS.n13715 1.32068
R19543 VSS.n14226 VSS.n13735 1.32068
R19544 VSS.n14227 VSS.n14226 1.32068
R19545 VSS.n14196 VSS.n14195 1.32068
R19546 VSS.n14195 VSS.n14152 1.32068
R19547 VSS.n14133 VSS.n13750 1.32068
R19548 VSS.n14134 VSS.n14133 1.32068
R19549 VSS.n14108 VSS.n14107 1.32068
R19550 VSS.n14108 VSS.n13756 1.32068
R19551 VSS.n14085 VSS.n13768 1.32068
R19552 VSS.n14086 VSS.n14085 1.32068
R19553 VSS.n14032 VSS.n13800 1.32068
R19554 VSS.n14033 VSS.n14032 1.32068
R19555 VSS.n14007 VSS.n14006 1.32068
R19556 VSS.n14007 VSS.n13806 1.32068
R19557 VSS.n13984 VSS.n13818 1.32068
R19558 VSS.n13985 VSS.n13984 1.32068
R19559 VSS.n14595 VSS.n14572 1.32068
R19560 VSS.n14591 VSS.n14572 1.32068
R19561 VSS.n14623 VSS.n68 1.32068
R19562 VSS.n14624 VSS.n14623 1.32068
R19563 VSS.n14640 VSS.n455 1.32068
R19564 VSS.n14640 VSS.n14639 1.32068
R19565 VSS.n14665 VSS.n14664 1.32068
R19566 VSS.n14664 VSS.n446 1.32068
R19567 VSS.t3521 VSS.t3007 1.30741
R19568 VSS.t3102 VSS.n4461 1.30741
R19569 VSS.n4296 VSS.t3087 1.30741
R19570 VSS.n4195 VSS.t3072 1.30741
R19571 VSS.n4094 VSS.t3057 1.30741
R19572 VSS.n3993 VSS.t3042 1.30741
R19573 VSS.n3892 VSS.t3027 1.30741
R19574 VSS.n5109 VSS.t2884 1.30741
R19575 VSS.n5293 VSS.t2869 1.30741
R19576 VSS.n5399 VSS.t2854 1.30741
R19577 VSS.n5505 VSS.t2839 1.30741
R19578 VSS.n5611 VSS.t2824 1.30741
R19579 VSS.n5717 VSS.t2809 1.30741
R19580 VSS.t2669 VSS.n6542 1.30741
R19581 VSS.n6377 VSS.t2654 1.30741
R19582 VSS.n6276 VSS.t2639 1.30741
R19583 VSS.n6175 VSS.t2624 1.30741
R19584 VSS.n6074 VSS.t2609 1.30741
R19585 VSS.n5973 VSS.t2594 1.30741
R19586 VSS.t2454 VSS.n7584 1.30741
R19587 VSS.n7419 VSS.t2439 1.30741
R19588 VSS.n7318 VSS.t2424 1.30741
R19589 VSS.n7217 VSS.t2409 1.30741
R19590 VSS.n7116 VSS.t2394 1.30741
R19591 VSS.n7015 VSS.t2379 1.30741
R19592 VSS.n7670 VSS.t2239 1.30741
R19593 VSS.n7775 VSS.t2224 1.30741
R19594 VSS.n7881 VSS.t2209 1.30741
R19595 VSS.n7987 VSS.t2194 1.30741
R19596 VSS.n8093 VSS.t2179 1.30741
R19597 VSS.n8199 VSS.t2164 1.30741
R19598 VSS.n8629 VSS.t2024 1.30741
R19599 VSS.n8813 VSS.t2009 1.30741
R19600 VSS.n8919 VSS.t1994 1.30741
R19601 VSS.n9025 VSS.t1979 1.30741
R19602 VSS.n9131 VSS.t1964 1.30741
R19603 VSS.n9237 VSS.t1949 1.30741
R19604 VSS.t3941 VSS.t1714 1.30741
R19605 VSS.t1809 VSS.n10062 1.30741
R19606 VSS.n9897 VSS.t1794 1.30741
R19607 VSS.n9796 VSS.t1779 1.30741
R19608 VSS.n9695 VSS.t1764 1.30741
R19609 VSS.n9594 VSS.t1749 1.30741
R19610 VSS.n9493 VSS.t1734 1.30741
R19611 VSS.t1591 VSS.n11104 1.30741
R19612 VSS.n10939 VSS.t1576 1.30741
R19613 VSS.n10838 VSS.t1561 1.30741
R19614 VSS.n10737 VSS.t1546 1.30741
R19615 VSS.n10636 VSS.t1531 1.30741
R19616 VSS.n10535 VSS.t1516 1.30741
R19617 VSS.n11190 VSS.t1376 1.30741
R19618 VSS.n11295 VSS.t1361 1.30741
R19619 VSS.n11401 VSS.t1346 1.30741
R19620 VSS.n11507 VSS.t1331 1.30741
R19621 VSS.n11613 VSS.t1316 1.30741
R19622 VSS.n11719 VSS.t1301 1.30741
R19623 VSS.n12149 VSS.t1161 1.30741
R19624 VSS.n12333 VSS.t1146 1.30741
R19625 VSS.n12439 VSS.t1131 1.30741
R19626 VSS.n12545 VSS.t1116 1.30741
R19627 VSS.n12651 VSS.t1101 1.30741
R19628 VSS.n12757 VSS.t1086 1.30741
R19629 VSS.t946 VSS.n13582 1.30741
R19630 VSS.n13417 VSS.t931 1.30741
R19631 VSS.n13316 VSS.t916 1.30741
R19632 VSS.n13215 VSS.t901 1.30741
R19633 VSS.n13114 VSS.t886 1.30741
R19634 VSS.n13013 VSS.t871 1.30741
R19635 VSS.t731 VSS.n14547 1.30741
R19636 VSS.n14382 VSS.t716 1.30741
R19637 VSS.n14123 VSS.t676 1.30741
R19638 VSS.n14022 VSS.t661 1.30741
R19639 VSS.n14630 VSS.t536 1.30741
R19640 VSS.t2678 VSS.n5822 1.29359
R19641 VSS.n4792 VSS.t2463 1.29359
R19642 VSS.n6873 VSS.t2248 1.29359
R19643 VSS.t2033 VSS.n8304 1.29359
R19644 VSS.t1818 VSS.n9342 1.29359
R19645 VSS.n10393 VSS.t1385 1.29359
R19646 VSS.t1170 VSS.n11824 1.29359
R19647 VSS.t955 VSS.n12862 1.29359
R19648 VSS.n1598 VSS.t740 1.29359
R19649 VSS.n13880 VSS.t545 1.29359
R19650 VSS.n15176 VSS.t397 1.29359
R19651 VSS.n217 VSS.n218 0.0823303
R19652 VSS.n3756 VSS.t2893 1.26736
R19653 VSS.n2226 VSS.t1600 1.26736
R19654 VSS.t3001 VSS.n4407 1.23782
R19655 VSS.t2786 VSS.n5139 1.23782
R19656 VSS.t2571 VSS.n6488 1.23782
R19657 VSS.t2356 VSS.n7530 1.23782
R19658 VSS.t2141 VSS.n7616 1.23782
R19659 VSS.t1926 VSS.n8659 1.23782
R19660 VSS.t1708 VSS.n10008 1.23782
R19661 VSS.t1493 VSS.n11050 1.23782
R19662 VSS.t1278 VSS.n11136 1.23782
R19663 VSS.t1063 VSS.n12179 1.23782
R19664 VSS.t848 VSS.n13528 1.23782
R19665 VSS.t638 VSS.n14493 1.23782
R19666 VSS.t468 VSS.n14576 1.23782
R19667 VSS.t521 VSS.n402 1.23739
R19668 VSS.t524 VSS.n420 1.23739
R19669 VSS.t1 VSS.t487 1.22603
R19670 VSS.n13679 VSS.t69 1.22603
R19671 VSS.n14928 VSS.t168 1.22603
R19672 VSS.n4430 VSS.n4429 1.18406
R19673 VSS.n4351 VSS.n3459 1.18406
R19674 VSS.n4250 VSS.n3509 1.18406
R19675 VSS.n4149 VSS.n3559 1.18406
R19676 VSS.n4048 VSS.n3609 1.18406
R19677 VSS.n3947 VSS.n3659 1.18406
R19678 VSS.n3846 VSS.n3709 1.18406
R19679 VSS.n5162 VSS.n5161 1.18406
R19680 VSS.n5228 VSS.n5088 1.18406
R19681 VSS.n5334 VSS.n5046 1.18406
R19682 VSS.n5440 VSS.n5004 1.18406
R19683 VSS.n5546 VSS.n4962 1.18406
R19684 VSS.n5652 VSS.n4920 1.18406
R19685 VSS.n5758 VSS.n4878 1.18406
R19686 VSS.n6511 VSS.n6510 1.18406
R19687 VSS.n6432 VSS.n4482 1.18406
R19688 VSS.n6331 VSS.n4532 1.18406
R19689 VSS.n6230 VSS.n4582 1.18406
R19690 VSS.n6129 VSS.n4632 1.18406
R19691 VSS.n6028 VSS.n4682 1.18406
R19692 VSS.n5927 VSS.n4732 1.18406
R19693 VSS.n7553 VSS.n7552 1.18406
R19694 VSS.n7474 VSS.n6563 1.18406
R19695 VSS.n7373 VSS.n6613 1.18406
R19696 VSS.n7272 VSS.n6663 1.18406
R19697 VSS.n7171 VSS.n6713 1.18406
R19698 VSS.n7070 VSS.n6763 1.18406
R19699 VSS.n6969 VSS.n6813 1.18406
R19700 VSS.n7639 VSS.n7638 1.18406
R19701 VSS.n7710 VSS.n2516 1.18406
R19702 VSS.n7816 VSS.n2474 1.18406
R19703 VSS.n7922 VSS.n2432 1.18406
R19704 VSS.n8028 VSS.n2390 1.18406
R19705 VSS.n8134 VSS.n2348 1.18406
R19706 VSS.n8240 VSS.n2306 1.18406
R19707 VSS.n8682 VSS.n8681 1.18406
R19708 VSS.n8748 VSS.n8608 1.18406
R19709 VSS.n8854 VSS.n8566 1.18406
R19710 VSS.n8960 VSS.n8524 1.18406
R19711 VSS.n9066 VSS.n8482 1.18406
R19712 VSS.n9172 VSS.n8440 1.18406
R19713 VSS.n9278 VSS.n8398 1.18406
R19714 VSS.n10031 VSS.n10030 1.18406
R19715 VSS.n9952 VSS.n1929 1.18406
R19716 VSS.n9851 VSS.n1979 1.18406
R19717 VSS.n9750 VSS.n2029 1.18406
R19718 VSS.n9649 VSS.n2079 1.18406
R19719 VSS.n9548 VSS.n2129 1.18406
R19720 VSS.n9447 VSS.n2179 1.18406
R19721 VSS.n11073 VSS.n11072 1.18406
R19722 VSS.n10994 VSS.n10083 1.18406
R19723 VSS.n10893 VSS.n10133 1.18406
R19724 VSS.n10792 VSS.n10183 1.18406
R19725 VSS.n10691 VSS.n10233 1.18406
R19726 VSS.n10590 VSS.n10283 1.18406
R19727 VSS.n10489 VSS.n10333 1.18406
R19728 VSS.n11159 VSS.n11158 1.18406
R19729 VSS.n11230 VSS.n1894 1.18406
R19730 VSS.n11336 VSS.n1852 1.18406
R19731 VSS.n11442 VSS.n1810 1.18406
R19732 VSS.n11548 VSS.n1768 1.18406
R19733 VSS.n11654 VSS.n1726 1.18406
R19734 VSS.n11760 VSS.n1684 1.18406
R19735 VSS.n12202 VSS.n12201 1.18406
R19736 VSS.n12268 VSS.n12128 1.18406
R19737 VSS.n12374 VSS.n12086 1.18406
R19738 VSS.n12480 VSS.n12044 1.18406
R19739 VSS.n12586 VSS.n12002 1.18406
R19740 VSS.n12692 VSS.n11960 1.18406
R19741 VSS.n12798 VSS.n11918 1.18406
R19742 VSS.n13551 VSS.n13550 1.18406
R19743 VSS.n13472 VSS.n1288 1.18406
R19744 VSS.n13371 VSS.n1338 1.18406
R19745 VSS.n13270 VSS.n1388 1.18406
R19746 VSS.n13169 VSS.n1438 1.18406
R19747 VSS.n13068 VSS.n1488 1.18406
R19748 VSS.n12967 VSS.n1538 1.18406
R19749 VSS.n14516 VSS.n14515 1.18406
R19750 VSS.n14437 VSS.n13603 1.18406
R19751 VSS.n14201 VSS.n14148 1.18406
R19752 VSS.n14077 VSS.n13770 1.18406
R19753 VSS.n13976 VSS.n13820 1.18406
R19754 VSS.n14599 VSS.n14598 1.18406
R19755 VSS.n14670 VSS.n442 1.18406
R19756 VSS.t3319 VSS.t484 1.18406
R19757 VSS.t3112 VSS.t3486 1.18311
R19758 VSS.t394 VSS.t4365 1.18311
R19759 VSS.t4367 VSS.t390 1.18311
R19760 VSS.t4372 VSS.t372 1.18311
R19761 VSS.t357 VSS.t4377 1.18311
R19762 VSS.t342 VSS.t4381 1.18311
R19763 VSS.t327 VSS.t4385 1.18311
R19764 VSS.t4388 VSS.t318 1.18311
R19765 VSS.t4391 VSS.t309 1.18311
R19766 VSS.t294 VSS.t4396 1.18311
R19767 VSS.t4397 VSS.t291 1.18311
R19768 VSS.t4356 VSS.t431 1.18311
R19769 VSS.t422 VSS.t4359 1.18311
R19770 VSS.t4401 VSS.t276 1.18311
R19771 VSS.t3481 VSS.t3127 1.18311
R19772 VSS.t3443 VSS.t3239 1.18311
R19773 VSS.t3445 VSS.t3235 1.18311
R19774 VSS.t3226 VSS.t3448 1.18311
R19775 VSS.t3451 VSS.t3217 1.18311
R19776 VSS.t3454 VSS.t3208 1.18311
R19777 VSS.t3457 VSS.t3199 1.18311
R19778 VSS.t3460 VSS.t3190 1.18311
R19779 VSS.t3463 VSS.t3181 1.18311
R19780 VSS.t3466 VSS.t3172 1.18311
R19781 VSS.t3469 VSS.t3163 1.18311
R19782 VSS.t3472 VSS.t3154 1.18311
R19783 VSS.t3475 VSS.t3145 1.18311
R19784 VSS.t3478 VSS.t3136 1.18311
R19785 VSS.n15291 VSS.n15290 1.14023
R19786 VSS.n15281 VSS.n15280 1.14023
R19787 VSS.n491 VSS.n471 1.14023
R19788 VSS.n463 VSS.n462 1.14023
R19789 VSS.n1241 VSS.n1240 1.14023
R19790 VSS.n1175 VSS.n1174 1.14023
R19791 VSS.n1152 VSS.n1151 1.14023
R19792 VSS.n1077 VSS.n1043 1.14023
R19793 VSS.n1100 VSS.n1099 1.14023
R19794 VSS.n1015 VSS.n1014 1.14023
R19795 VSS.n962 VSS.n929 1.14023
R19796 VSS.n985 VSS.n984 1.14023
R19797 VSS.n884 VSS.n589 1.14023
R19798 VSS.n850 VSS.n816 1.14023
R19799 VSS.n873 VSS.n872 1.14023
R19800 VSS.n790 VSS.n598 1.14023
R19801 VSS.n765 VSS.n764 1.14023
R19802 VSS.n736 VSS.n735 1.14023
R19803 VSS.n713 VSS.n712 1.14023
R19804 VSS.n695 VSS.n635 1.14023
R19805 VSS.n15251 VSS.n15250 1.14023
R19806 VSS.n3755 VSS.n3754 1.14023
R19807 VSS.n4443 VSS.n3449 1.14023
R19808 VSS.n4342 VSS.n4341 1.14023
R19809 VSS.n4321 VSS.n3481 1.14023
R19810 VSS.n4241 VSS.n4240 1.14023
R19811 VSS.n4220 VSS.n3531 1.14023
R19812 VSS.n4140 VSS.n4139 1.14023
R19813 VSS.n4119 VSS.n3581 1.14023
R19814 VSS.n4039 VSS.n4038 1.14023
R19815 VSS.n4018 VSS.n3631 1.14023
R19816 VSS.n3938 VSS.n3937 1.14023
R19817 VSS.n3917 VSS.n3681 1.14023
R19818 VSS.n3837 VSS.n3836 1.14023
R19819 VSS.n3816 VSS.n3731 1.14023
R19820 VSS.n5175 VSS.n5117 1.14023
R19821 VSS.n5241 VSS.n5085 1.14023
R19822 VSS.n5267 VSS.n5076 1.14023
R19823 VSS.n5347 VSS.n5043 1.14023
R19824 VSS.n5373 VSS.n5034 1.14023
R19825 VSS.n5453 VSS.n5001 1.14023
R19826 VSS.n5479 VSS.n4992 1.14023
R19827 VSS.n5559 VSS.n4959 1.14023
R19828 VSS.n5585 VSS.n4950 1.14023
R19829 VSS.n5665 VSS.n4917 1.14023
R19830 VSS.n5691 VSS.n4908 1.14023
R19831 VSS.n5771 VSS.n4875 1.14023
R19832 VSS.n5792 VSS.n5791 1.14023
R19833 VSS.n6524 VSS.n4472 1.14023
R19834 VSS.n6423 VSS.n6422 1.14023
R19835 VSS.n6402 VSS.n4504 1.14023
R19836 VSS.n6322 VSS.n6321 1.14023
R19837 VSS.n6301 VSS.n4554 1.14023
R19838 VSS.n6221 VSS.n6220 1.14023
R19839 VSS.n6200 VSS.n4604 1.14023
R19840 VSS.n6120 VSS.n6119 1.14023
R19841 VSS.n6099 VSS.n4654 1.14023
R19842 VSS.n6019 VSS.n6018 1.14023
R19843 VSS.n5998 VSS.n4704 1.14023
R19844 VSS.n5918 VSS.n5917 1.14023
R19845 VSS.n5897 VSS.n4754 1.14023
R19846 VSS.n7566 VSS.n6553 1.14023
R19847 VSS.n7465 VSS.n7464 1.14023
R19848 VSS.n7444 VSS.n6585 1.14023
R19849 VSS.n7364 VSS.n7363 1.14023
R19850 VSS.n7343 VSS.n6635 1.14023
R19851 VSS.n7263 VSS.n7262 1.14023
R19852 VSS.n7242 VSS.n6685 1.14023
R19853 VSS.n7162 VSS.n7161 1.14023
R19854 VSS.n7141 VSS.n6735 1.14023
R19855 VSS.n7061 VSS.n7060 1.14023
R19856 VSS.n7040 VSS.n6785 1.14023
R19857 VSS.n6960 VSS.n6959 1.14023
R19858 VSS.n6939 VSS.n6835 1.14023
R19859 VSS.n7652 VSS.n7594 1.14023
R19860 VSS.n7723 VSS.n2513 1.14023
R19861 VSS.n7749 VSS.n2504 1.14023
R19862 VSS.n7829 VSS.n2471 1.14023
R19863 VSS.n7855 VSS.n2462 1.14023
R19864 VSS.n7935 VSS.n2429 1.14023
R19865 VSS.n7961 VSS.n2420 1.14023
R19866 VSS.n8041 VSS.n2387 1.14023
R19867 VSS.n8067 VSS.n2378 1.14023
R19868 VSS.n8147 VSS.n2345 1.14023
R19869 VSS.n8173 VSS.n2336 1.14023
R19870 VSS.n8253 VSS.n2303 1.14023
R19871 VSS.n8274 VSS.n8273 1.14023
R19872 VSS.n8695 VSS.n8637 1.14023
R19873 VSS.n8761 VSS.n8605 1.14023
R19874 VSS.n8787 VSS.n8596 1.14023
R19875 VSS.n8867 VSS.n8563 1.14023
R19876 VSS.n8893 VSS.n8554 1.14023
R19877 VSS.n8973 VSS.n8521 1.14023
R19878 VSS.n8999 VSS.n8512 1.14023
R19879 VSS.n9079 VSS.n8479 1.14023
R19880 VSS.n9105 VSS.n8470 1.14023
R19881 VSS.n9185 VSS.n8437 1.14023
R19882 VSS.n9211 VSS.n8428 1.14023
R19883 VSS.n9291 VSS.n8395 1.14023
R19884 VSS.n9312 VSS.n9311 1.14023
R19885 VSS.n2225 VSS.n2224 1.14023
R19886 VSS.n10044 VSS.n1919 1.14023
R19887 VSS.n9943 VSS.n9942 1.14023
R19888 VSS.n9922 VSS.n1951 1.14023
R19889 VSS.n9842 VSS.n9841 1.14023
R19890 VSS.n9821 VSS.n2001 1.14023
R19891 VSS.n9741 VSS.n9740 1.14023
R19892 VSS.n9720 VSS.n2051 1.14023
R19893 VSS.n9640 VSS.n9639 1.14023
R19894 VSS.n9619 VSS.n2101 1.14023
R19895 VSS.n9539 VSS.n9538 1.14023
R19896 VSS.n9518 VSS.n2151 1.14023
R19897 VSS.n9438 VSS.n9437 1.14023
R19898 VSS.n9417 VSS.n2201 1.14023
R19899 VSS.n11086 VSS.n10073 1.14023
R19900 VSS.n10985 VSS.n10984 1.14023
R19901 VSS.n10964 VSS.n10105 1.14023
R19902 VSS.n10884 VSS.n10883 1.14023
R19903 VSS.n10863 VSS.n10155 1.14023
R19904 VSS.n10783 VSS.n10782 1.14023
R19905 VSS.n10762 VSS.n10205 1.14023
R19906 VSS.n10682 VSS.n10681 1.14023
R19907 VSS.n10661 VSS.n10255 1.14023
R19908 VSS.n10581 VSS.n10580 1.14023
R19909 VSS.n10560 VSS.n10305 1.14023
R19910 VSS.n10480 VSS.n10479 1.14023
R19911 VSS.n10459 VSS.n10355 1.14023
R19912 VSS.n11172 VSS.n11114 1.14023
R19913 VSS.n11243 VSS.n1891 1.14023
R19914 VSS.n11269 VSS.n1882 1.14023
R19915 VSS.n11349 VSS.n1849 1.14023
R19916 VSS.n11375 VSS.n1840 1.14023
R19917 VSS.n11455 VSS.n1807 1.14023
R19918 VSS.n11481 VSS.n1798 1.14023
R19919 VSS.n11561 VSS.n1765 1.14023
R19920 VSS.n11587 VSS.n1756 1.14023
R19921 VSS.n11667 VSS.n1723 1.14023
R19922 VSS.n11693 VSS.n1714 1.14023
R19923 VSS.n11773 VSS.n1681 1.14023
R19924 VSS.n11794 VSS.n11793 1.14023
R19925 VSS.n12215 VSS.n12157 1.14023
R19926 VSS.n12281 VSS.n12125 1.14023
R19927 VSS.n12307 VSS.n12116 1.14023
R19928 VSS.n12387 VSS.n12083 1.14023
R19929 VSS.n12413 VSS.n12074 1.14023
R19930 VSS.n12493 VSS.n12041 1.14023
R19931 VSS.n12519 VSS.n12032 1.14023
R19932 VSS.n12599 VSS.n11999 1.14023
R19933 VSS.n12625 VSS.n11990 1.14023
R19934 VSS.n12705 VSS.n11957 1.14023
R19935 VSS.n12731 VSS.n11948 1.14023
R19936 VSS.n12811 VSS.n11915 1.14023
R19937 VSS.n12832 VSS.n12831 1.14023
R19938 VSS.n13564 VSS.n1278 1.14023
R19939 VSS.n13463 VSS.n13462 1.14023
R19940 VSS.n13442 VSS.n1310 1.14023
R19941 VSS.n13362 VSS.n13361 1.14023
R19942 VSS.n13341 VSS.n1360 1.14023
R19943 VSS.n13261 VSS.n13260 1.14023
R19944 VSS.n13240 VSS.n1410 1.14023
R19945 VSS.n13160 VSS.n13159 1.14023
R19946 VSS.n13139 VSS.n1460 1.14023
R19947 VSS.n13059 VSS.n13058 1.14023
R19948 VSS.n13038 VSS.n1510 1.14023
R19949 VSS.n12958 VSS.n12957 1.14023
R19950 VSS.n12937 VSS.n1560 1.14023
R19951 VSS.n14529 VSS.n13593 1.14023
R19952 VSS.n14428 VSS.n14427 1.14023
R19953 VSS.n14407 VSS.n13625 1.14023
R19954 VSS.n14320 VSS.n14319 1.14023
R19955 VSS.n14298 VSS.n14297 1.14023
R19956 VSS.n14252 VSS.n13725 1.14023
R19957 VSS.n14210 VSS.n14209 1.14023
R19958 VSS.n14068 VSS.n14067 1.14023
R19959 VSS.n14047 VSS.n13792 1.14023
R19960 VSS.n13967 VSS.n13966 1.14023
R19961 VSS.n13946 VSS.n13842 1.14023
R19962 VSS.n15239 VSS.n15238 1.14023
R19963 VSS.n14612 VSS.n14557 1.14023
R19964 VSS.n14683 VSS.n439 1.14023
R19965 VSS.n14873 VSS.n361 1.14023
R19966 VSS.n14904 VSS.n14903 1.14023
R19967 VSS.n14945 VSS.t499 1.14023
R19968 VSS.n15059 VSS.n312 1.14023
R19969 VSS.n15112 VSS.n15111 1.14023
R19970 VSS.n261 VSS.n260 1.14023
R19971 VSS.n15347 VSS.n15346 1.14023
R19972 VSS.n2578 VSS.n2577 1.14023
R19973 VSS.n2537 VSS.n2536 1.14023
R19974 VSS.n2651 VSS.n2617 1.14023
R19975 VSS.n2674 VSS.n2673 1.14023
R19976 VSS.n3401 VSS.n3400 1.14023
R19977 VSS.n3378 VSS.n3377 1.14023
R19978 VSS.n3349 VSS.n3348 1.14023
R19979 VSS.n3326 VSS.n3325 1.14023
R19980 VSS.n3297 VSS.n3296 1.14023
R19981 VSS.n3274 VSS.n3273 1.14023
R19982 VSS.n3245 VSS.n3244 1.14023
R19983 VSS.n3222 VSS.n3221 1.14023
R19984 VSS.n3193 VSS.n3192 1.14023
R19985 VSS.n3170 VSS.n3169 1.14023
R19986 VSS.n3141 VSS.n3140 1.14023
R19987 VSS.n3118 VSS.n3117 1.14023
R19988 VSS.n3089 VSS.n3088 1.14023
R19989 VSS.n3066 VSS.n3065 1.14023
R19990 VSS.n3037 VSS.n3036 1.14023
R19991 VSS.n3014 VSS.n3013 1.14023
R19992 VSS.n2985 VSS.n2984 1.14023
R19993 VSS.n2962 VSS.n2961 1.14023
R19994 VSS.n2933 VSS.n2932 1.14023
R19995 VSS.n2910 VSS.n2909 1.14023
R19996 VSS.t232 VSS.n13656 1.14023
R19997 VSS.n14746 VSS.t519 1.14023
R19998 VSS.t522 VSS.n14728 1.14023
R19999 VSS.t525 VSS.n14709 1.14023
R20000 VSS.t183 VSS.t178 1.12991
R20001 VSS.t261 VSS.t20 1.12991
R20002 VSS.t59 VSS.t118 1.12991
R20003 VSS.n4459 VSS.t2994 1.11978
R20004 VSS.n4294 VSS.t2979 1.11978
R20005 VSS.n4193 VSS.t2964 1.11978
R20006 VSS.n4092 VSS.t2949 1.11978
R20007 VSS.n3991 VSS.t2934 1.11978
R20008 VSS.n3890 VSS.t2919 1.11978
R20009 VSS.n5111 VSS.t2779 1.11978
R20010 VSS.n5291 VSS.t2764 1.11978
R20011 VSS.n5397 VSS.t2749 1.11978
R20012 VSS.n5503 VSS.t2734 1.11978
R20013 VSS.n5609 VSS.t2719 1.11978
R20014 VSS.n5715 VSS.t2704 1.11978
R20015 VSS.n6540 VSS.t2564 1.11978
R20016 VSS.n6375 VSS.t2549 1.11978
R20017 VSS.n6274 VSS.t2534 1.11978
R20018 VSS.n6173 VSS.t2519 1.11978
R20019 VSS.n6072 VSS.t2504 1.11978
R20020 VSS.n5971 VSS.t2489 1.11978
R20021 VSS.n7582 VSS.t2349 1.11978
R20022 VSS.n7417 VSS.t2334 1.11978
R20023 VSS.n7316 VSS.t2319 1.11978
R20024 VSS.n7215 VSS.t2304 1.11978
R20025 VSS.n7114 VSS.t2289 1.11978
R20026 VSS.n7013 VSS.t2274 1.11978
R20027 VSS.n7668 VSS.t2134 1.11978
R20028 VSS.n7773 VSS.t2119 1.11978
R20029 VSS.n7879 VSS.t2104 1.11978
R20030 VSS.n7985 VSS.t2089 1.11978
R20031 VSS.n8091 VSS.t2074 1.11978
R20032 VSS.n8197 VSS.t2059 1.11978
R20033 VSS.n8631 VSS.t1919 1.11978
R20034 VSS.n8811 VSS.t1904 1.11978
R20035 VSS.n8917 VSS.t1889 1.11978
R20036 VSS.n9023 VSS.t1874 1.11978
R20037 VSS.n9129 VSS.t1859 1.11978
R20038 VSS.n9235 VSS.t1844 1.11978
R20039 VSS.n10060 VSS.t1701 1.11978
R20040 VSS.n9895 VSS.t1686 1.11978
R20041 VSS.n9794 VSS.t1671 1.11978
R20042 VSS.n9693 VSS.t1656 1.11978
R20043 VSS.n9592 VSS.t1641 1.11978
R20044 VSS.n9491 VSS.t1626 1.11978
R20045 VSS.n11102 VSS.t1486 1.11978
R20046 VSS.n10937 VSS.t1471 1.11978
R20047 VSS.n10836 VSS.t1456 1.11978
R20048 VSS.n10735 VSS.t1441 1.11978
R20049 VSS.n10634 VSS.t1426 1.11978
R20050 VSS.n10533 VSS.t1411 1.11978
R20051 VSS.n11188 VSS.t1271 1.11978
R20052 VSS.n11293 VSS.t1256 1.11978
R20053 VSS.n11399 VSS.t1241 1.11978
R20054 VSS.n11505 VSS.t1226 1.11978
R20055 VSS.n11611 VSS.t1211 1.11978
R20056 VSS.n11717 VSS.t1196 1.11978
R20057 VSS.n12151 VSS.t1056 1.11978
R20058 VSS.n12331 VSS.t1041 1.11978
R20059 VSS.n12437 VSS.t1026 1.11978
R20060 VSS.n12543 VSS.t1011 1.11978
R20061 VSS.n12649 VSS.t996 1.11978
R20062 VSS.n12755 VSS.t981 1.11978
R20063 VSS.n13580 VSS.t841 1.11978
R20064 VSS.n13415 VSS.t826 1.11978
R20065 VSS.n13314 VSS.t811 1.11978
R20066 VSS.n13213 VSS.t796 1.11978
R20067 VSS.n13112 VSS.t781 1.11978
R20068 VSS.n13011 VSS.t766 1.11978
R20069 VSS.n14545 VSS.t631 1.11978
R20070 VSS.n14380 VSS.t616 1.11978
R20071 VSS.n14121 VSS.t586 1.11978
R20072 VSS.n14020 VSS.t571 1.11978
R20073 VSS.n14628 VSS.t461 1.11978
R20074 VSS.n14890 VSS.t502 1.08588
R20075 VSS.n5832 VSS.n5831 1.07105
R20076 VSS.n5832 VSS.n5817 1.07105
R20077 VSS.n5855 VSS.n5854 1.07105
R20078 VSS.n5855 VSS.n5804 1.07105
R20079 VSS.n4799 VSS.n4785 1.07105
R20080 VSS.n4800 VSS.n4799 1.07105
R20081 VSS.n4821 VSS.n4771 1.07105
R20082 VSS.n4822 VSS.n4821 1.07105
R20083 VSS.n6880 VSS.n6866 1.07105
R20084 VSS.n6881 VSS.n6880 1.07105
R20085 VSS.n6902 VSS.n6852 1.07105
R20086 VSS.n6903 VSS.n6902 1.07105
R20087 VSS.n8314 VSS.n8313 1.07105
R20088 VSS.n8314 VSS.n8299 1.07105
R20089 VSS.n8337 VSS.n8336 1.07105
R20090 VSS.n8337 VSS.n8286 1.07105
R20091 VSS.n9352 VSS.n9351 1.07105
R20092 VSS.n9352 VSS.n9337 1.07105
R20093 VSS.n9375 VSS.n9374 1.07105
R20094 VSS.n9375 VSS.n9324 1.07105
R20095 VSS.n10400 VSS.n10386 1.07105
R20096 VSS.n10401 VSS.n10400 1.07105
R20097 VSS.n10422 VSS.n10372 1.07105
R20098 VSS.n10423 VSS.n10422 1.07105
R20099 VSS.n11834 VSS.n11833 1.07105
R20100 VSS.n11834 VSS.n11819 1.07105
R20101 VSS.n11857 VSS.n11856 1.07105
R20102 VSS.n11857 VSS.n11806 1.07105
R20103 VSS.n12872 VSS.n12871 1.07105
R20104 VSS.n12872 VSS.n12857 1.07105
R20105 VSS.n12895 VSS.n12894 1.07105
R20106 VSS.n12895 VSS.n12844 1.07105
R20107 VSS.n1605 VSS.n1591 1.07105
R20108 VSS.n1606 VSS.n1605 1.07105
R20109 VSS.n1627 VSS.n1577 1.07105
R20110 VSS.n1628 VSS.n1627 1.07105
R20111 VSS.n13887 VSS.n13873 1.07105
R20112 VSS.n13888 VSS.n13887 1.07105
R20113 VSS.n13909 VSS.n13859 1.07105
R20114 VSS.n13910 VSS.n13909 1.07105
R20115 VSS.n15183 VSS.n15169 1.07105
R20116 VSS.n15184 VSS.n15183 1.07105
R20117 VSS.n15205 VSS.n15155 1.07105
R20118 VSS.n15206 VSS.n15205 1.07105
R20119 VSS.n14964 VSS.n331 1.07105
R20120 VSS.n14965 VSS.n14964 1.07105
R20121 VSS.n14995 VSS.n323 1.07105
R20122 VSS.n14992 VSS.n323 1.07105
R20123 VSS.n4445 VSS.n4444 1.04845
R20124 VSS.n4336 VSS.n3466 1.04845
R20125 VSS.n4317 VSS.n3482 1.04845
R20126 VSS.n4235 VSS.n3516 1.04845
R20127 VSS.n4216 VSS.n3532 1.04845
R20128 VSS.n4134 VSS.n3566 1.04845
R20129 VSS.n4115 VSS.n3582 1.04845
R20130 VSS.n4033 VSS.n3616 1.04845
R20131 VSS.n4014 VSS.n3632 1.04845
R20132 VSS.n3932 VSS.n3666 1.04845
R20133 VSS.n3913 VSS.n3682 1.04845
R20134 VSS.n3831 VSS.n3716 1.04845
R20135 VSS.n5177 VSS.n5176 1.04845
R20136 VSS.n5243 VSS.n5242 1.04845
R20137 VSS.n5269 VSS.n5268 1.04845
R20138 VSS.n5349 VSS.n5348 1.04845
R20139 VSS.n5375 VSS.n5374 1.04845
R20140 VSS.n5455 VSS.n5454 1.04845
R20141 VSS.n5481 VSS.n5480 1.04845
R20142 VSS.n5561 VSS.n5560 1.04845
R20143 VSS.n5587 VSS.n5586 1.04845
R20144 VSS.n5667 VSS.n5666 1.04845
R20145 VSS.n5693 VSS.n5692 1.04845
R20146 VSS.n5773 VSS.n5772 1.04845
R20147 VSS.n6526 VSS.n6525 1.04845
R20148 VSS.n6417 VSS.n4489 1.04845
R20149 VSS.n6398 VSS.n4505 1.04845
R20150 VSS.n6316 VSS.n4539 1.04845
R20151 VSS.n6297 VSS.n4555 1.04845
R20152 VSS.n6215 VSS.n4589 1.04845
R20153 VSS.n6196 VSS.n4605 1.04845
R20154 VSS.n6114 VSS.n4639 1.04845
R20155 VSS.n6095 VSS.n4655 1.04845
R20156 VSS.n6013 VSS.n4689 1.04845
R20157 VSS.n5994 VSS.n4705 1.04845
R20158 VSS.n5912 VSS.n4739 1.04845
R20159 VSS.n7568 VSS.n7567 1.04845
R20160 VSS.n7459 VSS.n6570 1.04845
R20161 VSS.n7440 VSS.n6586 1.04845
R20162 VSS.n7358 VSS.n6620 1.04845
R20163 VSS.n7339 VSS.n6636 1.04845
R20164 VSS.n7257 VSS.n6670 1.04845
R20165 VSS.n7238 VSS.n6686 1.04845
R20166 VSS.n7156 VSS.n6720 1.04845
R20167 VSS.n7137 VSS.n6736 1.04845
R20168 VSS.n7055 VSS.n6770 1.04845
R20169 VSS.n7036 VSS.n6786 1.04845
R20170 VSS.n6954 VSS.n6820 1.04845
R20171 VSS.n7654 VSS.n7653 1.04845
R20172 VSS.n7725 VSS.n7724 1.04845
R20173 VSS.n7751 VSS.n7750 1.04845
R20174 VSS.n7831 VSS.n7830 1.04845
R20175 VSS.n7857 VSS.n7856 1.04845
R20176 VSS.n7937 VSS.n7936 1.04845
R20177 VSS.n7963 VSS.n7962 1.04845
R20178 VSS.n8043 VSS.n8042 1.04845
R20179 VSS.n8069 VSS.n8068 1.04845
R20180 VSS.n8149 VSS.n8148 1.04845
R20181 VSS.n8175 VSS.n8174 1.04845
R20182 VSS.n8255 VSS.n8254 1.04845
R20183 VSS.n8697 VSS.n8696 1.04845
R20184 VSS.n8763 VSS.n8762 1.04845
R20185 VSS.n8789 VSS.n8788 1.04845
R20186 VSS.n8869 VSS.n8868 1.04845
R20187 VSS.n8895 VSS.n8894 1.04845
R20188 VSS.n8975 VSS.n8974 1.04845
R20189 VSS.n9001 VSS.n9000 1.04845
R20190 VSS.n9081 VSS.n9080 1.04845
R20191 VSS.n9107 VSS.n9106 1.04845
R20192 VSS.n9187 VSS.n9186 1.04845
R20193 VSS.n9213 VSS.n9212 1.04845
R20194 VSS.n9293 VSS.n9292 1.04845
R20195 VSS.n10046 VSS.n10045 1.04845
R20196 VSS.n9937 VSS.n1936 1.04845
R20197 VSS.n9918 VSS.n1952 1.04845
R20198 VSS.n9836 VSS.n1986 1.04845
R20199 VSS.n9817 VSS.n2002 1.04845
R20200 VSS.n9735 VSS.n2036 1.04845
R20201 VSS.n9716 VSS.n2052 1.04845
R20202 VSS.n9634 VSS.n2086 1.04845
R20203 VSS.n9615 VSS.n2102 1.04845
R20204 VSS.n9533 VSS.n2136 1.04845
R20205 VSS.n9514 VSS.n2152 1.04845
R20206 VSS.n9432 VSS.n2186 1.04845
R20207 VSS.n11088 VSS.n11087 1.04845
R20208 VSS.n10979 VSS.n10090 1.04845
R20209 VSS.n10960 VSS.n10106 1.04845
R20210 VSS.n10878 VSS.n10140 1.04845
R20211 VSS.n10859 VSS.n10156 1.04845
R20212 VSS.n10777 VSS.n10190 1.04845
R20213 VSS.n10758 VSS.n10206 1.04845
R20214 VSS.n10676 VSS.n10240 1.04845
R20215 VSS.n10657 VSS.n10256 1.04845
R20216 VSS.n10575 VSS.n10290 1.04845
R20217 VSS.n10556 VSS.n10306 1.04845
R20218 VSS.n10474 VSS.n10340 1.04845
R20219 VSS.n11174 VSS.n11173 1.04845
R20220 VSS.n11245 VSS.n11244 1.04845
R20221 VSS.n11271 VSS.n11270 1.04845
R20222 VSS.n11351 VSS.n11350 1.04845
R20223 VSS.n11377 VSS.n11376 1.04845
R20224 VSS.n11457 VSS.n11456 1.04845
R20225 VSS.n11483 VSS.n11482 1.04845
R20226 VSS.n11563 VSS.n11562 1.04845
R20227 VSS.n11589 VSS.n11588 1.04845
R20228 VSS.n11669 VSS.n11668 1.04845
R20229 VSS.n11695 VSS.n11694 1.04845
R20230 VSS.n11775 VSS.n11774 1.04845
R20231 VSS.n12217 VSS.n12216 1.04845
R20232 VSS.n12283 VSS.n12282 1.04845
R20233 VSS.n12309 VSS.n12308 1.04845
R20234 VSS.n12389 VSS.n12388 1.04845
R20235 VSS.n12415 VSS.n12414 1.04845
R20236 VSS.n12495 VSS.n12494 1.04845
R20237 VSS.n12521 VSS.n12520 1.04845
R20238 VSS.n12601 VSS.n12600 1.04845
R20239 VSS.n12627 VSS.n12626 1.04845
R20240 VSS.n12707 VSS.n12706 1.04845
R20241 VSS.n12733 VSS.n12732 1.04845
R20242 VSS.n12813 VSS.n12812 1.04845
R20243 VSS.n13566 VSS.n13565 1.04845
R20244 VSS.n13457 VSS.n1295 1.04845
R20245 VSS.n13438 VSS.n1311 1.04845
R20246 VSS.n13356 VSS.n1345 1.04845
R20247 VSS.n13337 VSS.n1361 1.04845
R20248 VSS.n13255 VSS.n1395 1.04845
R20249 VSS.n13236 VSS.n1411 1.04845
R20250 VSS.n13154 VSS.n1445 1.04845
R20251 VSS.n13135 VSS.n1461 1.04845
R20252 VSS.n13053 VSS.n1495 1.04845
R20253 VSS.n13034 VSS.n1511 1.04845
R20254 VSS.n12952 VSS.n1545 1.04845
R20255 VSS.n14531 VSS.n14530 1.04845
R20256 VSS.n14422 VSS.n13610 1.04845
R20257 VSS.n14403 VSS.n13626 1.04845
R20258 VSS.n14144 VSS.n13744 1.04845
R20259 VSS.n14062 VSS.n13777 1.04845
R20260 VSS.n14043 VSS.n13793 1.04845
R20261 VSS.n13961 VSS.n13827 1.04845
R20262 VSS.n14614 VSS.n14613 1.04845
R20263 VSS.n14685 VSS.n14684 1.04845
R20264 VSS.n14711 VSS.n14710 1.04845
R20265 VSS.n14730 VSS.n14729 1.04845
R20266 VSS.t4268 VSS.t704 1.0221
R20267 VSS.t701 VSS.t4269 1.0221
R20268 VSS.n4330 VSS.n3470 1.01103
R20269 VSS.n4229 VSS.n3520 1.01103
R20270 VSS.n4128 VSS.n3570 1.01103
R20271 VSS.n4027 VSS.n3620 1.01103
R20272 VSS.n3926 VSS.n3670 1.01103
R20273 VSS.n3825 VSS.n3720 1.01103
R20274 VSS.n5248 VSS.n5080 1.01103
R20275 VSS.n5354 VSS.n5038 1.01103
R20276 VSS.n5460 VSS.n4996 1.01103
R20277 VSS.n5566 VSS.n4954 1.01103
R20278 VSS.n5672 VSS.n4912 1.01103
R20279 VSS.n5778 VSS.n4870 1.01103
R20280 VSS.n6411 VSS.n4493 1.01103
R20281 VSS.n6310 VSS.n4543 1.01103
R20282 VSS.n6209 VSS.n4593 1.01103
R20283 VSS.n6108 VSS.n4643 1.01103
R20284 VSS.n6007 VSS.n4693 1.01103
R20285 VSS.n5906 VSS.n4743 1.01103
R20286 VSS.n7453 VSS.n6574 1.01103
R20287 VSS.n7352 VSS.n6624 1.01103
R20288 VSS.n7251 VSS.n6674 1.01103
R20289 VSS.n7150 VSS.n6724 1.01103
R20290 VSS.n7049 VSS.n6774 1.01103
R20291 VSS.n6948 VSS.n6824 1.01103
R20292 VSS.n7730 VSS.n2508 1.01103
R20293 VSS.n7836 VSS.n2466 1.01103
R20294 VSS.n7942 VSS.n2424 1.01103
R20295 VSS.n8048 VSS.n2382 1.01103
R20296 VSS.n8154 VSS.n2340 1.01103
R20297 VSS.n8260 VSS.n2298 1.01103
R20298 VSS.n8768 VSS.n8600 1.01103
R20299 VSS.n8874 VSS.n8558 1.01103
R20300 VSS.n8980 VSS.n8516 1.01103
R20301 VSS.n9086 VSS.n8474 1.01103
R20302 VSS.n9192 VSS.n8432 1.01103
R20303 VSS.n9298 VSS.n8390 1.01103
R20304 VSS.n9931 VSS.n1940 1.01103
R20305 VSS.n9830 VSS.n1990 1.01103
R20306 VSS.n9729 VSS.n2040 1.01103
R20307 VSS.n9628 VSS.n2090 1.01103
R20308 VSS.n9527 VSS.n2140 1.01103
R20309 VSS.n9426 VSS.n2190 1.01103
R20310 VSS.n10973 VSS.n10094 1.01103
R20311 VSS.n10872 VSS.n10144 1.01103
R20312 VSS.n10771 VSS.n10194 1.01103
R20313 VSS.n10670 VSS.n10244 1.01103
R20314 VSS.n10569 VSS.n10294 1.01103
R20315 VSS.n10468 VSS.n10344 1.01103
R20316 VSS.n11250 VSS.n1886 1.01103
R20317 VSS.n11356 VSS.n1844 1.01103
R20318 VSS.n11462 VSS.n1802 1.01103
R20319 VSS.n11568 VSS.n1760 1.01103
R20320 VSS.n11674 VSS.n1718 1.01103
R20321 VSS.n11780 VSS.n1676 1.01103
R20322 VSS.n12288 VSS.n12120 1.01103
R20323 VSS.n12394 VSS.n12078 1.01103
R20324 VSS.n12500 VSS.n12036 1.01103
R20325 VSS.n12606 VSS.n11994 1.01103
R20326 VSS.n12712 VSS.n11952 1.01103
R20327 VSS.n12818 VSS.n11910 1.01103
R20328 VSS.n13451 VSS.n1299 1.01103
R20329 VSS.n13350 VSS.n1349 1.01103
R20330 VSS.n13249 VSS.n1399 1.01103
R20331 VSS.n13148 VSS.n1449 1.01103
R20332 VSS.n13047 VSS.n1499 1.01103
R20333 VSS.n12946 VSS.n1549 1.01103
R20334 VSS.n14416 VSS.n13614 1.01103
R20335 VSS.n14056 VSS.n13781 1.01103
R20336 VSS.n13955 VSS.n13831 1.01103
R20337 VSS.n14690 VSS.n434 1.01103
R20338 VSS.n3784 VSS.n3744 0.973599
R20339 VSS.n2254 VSS.n2214 0.973599
R20340 VSS.t157 VSS.n15137 0.953691
R20341 VSS.n14796 VSS.t512 0.899674
R20342 VSS.t3106 VSS.n4443 0.877212
R20343 VSS.n4321 VSS.t3091 0.877212
R20344 VSS.n4220 VSS.t3076 0.877212
R20345 VSS.n4119 VSS.t3061 0.877212
R20346 VSS.n4018 VSS.t3046 0.877212
R20347 VSS.n3917 VSS.t3031 0.877212
R20348 VSS.n3816 VSS.t3016 0.877212
R20349 VSS.t2888 VSS.n5175 0.877212
R20350 VSS.t2873 VSS.n5267 0.877212
R20351 VSS.t2858 VSS.n5373 0.877212
R20352 VSS.t2843 VSS.n5479 0.877212
R20353 VSS.t2828 VSS.n5585 0.877212
R20354 VSS.t2813 VSS.n5691 0.877212
R20355 VSS.n5791 VSS.t2798 0.877212
R20356 VSS.t2673 VSS.n6524 0.877212
R20357 VSS.n6402 VSS.t2658 0.877212
R20358 VSS.n6301 VSS.t2643 0.877212
R20359 VSS.n6200 VSS.t2628 0.877212
R20360 VSS.n6099 VSS.t2613 0.877212
R20361 VSS.n5998 VSS.t2598 0.877212
R20362 VSS.n5897 VSS.t2583 0.877212
R20363 VSS.t2458 VSS.n7566 0.877212
R20364 VSS.n7444 VSS.t2443 0.877212
R20365 VSS.n7343 VSS.t2428 0.877212
R20366 VSS.n7242 VSS.t2413 0.877212
R20367 VSS.n7141 VSS.t2398 0.877212
R20368 VSS.n7040 VSS.t2383 0.877212
R20369 VSS.n6939 VSS.t2368 0.877212
R20370 VSS.t2243 VSS.n7652 0.877212
R20371 VSS.t2228 VSS.n7749 0.877212
R20372 VSS.t2213 VSS.n7855 0.877212
R20373 VSS.t2198 VSS.n7961 0.877212
R20374 VSS.t2183 VSS.n8067 0.877212
R20375 VSS.t2168 VSS.n8173 0.877212
R20376 VSS.n8273 VSS.t2153 0.877212
R20377 VSS.t2028 VSS.n8695 0.877212
R20378 VSS.t2013 VSS.n8787 0.877212
R20379 VSS.t1998 VSS.n8893 0.877212
R20380 VSS.t1983 VSS.n8999 0.877212
R20381 VSS.t1968 VSS.n9105 0.877212
R20382 VSS.t1953 VSS.n9211 0.877212
R20383 VSS.n9311 VSS.t1938 0.877212
R20384 VSS.t1813 VSS.n10044 0.877212
R20385 VSS.n9922 VSS.t1798 0.877212
R20386 VSS.n9821 VSS.t1783 0.877212
R20387 VSS.n9720 VSS.t1768 0.877212
R20388 VSS.n9619 VSS.t1753 0.877212
R20389 VSS.n9518 VSS.t1738 0.877212
R20390 VSS.n9417 VSS.t1723 0.877212
R20391 VSS.t1595 VSS.n11086 0.877212
R20392 VSS.n10964 VSS.t1580 0.877212
R20393 VSS.n10863 VSS.t1565 0.877212
R20394 VSS.n10762 VSS.t1550 0.877212
R20395 VSS.n10661 VSS.t1535 0.877212
R20396 VSS.n10560 VSS.t1520 0.877212
R20397 VSS.n10459 VSS.t1505 0.877212
R20398 VSS.t1380 VSS.n11172 0.877212
R20399 VSS.t1365 VSS.n11269 0.877212
R20400 VSS.t1350 VSS.n11375 0.877212
R20401 VSS.t1335 VSS.n11481 0.877212
R20402 VSS.t1320 VSS.n11587 0.877212
R20403 VSS.t1305 VSS.n11693 0.877212
R20404 VSS.n11793 VSS.t1290 0.877212
R20405 VSS.t1165 VSS.n12215 0.877212
R20406 VSS.t1150 VSS.n12307 0.877212
R20407 VSS.t1135 VSS.n12413 0.877212
R20408 VSS.t1120 VSS.n12519 0.877212
R20409 VSS.t1105 VSS.n12625 0.877212
R20410 VSS.t1090 VSS.n12731 0.877212
R20411 VSS.n12831 VSS.t1075 0.877212
R20412 VSS.t950 VSS.n13564 0.877212
R20413 VSS.n13442 VSS.t935 0.877212
R20414 VSS.n13341 VSS.t920 0.877212
R20415 VSS.n13240 VSS.t905 0.877212
R20416 VSS.n13139 VSS.t890 0.877212
R20417 VSS.n13038 VSS.t875 0.877212
R20418 VSS.n12937 VSS.t860 0.877212
R20419 VSS.t735 VSS.n14529 0.877212
R20420 VSS.n14407 VSS.t720 0.877212
R20421 VSS.n14209 VSS.t680 0.877212
R20422 VSS.n14047 VSS.t665 0.877212
R20423 VSS.n13946 VSS.t650 0.877212
R20424 VSS.t540 VSS.n14612 0.877212
R20425 VSS.n489 VSS.n488 0.833377
R20426 VSS.n885 VSS.n588 0.833377
R20427 VSS.n793 VSS.n792 0.833377
R20428 VSS.n696 VSS.n634 0.833377
R20429 VSS.n14253 VSS.n13724 0.833377
R20430 VSS.n14871 VSS.t234 0.833377
R20431 VSS.n15057 VSS.n15056 0.833377
R20432 VSS.t708 VSS.n13657 0.817521
R20433 VSS.t14 VSS.n14772 0.753441
R20434 VSS.t3280 VSS.n14816 0.753441
R20435 VSS.n15066 VSS.t3269 0.753441
R20436 VSS.t129 VSS.n15105 0.753441
R20437 VSS.n14818 VSS.t436 0.749436
R20438 VSS.n14896 VSS.n353 0.749038
R20439 VSS.n3492 VSS.n3491 0.746688
R20440 VSS.n3542 VSS.n3541 0.746688
R20441 VSS.n3592 VSS.n3591 0.746688
R20442 VSS.n3642 VSS.n3641 0.746688
R20443 VSS.n3692 VSS.n3691 0.746688
R20444 VSS.n5290 VSS.n5068 0.746688
R20445 VSS.n5396 VSS.n5026 0.746688
R20446 VSS.n5502 VSS.n4984 0.746688
R20447 VSS.n5608 VSS.n4942 0.746688
R20448 VSS.n5714 VSS.n4900 0.746688
R20449 VSS.n4515 VSS.n4514 0.746688
R20450 VSS.n4565 VSS.n4564 0.746688
R20451 VSS.n4615 VSS.n4614 0.746688
R20452 VSS.n4665 VSS.n4664 0.746688
R20453 VSS.n4715 VSS.n4714 0.746688
R20454 VSS.n6596 VSS.n6595 0.746688
R20455 VSS.n6646 VSS.n6645 0.746688
R20456 VSS.n6696 VSS.n6695 0.746688
R20457 VSS.n6746 VSS.n6745 0.746688
R20458 VSS.n6796 VSS.n6795 0.746688
R20459 VSS.n7772 VSS.n2496 0.746688
R20460 VSS.n7878 VSS.n2454 0.746688
R20461 VSS.n7984 VSS.n2412 0.746688
R20462 VSS.n8090 VSS.n2370 0.746688
R20463 VSS.n8196 VSS.n2328 0.746688
R20464 VSS.n8810 VSS.n8588 0.746688
R20465 VSS.n8916 VSS.n8546 0.746688
R20466 VSS.n9022 VSS.n8504 0.746688
R20467 VSS.n9128 VSS.n8462 0.746688
R20468 VSS.n9234 VSS.n8420 0.746688
R20469 VSS.n1962 VSS.n1961 0.746688
R20470 VSS.n2012 VSS.n2011 0.746688
R20471 VSS.n2062 VSS.n2061 0.746688
R20472 VSS.n2112 VSS.n2111 0.746688
R20473 VSS.n2162 VSS.n2161 0.746688
R20474 VSS.n10116 VSS.n10115 0.746688
R20475 VSS.n10166 VSS.n10165 0.746688
R20476 VSS.n10216 VSS.n10215 0.746688
R20477 VSS.n10266 VSS.n10265 0.746688
R20478 VSS.n10316 VSS.n10315 0.746688
R20479 VSS.n11292 VSS.n1874 0.746688
R20480 VSS.n11398 VSS.n1832 0.746688
R20481 VSS.n11504 VSS.n1790 0.746688
R20482 VSS.n11610 VSS.n1748 0.746688
R20483 VSS.n11716 VSS.n1706 0.746688
R20484 VSS.n12330 VSS.n12108 0.746688
R20485 VSS.n12436 VSS.n12066 0.746688
R20486 VSS.n12542 VSS.n12024 0.746688
R20487 VSS.n12648 VSS.n11982 0.746688
R20488 VSS.n12754 VSS.n11940 0.746688
R20489 VSS.n1321 VSS.n1320 0.746688
R20490 VSS.n1371 VSS.n1370 0.746688
R20491 VSS.n1421 VSS.n1420 0.746688
R20492 VSS.n1471 VSS.n1470 0.746688
R20493 VSS.n1521 VSS.n1520 0.746688
R20494 VSS.n13636 VSS.n13635 0.746688
R20495 VSS.t4304 VSS.n14268 0.746688
R20496 VSS.n13753 VSS.n13752 0.746688
R20497 VSS.n13803 VSS.n13802 0.746688
R20498 VSS.n3764 VSS.n3763 0.745706
R20499 VSS.n2234 VSS.n2233 0.745706
R20500 VSS.n14717 VSS.n426 0.711611
R20501 VSS.n14736 VSS.n408 0.711611
R20502 VSS.t67 VSS.n13683 0.613266
R20503 VSS.n5827 VSS.n5826 0.605591
R20504 VSS.n5850 VSS.n5849 0.605591
R20505 VSS.n4791 VSS.n4787 0.605591
R20506 VSS.n4777 VSS.n4773 0.605591
R20507 VSS.n6872 VSS.n6868 0.605591
R20508 VSS.n6858 VSS.n6854 0.605591
R20509 VSS.n8309 VSS.n8308 0.605591
R20510 VSS.n8332 VSS.n8331 0.605591
R20511 VSS.n9347 VSS.n9346 0.605591
R20512 VSS.n9370 VSS.n9369 0.605591
R20513 VSS.n10392 VSS.n10388 0.605591
R20514 VSS.n10378 VSS.n10374 0.605591
R20515 VSS.n11829 VSS.n11828 0.605591
R20516 VSS.n11852 VSS.n11851 0.605591
R20517 VSS.n12867 VSS.n12866 0.605591
R20518 VSS.n12890 VSS.n12889 0.605591
R20519 VSS.n1597 VSS.n1593 0.605591
R20520 VSS.n1583 VSS.n1579 0.605591
R20521 VSS.n13879 VSS.n13875 0.605591
R20522 VSS.n13865 VSS.n13861 0.605591
R20523 VSS.n15175 VSS.n15171 0.605591
R20524 VSS.n15161 VSS.n15157 0.605591
R20525 VSS.n14973 VSS.n328 0.605591
R20526 VSS.n14999 VSS.n14998 0.605591
R20527 VSS.n4459 VSS.n4458 0.603191
R20528 VSS.n4294 VSS.n3491 0.603191
R20529 VSS.n4193 VSS.n3541 0.603191
R20530 VSS.n4092 VSS.n3591 0.603191
R20531 VSS.n3991 VSS.n3641 0.603191
R20532 VSS.n3890 VSS.n3691 0.603191
R20533 VSS.n5190 VSS.n5111 0.603191
R20534 VSS.n5291 VSS.n5290 0.603191
R20535 VSS.n5397 VSS.n5396 0.603191
R20536 VSS.n5503 VSS.n5502 0.603191
R20537 VSS.n5609 VSS.n5608 0.603191
R20538 VSS.n5715 VSS.n5714 0.603191
R20539 VSS.n6540 VSS.n6539 0.603191
R20540 VSS.n6375 VSS.n4514 0.603191
R20541 VSS.n6274 VSS.n4564 0.603191
R20542 VSS.n6173 VSS.n4614 0.603191
R20543 VSS.n6072 VSS.n4664 0.603191
R20544 VSS.n5971 VSS.n4714 0.603191
R20545 VSS.n7582 VSS.n7581 0.603191
R20546 VSS.n7417 VSS.n6595 0.603191
R20547 VSS.n7316 VSS.n6645 0.603191
R20548 VSS.n7215 VSS.n6695 0.603191
R20549 VSS.n7114 VSS.n6745 0.603191
R20550 VSS.n7013 VSS.n6795 0.603191
R20551 VSS.n7668 VSS.n7667 0.603191
R20552 VSS.n7773 VSS.n7772 0.603191
R20553 VSS.n7879 VSS.n7878 0.603191
R20554 VSS.n7985 VSS.n7984 0.603191
R20555 VSS.n8091 VSS.n8090 0.603191
R20556 VSS.n8197 VSS.n8196 0.603191
R20557 VSS.n8710 VSS.n8631 0.603191
R20558 VSS.n8811 VSS.n8810 0.603191
R20559 VSS.n8917 VSS.n8916 0.603191
R20560 VSS.n9023 VSS.n9022 0.603191
R20561 VSS.n9129 VSS.n9128 0.603191
R20562 VSS.n9235 VSS.n9234 0.603191
R20563 VSS.n10060 VSS.n10059 0.603191
R20564 VSS.n9895 VSS.n1961 0.603191
R20565 VSS.n9794 VSS.n2011 0.603191
R20566 VSS.n9693 VSS.n2061 0.603191
R20567 VSS.n9592 VSS.n2111 0.603191
R20568 VSS.n9491 VSS.n2161 0.603191
R20569 VSS.n11102 VSS.n11101 0.603191
R20570 VSS.n10937 VSS.n10115 0.603191
R20571 VSS.n10836 VSS.n10165 0.603191
R20572 VSS.n10735 VSS.n10215 0.603191
R20573 VSS.n10634 VSS.n10265 0.603191
R20574 VSS.n10533 VSS.n10315 0.603191
R20575 VSS.n11188 VSS.n11187 0.603191
R20576 VSS.n11293 VSS.n11292 0.603191
R20577 VSS.n11399 VSS.n11398 0.603191
R20578 VSS.n11505 VSS.n11504 0.603191
R20579 VSS.n11611 VSS.n11610 0.603191
R20580 VSS.n11717 VSS.n11716 0.603191
R20581 VSS.n12230 VSS.n12151 0.603191
R20582 VSS.n12331 VSS.n12330 0.603191
R20583 VSS.n12437 VSS.n12436 0.603191
R20584 VSS.n12543 VSS.n12542 0.603191
R20585 VSS.n12649 VSS.n12648 0.603191
R20586 VSS.n12755 VSS.n12754 0.603191
R20587 VSS.n13580 VSS.n13579 0.603191
R20588 VSS.n13415 VSS.n1320 0.603191
R20589 VSS.n13314 VSS.n1370 0.603191
R20590 VSS.n13213 VSS.n1420 0.603191
R20591 VSS.n13112 VSS.n1470 0.603191
R20592 VSS.n13011 VSS.n1520 0.603191
R20593 VSS.n14545 VSS.n14544 0.603191
R20594 VSS.n14380 VSS.n13635 0.603191
R20595 VSS.n14121 VSS.n13752 0.603191
R20596 VSS.n14020 VSS.n13802 0.603191
R20597 VSS.n14628 VSS.n14627 0.603191
R20598 VSS.n13673 VSS.t608 0.541345
R20599 VSS.n13697 VSS.t605 0.541345
R20600 VSS.n485 VSS.n472 0.526527
R20601 VSS.n888 VSS.n887 0.526527
R20602 VSS.n597 VSS.n595 0.526527
R20603 VSS.n699 VSS.n698 0.526527
R20604 VSS.t3396 VSS.n13702 0.526527
R20605 VSS.n14256 VSS.n14255 0.526527
R20606 VSS.n15239 VSS.t3415 0.526527
R20607 VSS.n14868 VSS.n362 0.526527
R20608 VSS.n15052 VSS.n313 0.526527
R20609 VSS.n14874 VSS.t3 0.482692
R20610 VSS.n13700 VSS.n13669 0.473162
R20611 VSS.n13688 VSS.n13687 0.473162
R20612 VSS.n15301 VSS.n15300 0.438856
R20613 VSS.n15287 VSS.n15285 0.438856
R20614 VSS.n15323 VSS.n15322 0.438856
R20615 VSS.n15277 VSS.n15275 0.438856
R20616 VSS.n70 VSS.n505 2.09649
R20617 VSS.n38 VSS.n512 2.59411
R20618 VSS.n1264 VSS.n1263 0.438856
R20619 VSS.n56 VSS.n459 5.28095
R20620 VSS.n1238 VSS.n1205 0.438856
R20621 VSS.n1233 VSS.n1230 0.438856
R20622 VSS.n1176 VSS.n534 0.438856
R20623 VSS.n1184 VSS.n1183 0.438856
R20624 VSS.n1153 VSS.n543 0.438856
R20625 VSS.n1161 VSS.n1160 0.438856
R20626 VSS.n1075 VSS.n1074 0.438856
R20627 VSS.n1065 VSS.n1064 0.438856
R20628 VSS.n1097 VSS.n1036 0.438856
R20629 VSS.n1092 VSS.n1089 0.438856
R20630 VSS.n1016 VSS.n566 0.438856
R20631 VSS.n1024 VSS.n1023 0.438856
R20632 VSS.n960 VSS.n959 0.438856
R20633 VSS.n950 VSS.n949 0.438856
R20634 VSS.n982 VSS.n922 0.438856
R20635 VSS.n977 VSS.n974 0.438856
R20636 VSS.n848 VSS.n847 0.438856
R20637 VSS.n838 VSS.n837 0.438856
R20638 VSS.n870 VSS.n809 0.438856
R20639 VSS.n865 VSS.n862 0.438856
R20640 VSS.n766 VSS.n607 0.438856
R20641 VSS.n774 VSS.n773 0.438856
R20642 VSS.n737 VSS.n618 0.438856
R20643 VSS.n745 VSS.n744 0.438856
R20644 VSS.n714 VSS.n627 0.438856
R20645 VSS.n722 VSS.n721 0.438856
R20646 VSS.n162 VSS.n648 2.09649
R20647 VSS.n15248 VSS.n298 0.438856
R20648 VSS.n15243 VSS.n3 5.28095
R20649 VSS.n3759 VSS.n3758 0.438856
R20650 VSS.n4441 VSS.n4440 0.438856
R20651 VSS.n4431 VSS.n4430 0.438856
R20652 VSS.n4343 VSS.n3464 0.438856
R20653 VSS.n4351 VSS.n4350 0.438856
R20654 VSS.n4323 VSS.n3477 0.438856
R20655 VSS.n3472 VSS.n3471 0.438856
R20656 VSS.n4242 VSS.n3514 0.438856
R20657 VSS.n4250 VSS.n4249 0.438856
R20658 VSS.n4222 VSS.n3527 0.438856
R20659 VSS.n3522 VSS.n3521 0.438856
R20660 VSS.n4141 VSS.n3564 0.438856
R20661 VSS.n4149 VSS.n4148 0.438856
R20662 VSS.n4121 VSS.n3577 0.438856
R20663 VSS.n3572 VSS.n3571 0.438856
R20664 VSS.n4040 VSS.n3614 0.438856
R20665 VSS.n4048 VSS.n4047 0.438856
R20666 VSS.n4020 VSS.n3627 0.438856
R20667 VSS.n3622 VSS.n3621 0.438856
R20668 VSS.n3939 VSS.n3664 0.438856
R20669 VSS.n3947 VSS.n3946 0.438856
R20670 VSS.n3919 VSS.n3677 0.438856
R20671 VSS.n3672 VSS.n3671 0.438856
R20672 VSS.n3838 VSS.n3714 0.438856
R20673 VSS.n3846 VSS.n3845 0.438856
R20674 VSS.n3818 VSS.n3727 0.438856
R20675 VSS.n3722 VSS.n3721 0.438856
R20676 VSS.n5173 VSS.n5172 0.438856
R20677 VSS.n5163 VSS.n5162 0.438856
R20678 VSS.n5236 VSS.n5084 0.438856
R20679 VSS.n5231 VSS.n5088 0.438856
R20680 VSS.n5265 VSS.n5264 0.438856
R20681 VSS.n5255 VSS.n5254 0.438856
R20682 VSS.n5342 VSS.n5042 0.438856
R20683 VSS.n5337 VSS.n5046 0.438856
R20684 VSS.n5371 VSS.n5370 0.438856
R20685 VSS.n5361 VSS.n5360 0.438856
R20686 VSS.n5448 VSS.n5000 0.438856
R20687 VSS.n5443 VSS.n5004 0.438856
R20688 VSS.n5477 VSS.n5476 0.438856
R20689 VSS.n5467 VSS.n5466 0.438856
R20690 VSS.n5554 VSS.n4958 0.438856
R20691 VSS.n5549 VSS.n4962 0.438856
R20692 VSS.n5583 VSS.n5582 0.438856
R20693 VSS.n5573 VSS.n5572 0.438856
R20694 VSS.n5660 VSS.n4916 0.438856
R20695 VSS.n5655 VSS.n4920 0.438856
R20696 VSS.n5689 VSS.n5688 0.438856
R20697 VSS.n5679 VSS.n5678 0.438856
R20698 VSS.n5766 VSS.n4874 0.438856
R20699 VSS.n5761 VSS.n4878 0.438856
R20700 VSS.n5793 VSS.n4850 0.438856
R20701 VSS.n5786 VSS.n135 0.438856
R20702 VSS.n6522 VSS.n6521 0.438856
R20703 VSS.n6512 VSS.n6511 0.438856
R20704 VSS.n6424 VSS.n4487 0.438856
R20705 VSS.n6432 VSS.n6431 0.438856
R20706 VSS.n6404 VSS.n4500 0.438856
R20707 VSS.n4495 VSS.n4494 0.438856
R20708 VSS.n6323 VSS.n4537 0.438856
R20709 VSS.n6331 VSS.n6330 0.438856
R20710 VSS.n6303 VSS.n4550 0.438856
R20711 VSS.n4545 VSS.n4544 0.438856
R20712 VSS.n6222 VSS.n4587 0.438856
R20713 VSS.n6230 VSS.n6229 0.438856
R20714 VSS.n6202 VSS.n4600 0.438856
R20715 VSS.n4595 VSS.n4594 0.438856
R20716 VSS.n6121 VSS.n4637 0.438856
R20717 VSS.n6129 VSS.n6128 0.438856
R20718 VSS.n6101 VSS.n4650 0.438856
R20719 VSS.n4645 VSS.n4644 0.438856
R20720 VSS.n6020 VSS.n4687 0.438856
R20721 VSS.n6028 VSS.n6027 0.438856
R20722 VSS.n6000 VSS.n4700 0.438856
R20723 VSS.n4695 VSS.n4694 0.438856
R20724 VSS.n5919 VSS.n4737 0.438856
R20725 VSS.n5927 VSS.n5926 0.438856
R20726 VSS.n5899 VSS.n4750 0.438856
R20727 VSS.n4745 VSS.n4744 0.438856
R20728 VSS.n7564 VSS.n7563 0.438856
R20729 VSS.n7554 VSS.n7553 0.438856
R20730 VSS.n7466 VSS.n6568 0.438856
R20731 VSS.n7474 VSS.n7473 0.438856
R20732 VSS.n7446 VSS.n6581 0.438856
R20733 VSS.n6576 VSS.n6575 0.438856
R20734 VSS.n7365 VSS.n6618 0.438856
R20735 VSS.n7373 VSS.n7372 0.438856
R20736 VSS.n7345 VSS.n6631 0.438856
R20737 VSS.n6626 VSS.n6625 0.438856
R20738 VSS.n7264 VSS.n6668 0.438856
R20739 VSS.n7272 VSS.n7271 0.438856
R20740 VSS.n7244 VSS.n6681 0.438856
R20741 VSS.n6676 VSS.n6675 0.438856
R20742 VSS.n7163 VSS.n6718 0.438856
R20743 VSS.n7171 VSS.n7170 0.438856
R20744 VSS.n7143 VSS.n6731 0.438856
R20745 VSS.n6726 VSS.n6725 0.438856
R20746 VSS.n7062 VSS.n6768 0.438856
R20747 VSS.n7070 VSS.n7069 0.438856
R20748 VSS.n7042 VSS.n6781 0.438856
R20749 VSS.n6776 VSS.n6775 0.438856
R20750 VSS.n6961 VSS.n6818 0.438856
R20751 VSS.n6969 VSS.n6968 0.438856
R20752 VSS.n6941 VSS.n6831 0.438856
R20753 VSS.n6826 VSS.n6825 0.438856
R20754 VSS.n7650 VSS.n7649 0.438856
R20755 VSS.n7640 VSS.n7639 0.438856
R20756 VSS.n7718 VSS.n2512 0.438856
R20757 VSS.n7713 VSS.n2516 0.438856
R20758 VSS.n7747 VSS.n7746 0.438856
R20759 VSS.n7737 VSS.n7736 0.438856
R20760 VSS.n7824 VSS.n2470 0.438856
R20761 VSS.n7819 VSS.n2474 0.438856
R20762 VSS.n7853 VSS.n7852 0.438856
R20763 VSS.n7843 VSS.n7842 0.438856
R20764 VSS.n7930 VSS.n2428 0.438856
R20765 VSS.n7925 VSS.n2432 0.438856
R20766 VSS.n7959 VSS.n7958 0.438856
R20767 VSS.n7949 VSS.n7948 0.438856
R20768 VSS.n8036 VSS.n2386 0.438856
R20769 VSS.n8031 VSS.n2390 0.438856
R20770 VSS.n8065 VSS.n8064 0.438856
R20771 VSS.n8055 VSS.n8054 0.438856
R20772 VSS.n8142 VSS.n2344 0.438856
R20773 VSS.n8137 VSS.n2348 0.438856
R20774 VSS.n8171 VSS.n8170 0.438856
R20775 VSS.n8161 VSS.n8160 0.438856
R20776 VSS.n8248 VSS.n2302 0.438856
R20777 VSS.n8243 VSS.n2306 0.438856
R20778 VSS.n8275 VSS.n2278 0.438856
R20779 VSS.n8268 VSS.n141 0.438856
R20780 VSS.n8693 VSS.n8692 0.438856
R20781 VSS.n8683 VSS.n8682 0.438856
R20782 VSS.n8756 VSS.n8604 0.438856
R20783 VSS.n8751 VSS.n8608 0.438856
R20784 VSS.n8785 VSS.n8784 0.438856
R20785 VSS.n8775 VSS.n8774 0.438856
R20786 VSS.n8862 VSS.n8562 0.438856
R20787 VSS.n8857 VSS.n8566 0.438856
R20788 VSS.n8891 VSS.n8890 0.438856
R20789 VSS.n8881 VSS.n8880 0.438856
R20790 VSS.n8968 VSS.n8520 0.438856
R20791 VSS.n8963 VSS.n8524 0.438856
R20792 VSS.n8997 VSS.n8996 0.438856
R20793 VSS.n8987 VSS.n8986 0.438856
R20794 VSS.n9074 VSS.n8478 0.438856
R20795 VSS.n9069 VSS.n8482 0.438856
R20796 VSS.n9103 VSS.n9102 0.438856
R20797 VSS.n9093 VSS.n9092 0.438856
R20798 VSS.n9180 VSS.n8436 0.438856
R20799 VSS.n9175 VSS.n8440 0.438856
R20800 VSS.n9209 VSS.n9208 0.438856
R20801 VSS.n9199 VSS.n9198 0.438856
R20802 VSS.n9286 VSS.n8394 0.438856
R20803 VSS.n9281 VSS.n8398 0.438856
R20804 VSS.n9313 VSS.n8370 0.438856
R20805 VSS.n9306 VSS.n147 0.438856
R20806 VSS.n2229 VSS.n2228 0.438856
R20807 VSS.n10042 VSS.n10041 0.438856
R20808 VSS.n10032 VSS.n10031 0.438856
R20809 VSS.n9944 VSS.n1934 0.438856
R20810 VSS.n9952 VSS.n9951 0.438856
R20811 VSS.n9924 VSS.n1947 0.438856
R20812 VSS.n1942 VSS.n1941 0.438856
R20813 VSS.n9843 VSS.n1984 0.438856
R20814 VSS.n9851 VSS.n9850 0.438856
R20815 VSS.n9823 VSS.n1997 0.438856
R20816 VSS.n1992 VSS.n1991 0.438856
R20817 VSS.n9742 VSS.n2034 0.438856
R20818 VSS.n9750 VSS.n9749 0.438856
R20819 VSS.n9722 VSS.n2047 0.438856
R20820 VSS.n2042 VSS.n2041 0.438856
R20821 VSS.n9641 VSS.n2084 0.438856
R20822 VSS.n9649 VSS.n9648 0.438856
R20823 VSS.n9621 VSS.n2097 0.438856
R20824 VSS.n2092 VSS.n2091 0.438856
R20825 VSS.n9540 VSS.n2134 0.438856
R20826 VSS.n9548 VSS.n9547 0.438856
R20827 VSS.n9520 VSS.n2147 0.438856
R20828 VSS.n2142 VSS.n2141 0.438856
R20829 VSS.n9439 VSS.n2184 0.438856
R20830 VSS.n9447 VSS.n9446 0.438856
R20831 VSS.n9419 VSS.n2197 0.438856
R20832 VSS.n2192 VSS.n2191 0.438856
R20833 VSS.n11084 VSS.n11083 0.438856
R20834 VSS.n11074 VSS.n11073 0.438856
R20835 VSS.n10986 VSS.n10088 0.438856
R20836 VSS.n10994 VSS.n10993 0.438856
R20837 VSS.n10966 VSS.n10101 0.438856
R20838 VSS.n10096 VSS.n10095 0.438856
R20839 VSS.n10885 VSS.n10138 0.438856
R20840 VSS.n10893 VSS.n10892 0.438856
R20841 VSS.n10865 VSS.n10151 0.438856
R20842 VSS.n10146 VSS.n10145 0.438856
R20843 VSS.n10784 VSS.n10188 0.438856
R20844 VSS.n10792 VSS.n10791 0.438856
R20845 VSS.n10764 VSS.n10201 0.438856
R20846 VSS.n10196 VSS.n10195 0.438856
R20847 VSS.n10683 VSS.n10238 0.438856
R20848 VSS.n10691 VSS.n10690 0.438856
R20849 VSS.n10663 VSS.n10251 0.438856
R20850 VSS.n10246 VSS.n10245 0.438856
R20851 VSS.n10582 VSS.n10288 0.438856
R20852 VSS.n10590 VSS.n10589 0.438856
R20853 VSS.n10562 VSS.n10301 0.438856
R20854 VSS.n10296 VSS.n10295 0.438856
R20855 VSS.n10481 VSS.n10338 0.438856
R20856 VSS.n10489 VSS.n10488 0.438856
R20857 VSS.n10461 VSS.n10351 0.438856
R20858 VSS.n10346 VSS.n10345 0.438856
R20859 VSS.n11170 VSS.n11169 0.438856
R20860 VSS.n11160 VSS.n11159 0.438856
R20861 VSS.n11238 VSS.n1890 0.438856
R20862 VSS.n11233 VSS.n1894 0.438856
R20863 VSS.n11267 VSS.n11266 0.438856
R20864 VSS.n11257 VSS.n11256 0.438856
R20865 VSS.n11344 VSS.n1848 0.438856
R20866 VSS.n11339 VSS.n1852 0.438856
R20867 VSS.n11373 VSS.n11372 0.438856
R20868 VSS.n11363 VSS.n11362 0.438856
R20869 VSS.n11450 VSS.n1806 0.438856
R20870 VSS.n11445 VSS.n1810 0.438856
R20871 VSS.n11479 VSS.n11478 0.438856
R20872 VSS.n11469 VSS.n11468 0.438856
R20873 VSS.n11556 VSS.n1764 0.438856
R20874 VSS.n11551 VSS.n1768 0.438856
R20875 VSS.n11585 VSS.n11584 0.438856
R20876 VSS.n11575 VSS.n11574 0.438856
R20877 VSS.n11662 VSS.n1722 0.438856
R20878 VSS.n11657 VSS.n1726 0.438856
R20879 VSS.n11691 VSS.n11690 0.438856
R20880 VSS.n11681 VSS.n11680 0.438856
R20881 VSS.n11768 VSS.n1680 0.438856
R20882 VSS.n11763 VSS.n1684 0.438856
R20883 VSS.n11795 VSS.n1656 0.438856
R20884 VSS.n11788 VSS.n153 0.438856
R20885 VSS.n12213 VSS.n12212 0.438856
R20886 VSS.n12203 VSS.n12202 0.438856
R20887 VSS.n12276 VSS.n12124 0.438856
R20888 VSS.n12271 VSS.n12128 0.438856
R20889 VSS.n12305 VSS.n12304 0.438856
R20890 VSS.n12295 VSS.n12294 0.438856
R20891 VSS.n12382 VSS.n12082 0.438856
R20892 VSS.n12377 VSS.n12086 0.438856
R20893 VSS.n12411 VSS.n12410 0.438856
R20894 VSS.n12401 VSS.n12400 0.438856
R20895 VSS.n12488 VSS.n12040 0.438856
R20896 VSS.n12483 VSS.n12044 0.438856
R20897 VSS.n12517 VSS.n12516 0.438856
R20898 VSS.n12507 VSS.n12506 0.438856
R20899 VSS.n12594 VSS.n11998 0.438856
R20900 VSS.n12589 VSS.n12002 0.438856
R20901 VSS.n12623 VSS.n12622 0.438856
R20902 VSS.n12613 VSS.n12612 0.438856
R20903 VSS.n12700 VSS.n11956 0.438856
R20904 VSS.n12695 VSS.n11960 0.438856
R20905 VSS.n12729 VSS.n12728 0.438856
R20906 VSS.n12719 VSS.n12718 0.438856
R20907 VSS.n12806 VSS.n11914 0.438856
R20908 VSS.n12801 VSS.n11918 0.438856
R20909 VSS.n12833 VSS.n11890 0.438856
R20910 VSS.n12826 VSS.n159 0.438856
R20911 VSS.n13562 VSS.n13561 0.438856
R20912 VSS.n13552 VSS.n13551 0.438856
R20913 VSS.n13464 VSS.n1293 0.438856
R20914 VSS.n13472 VSS.n13471 0.438856
R20915 VSS.n13444 VSS.n1306 0.438856
R20916 VSS.n1301 VSS.n1300 0.438856
R20917 VSS.n13363 VSS.n1343 0.438856
R20918 VSS.n13371 VSS.n13370 0.438856
R20919 VSS.n13343 VSS.n1356 0.438856
R20920 VSS.n1351 VSS.n1350 0.438856
R20921 VSS.n13262 VSS.n1393 0.438856
R20922 VSS.n13270 VSS.n13269 0.438856
R20923 VSS.n13242 VSS.n1406 0.438856
R20924 VSS.n1401 VSS.n1400 0.438856
R20925 VSS.n13161 VSS.n1443 0.438856
R20926 VSS.n13169 VSS.n13168 0.438856
R20927 VSS.n13141 VSS.n1456 0.438856
R20928 VSS.n1451 VSS.n1450 0.438856
R20929 VSS.n13060 VSS.n1493 0.438856
R20930 VSS.n13068 VSS.n13067 0.438856
R20931 VSS.n13040 VSS.n1506 0.438856
R20932 VSS.n1501 VSS.n1500 0.438856
R20933 VSS.n12959 VSS.n1543 0.438856
R20934 VSS.n12967 VSS.n12966 0.438856
R20935 VSS.n12939 VSS.n1556 0.438856
R20936 VSS.n1551 VSS.n1550 0.438856
R20937 VSS.n14527 VSS.n14526 0.438856
R20938 VSS.n14517 VSS.n14516 0.438856
R20939 VSS.n14429 VSS.n13608 0.438856
R20940 VSS.n14437 VSS.n14436 0.438856
R20941 VSS.n14409 VSS.n13621 0.438856
R20942 VSS.n13616 VSS.n13615 0.438856
R20943 VSS.n14342 VSS.n13655 0.438856
R20944 VSS.n14321 VSS.n13663 0.438856
R20945 VSS.n14329 VSS.n14328 0.438856
R20946 VSS.n14299 VSS.n13704 0.438856
R20947 VSS.n14307 VSS.n14306 0.438856
R20948 VSS.n14178 VSS.n14158 0.438856
R20949 VSS.n14170 VSS.n14169 0.438856
R20950 VSS.n14211 VSS.n13741 0.438856
R20951 VSS.n14204 VSS.n14148 0.438856
R20952 VSS.n14069 VSS.n13775 0.438856
R20953 VSS.n14077 VSS.n14076 0.438856
R20954 VSS.n14049 VSS.n13788 0.438856
R20955 VSS.n13783 VSS.n13782 0.438856
R20956 VSS.n13968 VSS.n13825 0.438856
R20957 VSS.n13976 VSS.n13975 0.438856
R20958 VSS.n13948 VSS.n13838 0.438856
R20959 VSS.n13833 VSS.n13832 0.438856
R20960 VSS.n15236 VSS.n15235 0.438856
R20961 VSS.n15230 VSS.n15229 0.438856
R20962 VSS.n14610 VSS.n14609 0.438856
R20963 VSS.n14600 VSS.n14599 0.438856
R20964 VSS.n14678 VSS.n438 0.438856
R20965 VSS.n14673 VSS.n442 0.438856
R20966 VSS.n14707 VSS.n14706 0.438856
R20967 VSS.n14697 VSS.n14696 0.438856
R20968 VSS.n14726 VSS.n14725 0.438856
R20969 VSS.n420 VSS.n416 0.438856
R20970 VSS.n14744 VSS.n14743 0.438856
R20971 VSS.n402 VSS.n398 0.438856
R20972 VSS.n14901 VSS.n352 0.438856
R20973 VSS.n14943 VSS.n14942 0.438856
R20974 VSS.n14934 VSS.n14933 0.438856
R20975 VSS.n15113 VSS.n15087 0.438856
R20976 VSS.n262 VSS.n250 0.438856
R20977 VSS.n270 VSS.n269 0.438856
R20978 VSS.n15348 VSS.n237 0.438856
R20979 VSS.n1 VSS.n15355 5.28095
R20980 VSS.n2891 VSS.n161 2.09649
R20981 VSS.n2575 VSS.n2543 0.438856
R20982 VSS.n2570 VSS.n2567 0.438856
R20983 VSS.n69 VSS.n2585 2.09649
R20984 VSS.n36 VSS.n2592 2.59411
R20985 VSS.n3435 VSS.n3434 0.438856
R20986 VSS.n57 VSS.n2533 5.28095
R20987 VSS.n2649 VSS.n2648 0.438856
R20988 VSS.n2639 VSS.n2638 0.438856
R20989 VSS.n2671 VSS.n2610 0.438856
R20990 VSS.n2666 VSS.n2663 0.438856
R20991 VSS.n3402 VSS.n2683 0.438856
R20992 VSS.n3410 VSS.n3409 0.438856
R20993 VSS.n3379 VSS.n2692 0.438856
R20994 VSS.n3387 VSS.n3386 0.438856
R20995 VSS.n3350 VSS.n2703 0.438856
R20996 VSS.n3358 VSS.n3357 0.438856
R20997 VSS.n3327 VSS.n2712 0.438856
R20998 VSS.n3335 VSS.n3334 0.438856
R20999 VSS.n3298 VSS.n2723 0.438856
R21000 VSS.n3306 VSS.n3305 0.438856
R21001 VSS.n3275 VSS.n2732 0.438856
R21002 VSS.n3283 VSS.n3282 0.438856
R21003 VSS.n3246 VSS.n2743 0.438856
R21004 VSS.n3254 VSS.n3253 0.438856
R21005 VSS.n3223 VSS.n2752 0.438856
R21006 VSS.n3231 VSS.n3230 0.438856
R21007 VSS.n3194 VSS.n2763 0.438856
R21008 VSS.n3202 VSS.n3201 0.438856
R21009 VSS.n3171 VSS.n2772 0.438856
R21010 VSS.n3179 VSS.n3178 0.438856
R21011 VSS.n3142 VSS.n2783 0.438856
R21012 VSS.n3150 VSS.n3149 0.438856
R21013 VSS.n3119 VSS.n2792 0.438856
R21014 VSS.n3127 VSS.n3126 0.438856
R21015 VSS.n3090 VSS.n2803 0.438856
R21016 VSS.n3098 VSS.n3097 0.438856
R21017 VSS.n3067 VSS.n2812 0.438856
R21018 VSS.n3075 VSS.n3074 0.438856
R21019 VSS.n3038 VSS.n2823 0.438856
R21020 VSS.n3046 VSS.n3045 0.438856
R21021 VSS.n3015 VSS.n2832 0.438856
R21022 VSS.n3023 VSS.n3022 0.438856
R21023 VSS.n2986 VSS.n2843 0.438856
R21024 VSS.n2994 VSS.n2993 0.438856
R21025 VSS.n2963 VSS.n2852 0.438856
R21026 VSS.n2971 VSS.n2970 0.438856
R21027 VSS.n2934 VSS.n2863 0.438856
R21028 VSS.n2942 VSS.n2941 0.438856
R21029 VSS.n2911 VSS.n2872 0.438856
R21030 VSS.n2919 VSS.n2918 0.438856
R21031 VSS.n15295 VSS.t3111 0.417891
R21032 VSS.n478 VSS.t395 0.417891
R21033 VSS.t390 VSS.n521 0.417891
R21034 VSS.t389 VSS.n466 0.417891
R21035 VSS.t372 VSS.n1195 0.417891
R21036 VSS.t371 VSS.n527 0.417891
R21037 VSS.n1053 VSS.t357 0.417891
R21038 VSS.t356 VSS.n558 0.417891
R21039 VSS.n938 VSS.t342 0.417891
R21040 VSS.t341 VSS.n576 0.417891
R21041 VSS.n826 VSS.t327 0.417891
R21042 VSS.t326 VSS.n591 0.417891
R21043 VSS.t318 VSS.n803 0.417891
R21044 VSS.t317 VSS.n592 0.417891
R21045 VSS.t309 VSS.n756 0.417891
R21046 VSS.n758 VSS.t308 0.417891
R21047 VSS.n668 VSS.t294 0.417891
R21048 VSS.n672 VSS.t293 0.417891
R21049 VSS.t291 VSS.n659 0.417891
R21050 VSS.n663 VSS.t290 0.417891
R21051 VSS.t431 VSS.n367 0.417891
R21052 VSS.t430 VSS.n14847 0.417891
R21053 VSS.n14922 VSS.t422 0.417891
R21054 VSS.n14918 VSS.t421 0.417891
R21055 VSS.t275 VSS.n253 0.417891
R21056 VSS.t3127 VSS.n2901 0.417891
R21057 VSS.n2903 VSS.t3126 0.417891
R21058 VSS.t3240 VSS.n2550 0.417891
R21059 VSS.t3235 VSS.n2601 0.417891
R21060 VSS.t3234 VSS.n2540 0.417891
R21061 VSS.n2627 VSS.t3226 0.417891
R21062 VSS.t3225 VSS.n2539 0.417891
R21063 VSS.t3217 VSS.n3421 0.417891
R21064 VSS.t3216 VSS.n2607 0.417891
R21065 VSS.t3208 VSS.n3369 0.417891
R21066 VSS.n3371 VSS.t3207 0.417891
R21067 VSS.t3199 VSS.n3317 0.417891
R21068 VSS.n3319 VSS.t3198 0.417891
R21069 VSS.t3190 VSS.n3265 0.417891
R21070 VSS.n3267 VSS.t3189 0.417891
R21071 VSS.t3181 VSS.n3213 0.417891
R21072 VSS.n3215 VSS.t3180 0.417891
R21073 VSS.t3172 VSS.n3161 0.417891
R21074 VSS.n3163 VSS.t3171 0.417891
R21075 VSS.t3163 VSS.n3109 0.417891
R21076 VSS.n3111 VSS.t3162 0.417891
R21077 VSS.t3154 VSS.n3057 0.417891
R21078 VSS.n3059 VSS.t3153 0.417891
R21079 VSS.t3145 VSS.n3005 0.417891
R21080 VSS.n3007 VSS.t3144 0.417891
R21081 VSS.t3136 VSS.n2953 0.417891
R21082 VSS.n2955 VSS.t3135 0.417891
R21083 VSS.n14831 VSS.n14830 0.410187
R21084 VSS.n15317 VSS.t3114 0.409011
R21085 VSS.n15339 VSS.t3117 0.409011
R21086 VSS.n479 VSS.t393 0.409011
R21087 VSS.n520 VSS.t387 0.409011
R21088 VSS.n1214 VSS.t381 0.409011
R21089 VSS.n1220 VSS.t378 0.409011
R21090 VSS.n1254 VSS.t375 0.409011
R21091 VSS.t374 VSS.n1249 0.409011
R21092 VSS.n1194 VSS.t369 0.409011
R21093 VSS.t366 VSS.n537 0.409011
R21094 VSS.n1140 VSS.t363 0.409011
R21095 VSS.n1145 VSS.t362 0.409011
R21096 VSS.t360 VSS.n1122 0.409011
R21097 VSS.n1127 VSS.t359 0.409011
R21098 VSS.n1054 VSS.t354 0.409011
R21099 VSS.n1079 VSS.t351 0.409011
R21100 VSS.t348 VSS.n560 0.409011
R21101 VSS.n998 VSS.t345 0.409011
R21102 VSS.n939 VSS.t339 0.409011
R21103 VSS.n964 VSS.t336 0.409011
R21104 VSS.t333 VSS.n577 0.409011
R21105 VSS.n894 VSS.t330 0.409011
R21106 VSS.n827 VSS.t324 0.409011
R21107 VSS.n852 VSS.t321 0.409011
R21108 VSS.n802 VSS.t315 0.409011
R21109 VSS.t312 VSS.n601 0.409011
R21110 VSS.t306 VSS.n612 0.409011
R21111 VSS.t303 VSS.n621 0.409011
R21112 VSS.n705 VSS.t300 0.409011
R21113 VSS.t297 VSS.n681 0.409011
R21114 VSS.n686 VSS.t296 0.409011
R21115 VSS.n658 VSS.t288 0.409011
R21116 VSS.n126 VSS.t285 4.76073
R21117 VSS.n293 VSS.t282 0.409011
R21118 VSS.t705 VSS.n13667 0.409011
R21119 VSS.n14308 VSS.t185 0.409011
R21120 VSS.t696 VSS.n13710 0.409011
R21121 VSS.t3313 VSS.n14261 0.409011
R21122 VSS.n14262 VSS.t694 0.409011
R21123 VSS.n15218 VSS.t474 0.409011
R21124 VSS.n15145 VSS.t473 0.409011
R21125 VSS.n34 VSS.t239 5.22965
R21126 VSS.t476 VSS.n15228 0.409011
R21127 VSS.t428 VSS.n14857 0.409011
R21128 VSS.n14889 VSS.t505 0.409011
R21129 VSS.t504 VSS.n14884 0.409011
R21130 VSS.t3360 VSS.n14932 0.409011
R21131 VSS.n14923 VSS.t419 0.409011
R21132 VSS.t488 VSS.n15130 0.409011
R21133 VSS.n15046 VSS.t490 0.409011
R21134 VSS.t102 VSS.n15083 0.409011
R21135 VSS.t482 VSS.n304 0.409011
R21136 VSS.t481 VSS.n15093 0.409011
R21137 VSS.n280 VSS.t279 0.409011
R21138 VSS.n125 VSS.t3120 4.76073
R21139 VSS.t3123 VSS.n2887 0.409011
R21140 VSS.n2557 VSS.t3238 0.409011
R21141 VSS.n2600 VSS.t3232 0.409011
R21142 VSS.n2628 VSS.t3223 0.409011
R21143 VSS.n2653 VSS.t3220 0.409011
R21144 VSS.n3420 VSS.t3214 0.409011
R21145 VSS.t3211 VSS.n2686 0.409011
R21146 VSS.t3205 VSS.n2697 0.409011
R21147 VSS.t3202 VSS.n2706 0.409011
R21148 VSS.t3196 VSS.n2717 0.409011
R21149 VSS.t3193 VSS.n2726 0.409011
R21150 VSS.t3187 VSS.n2737 0.409011
R21151 VSS.t3184 VSS.n2746 0.409011
R21152 VSS.t3178 VSS.n2757 0.409011
R21153 VSS.t3175 VSS.n2766 0.409011
R21154 VSS.t3169 VSS.n2777 0.409011
R21155 VSS.t3166 VSS.n2786 0.409011
R21156 VSS.t3160 VSS.n2797 0.409011
R21157 VSS.t3157 VSS.n2806 0.409011
R21158 VSS.t3151 VSS.n2817 0.409011
R21159 VSS.t3148 VSS.n2826 0.409011
R21160 VSS.t3142 VSS.n2837 0.409011
R21161 VSS.t3139 VSS.n2846 0.409011
R21162 VSS.t3133 VSS.n2857 0.409011
R21163 VSS.t3130 VSS.n2866 0.409011
R21164 VSS.n15081 VSS.t485 0.409011
R21165 VSS.n14831 VSS.n372 0.408404
R21166 VSS.n14248 VSS.t3353 0.376971
R21167 VSS.n14162 VSS.n14161 0.358816
R21168 VSS.n3781 VSS.n3746 0.358087
R21169 VSS.n3794 VSS.n3739 0.358087
R21170 VSS.n5873 VSS.n4848 0.358087
R21171 VSS.n4836 VSS.n4762 0.358087
R21172 VSS.n6917 VSS.n6843 0.358087
R21173 VSS.n8355 VSS.n2276 0.358087
R21174 VSS.n9393 VSS.n8368 0.358087
R21175 VSS.n2251 VSS.n2216 0.358087
R21176 VSS.n2264 VSS.n2209 0.358087
R21177 VSS.n10437 VSS.n10363 0.358087
R21178 VSS.n11875 VSS.n1654 0.358087
R21179 VSS.n12913 VSS.n11888 0.358087
R21180 VSS.n1642 VSS.n1568 0.358087
R21181 VSS.n13924 VSS.n13850 0.358087
R21182 VSS.n15027 VSS.n15003 0.357692
R21183 VSS.n3794 VSS.n3793 0.357304
R21184 VSS.n5799 VSS.n4848 0.357304
R21185 VSS.n4836 VSS.n4835 0.357304
R21186 VSS.n6917 VSS.n6916 0.357304
R21187 VSS.n8281 VSS.n2276 0.357304
R21188 VSS.n9319 VSS.n8368 0.357304
R21189 VSS.n2264 VSS.n2263 0.357304
R21190 VSS.n10437 VSS.n10436 0.357304
R21191 VSS.n11801 VSS.n1654 0.357304
R21192 VSS.n12839 VSS.n11888 0.357304
R21193 VSS.n1642 VSS.n1641 0.357304
R21194 VSS.n13924 VSS.n13923 0.357304
R21195 VSS.n13670 VSS.n13669 0.354995
R21196 VSS.n13687 VSS.n13686 0.354995
R21197 VSS.n14253 VSS.t3321 0.351185
R21198 VSS.n13694 VSS.t201 0.340926
R21199 VSS.n3755 VSS.t3356 0.307349
R21200 VSS.n2225 VSS.t3399 0.307349
R21201 VSS.n3894 VSS.n3693 0.298074
R21202 VSS.n3995 VSS.n3643 0.298074
R21203 VSS.n4096 VSS.n3593 0.298074
R21204 VSS.n4197 VSS.n3543 0.298074
R21205 VSS.n4298 VSS.n3493 0.298074
R21206 VSS.n5720 VSS.n5719 0.298074
R21207 VSS.n5614 VSS.n5613 0.298074
R21208 VSS.n5508 VSS.n5507 0.298074
R21209 VSS.n5402 VSS.n5401 0.298074
R21210 VSS.n5296 VSS.n5295 0.298074
R21211 VSS.n5975 VSS.n4716 0.298074
R21212 VSS.n6076 VSS.n4666 0.298074
R21213 VSS.n6177 VSS.n4616 0.298074
R21214 VSS.n6278 VSS.n4566 0.298074
R21215 VSS.n6379 VSS.n4516 0.298074
R21216 VSS.n7017 VSS.n6797 0.298074
R21217 VSS.n7118 VSS.n6747 0.298074
R21218 VSS.n7219 VSS.n6697 0.298074
R21219 VSS.n7320 VSS.n6647 0.298074
R21220 VSS.n7421 VSS.n6597 0.298074
R21221 VSS.n8202 VSS.n8201 0.298074
R21222 VSS.n8096 VSS.n8095 0.298074
R21223 VSS.n7990 VSS.n7989 0.298074
R21224 VSS.n7884 VSS.n7883 0.298074
R21225 VSS.n7778 VSS.n7777 0.298074
R21226 VSS.n9240 VSS.n9239 0.298074
R21227 VSS.n9134 VSS.n9133 0.298074
R21228 VSS.n9028 VSS.n9027 0.298074
R21229 VSS.n8922 VSS.n8921 0.298074
R21230 VSS.n8816 VSS.n8815 0.298074
R21231 VSS.n9495 VSS.n2163 0.298074
R21232 VSS.n9596 VSS.n2113 0.298074
R21233 VSS.n9697 VSS.n2063 0.298074
R21234 VSS.n9798 VSS.n2013 0.298074
R21235 VSS.n9899 VSS.n1963 0.298074
R21236 VSS.n10537 VSS.n10317 0.298074
R21237 VSS.n10638 VSS.n10267 0.298074
R21238 VSS.n10739 VSS.n10217 0.298074
R21239 VSS.n10840 VSS.n10167 0.298074
R21240 VSS.n10941 VSS.n10117 0.298074
R21241 VSS.n11722 VSS.n11721 0.298074
R21242 VSS.n11616 VSS.n11615 0.298074
R21243 VSS.n11510 VSS.n11509 0.298074
R21244 VSS.n11404 VSS.n11403 0.298074
R21245 VSS.n11298 VSS.n11297 0.298074
R21246 VSS.n12760 VSS.n12759 0.298074
R21247 VSS.n12654 VSS.n12653 0.298074
R21248 VSS.n12548 VSS.n12547 0.298074
R21249 VSS.n12442 VSS.n12441 0.298074
R21250 VSS.n12336 VSS.n12335 0.298074
R21251 VSS.n13015 VSS.n1522 0.298074
R21252 VSS.n13116 VSS.n1472 0.298074
R21253 VSS.n13217 VSS.n1422 0.298074
R21254 VSS.n13318 VSS.n1372 0.298074
R21255 VSS.n13419 VSS.n1322 0.298074
R21256 VSS.n14024 VSS.n13804 0.298074
R21257 VSS.n14125 VSS.n13754 0.298074
R21258 VSS.n14384 VSS.n13637 0.298074
R21259 VSS.n15029 VSS.n15003 0.29768
R21260 VSS.n3781 VSS.n3780 0.297291
R21261 VSS.n3884 VSS.n3693 0.297291
R21262 VSS.n3985 VSS.n3643 0.297291
R21263 VSS.n4086 VSS.n3593 0.297291
R21264 VSS.n4187 VSS.n3543 0.297291
R21265 VSS.n4288 VSS.n3493 0.297291
R21266 VSS.n5721 VSS.n5720 0.297291
R21267 VSS.n5615 VSS.n5614 0.297291
R21268 VSS.n5509 VSS.n5508 0.297291
R21269 VSS.n5403 VSS.n5402 0.297291
R21270 VSS.n5297 VSS.n5296 0.297291
R21271 VSS.n5965 VSS.n4716 0.297291
R21272 VSS.n6066 VSS.n4666 0.297291
R21273 VSS.n6167 VSS.n4616 0.297291
R21274 VSS.n6268 VSS.n4566 0.297291
R21275 VSS.n6369 VSS.n4516 0.297291
R21276 VSS.n7007 VSS.n6797 0.297291
R21277 VSS.n7108 VSS.n6747 0.297291
R21278 VSS.n7209 VSS.n6697 0.297291
R21279 VSS.n7310 VSS.n6647 0.297291
R21280 VSS.n7411 VSS.n6597 0.297291
R21281 VSS.n8203 VSS.n8202 0.297291
R21282 VSS.n8097 VSS.n8096 0.297291
R21283 VSS.n7991 VSS.n7990 0.297291
R21284 VSS.n7885 VSS.n7884 0.297291
R21285 VSS.n7779 VSS.n7778 0.297291
R21286 VSS.n9241 VSS.n9240 0.297291
R21287 VSS.n9135 VSS.n9134 0.297291
R21288 VSS.n9029 VSS.n9028 0.297291
R21289 VSS.n8923 VSS.n8922 0.297291
R21290 VSS.n8817 VSS.n8816 0.297291
R21291 VSS.n2251 VSS.n2250 0.297291
R21292 VSS.n9485 VSS.n2163 0.297291
R21293 VSS.n9586 VSS.n2113 0.297291
R21294 VSS.n9687 VSS.n2063 0.297291
R21295 VSS.n9788 VSS.n2013 0.297291
R21296 VSS.n9889 VSS.n1963 0.297291
R21297 VSS.n10527 VSS.n10317 0.297291
R21298 VSS.n10628 VSS.n10267 0.297291
R21299 VSS.n10729 VSS.n10217 0.297291
R21300 VSS.n10830 VSS.n10167 0.297291
R21301 VSS.n10931 VSS.n10117 0.297291
R21302 VSS.n11723 VSS.n11722 0.297291
R21303 VSS.n11617 VSS.n11616 0.297291
R21304 VSS.n11511 VSS.n11510 0.297291
R21305 VSS.n11405 VSS.n11404 0.297291
R21306 VSS.n11299 VSS.n11298 0.297291
R21307 VSS.n12761 VSS.n12760 0.297291
R21308 VSS.n12655 VSS.n12654 0.297291
R21309 VSS.n12549 VSS.n12548 0.297291
R21310 VSS.n12443 VSS.n12442 0.297291
R21311 VSS.n12337 VSS.n12336 0.297291
R21312 VSS.n13005 VSS.n1522 0.297291
R21313 VSS.n13106 VSS.n1472 0.297291
R21314 VSS.n13207 VSS.n1422 0.297291
R21315 VSS.n13308 VSS.n1372 0.297291
R21316 VSS.n13409 VSS.n1322 0.297291
R21317 VSS.n14014 VSS.n13804 0.297291
R21318 VSS.n14115 VSS.n13754 0.297291
R21319 VSS.n14374 VSS.n13637 0.297291
R21320 VSS.n3769 VSS.n3768 0.287496
R21321 VSS.n3777 VSS.n3748 0.287496
R21322 VSS.n4427 VSS.n4401 0.287496
R21323 VSS.n4421 VSS.n4418 0.287496
R21324 VSS.n4456 VSS.n83 1.44407
R21325 VSS.n4392 VSS.n4391 0.287496
R21326 VSS.n4383 VSS.n4378 0.287496
R21327 VSS.n4355 VSS.n4354 0.287496
R21328 VSS.n3456 VSS.n3454 0.287496
R21329 VSS.n4302 VSS.n4301 0.287496
R21330 VSS.n3488 VSS.n3486 0.287496
R21331 VSS.n4277 VSS.n3497 0.287496
R21332 VSS.n4285 VSS.n4284 0.287496
R21333 VSS.n4254 VSS.n4253 0.287496
R21334 VSS.n3506 VSS.n3504 0.287496
R21335 VSS.n4201 VSS.n4200 0.287496
R21336 VSS.n3538 VSS.n3536 0.287496
R21337 VSS.n4176 VSS.n3547 0.287496
R21338 VSS.n4184 VSS.n4183 0.287496
R21339 VSS.n4153 VSS.n4152 0.287496
R21340 VSS.n3556 VSS.n3554 0.287496
R21341 VSS.n4100 VSS.n4099 0.287496
R21342 VSS.n3588 VSS.n3586 0.287496
R21343 VSS.n4075 VSS.n3597 0.287496
R21344 VSS.n4083 VSS.n4082 0.287496
R21345 VSS.n4052 VSS.n4051 0.287496
R21346 VSS.n3606 VSS.n3604 0.287496
R21347 VSS.n3999 VSS.n3998 0.287496
R21348 VSS.n3638 VSS.n3636 0.287496
R21349 VSS.n3974 VSS.n3647 0.287496
R21350 VSS.n3982 VSS.n3981 0.287496
R21351 VSS.n3951 VSS.n3950 0.287496
R21352 VSS.n3656 VSS.n3654 0.287496
R21353 VSS.n3898 VSS.n3897 0.287496
R21354 VSS.n3688 VSS.n3686 0.287496
R21355 VSS.n3873 VSS.n3697 0.287496
R21356 VSS.n3881 VSS.n3880 0.287496
R21357 VSS.n3850 VSS.n3849 0.287496
R21358 VSS.n3706 VSS.n3704 0.287496
R21359 VSS.n5159 VSS.n5133 0.287496
R21360 VSS.n5153 VSS.n5150 0.287496
R21361 VSS.n5188 VSS.n82 1.44407
R21362 VSS.n5203 VSS.n5202 0.287496
R21363 VSS.n5194 VSS.n5103 0.287496
R21364 VSS.n5227 VSS.n5090 0.287496
R21365 VSS.n5218 VSS.n5217 0.287496
R21366 VSS.n5288 VSS.n5287 0.287496
R21367 VSS.n5279 VSS.n5278 0.287496
R21368 VSS.n5309 VSS.n5308 0.287496
R21369 VSS.n5300 VSS.n5061 0.287496
R21370 VSS.n5333 VSS.n5048 0.287496
R21371 VSS.n5324 VSS.n5323 0.287496
R21372 VSS.n5394 VSS.n5393 0.287496
R21373 VSS.n5385 VSS.n5384 0.287496
R21374 VSS.n5415 VSS.n5414 0.287496
R21375 VSS.n5406 VSS.n5019 0.287496
R21376 VSS.n5439 VSS.n5006 0.287496
R21377 VSS.n5430 VSS.n5429 0.287496
R21378 VSS.n5500 VSS.n5499 0.287496
R21379 VSS.n5491 VSS.n5490 0.287496
R21380 VSS.n5521 VSS.n5520 0.287496
R21381 VSS.n5512 VSS.n4977 0.287496
R21382 VSS.n5545 VSS.n4964 0.287496
R21383 VSS.n5536 VSS.n5535 0.287496
R21384 VSS.n5606 VSS.n5605 0.287496
R21385 VSS.n5597 VSS.n5596 0.287496
R21386 VSS.n5627 VSS.n5626 0.287496
R21387 VSS.n5618 VSS.n4935 0.287496
R21388 VSS.n5651 VSS.n4922 0.287496
R21389 VSS.n5642 VSS.n5641 0.287496
R21390 VSS.n5712 VSS.n5711 0.287496
R21391 VSS.n5703 VSS.n5702 0.287496
R21392 VSS.n5733 VSS.n5732 0.287496
R21393 VSS.n5724 VSS.n4893 0.287496
R21394 VSS.n5757 VSS.n4880 0.287496
R21395 VSS.n5748 VSS.n5747 0.287496
R21396 VSS.n6508 VSS.n6482 0.287496
R21397 VSS.n6502 VSS.n6499 0.287496
R21398 VSS.n6537 VSS.n81 1.44407
R21399 VSS.n6473 VSS.n6472 0.287496
R21400 VSS.n6464 VSS.n6459 0.287496
R21401 VSS.n6436 VSS.n6435 0.287496
R21402 VSS.n4479 VSS.n4477 0.287496
R21403 VSS.n6383 VSS.n6382 0.287496
R21404 VSS.n4511 VSS.n4509 0.287496
R21405 VSS.n6358 VSS.n4520 0.287496
R21406 VSS.n6366 VSS.n6365 0.287496
R21407 VSS.n6335 VSS.n6334 0.287496
R21408 VSS.n4529 VSS.n4527 0.287496
R21409 VSS.n6282 VSS.n6281 0.287496
R21410 VSS.n4561 VSS.n4559 0.287496
R21411 VSS.n6257 VSS.n4570 0.287496
R21412 VSS.n6265 VSS.n6264 0.287496
R21413 VSS.n6234 VSS.n6233 0.287496
R21414 VSS.n4579 VSS.n4577 0.287496
R21415 VSS.n6181 VSS.n6180 0.287496
R21416 VSS.n4611 VSS.n4609 0.287496
R21417 VSS.n6156 VSS.n4620 0.287496
R21418 VSS.n6164 VSS.n6163 0.287496
R21419 VSS.n6133 VSS.n6132 0.287496
R21420 VSS.n4629 VSS.n4627 0.287496
R21421 VSS.n6080 VSS.n6079 0.287496
R21422 VSS.n4661 VSS.n4659 0.287496
R21423 VSS.n6055 VSS.n4670 0.287496
R21424 VSS.n6063 VSS.n6062 0.287496
R21425 VSS.n6032 VSS.n6031 0.287496
R21426 VSS.n4679 VSS.n4677 0.287496
R21427 VSS.n5979 VSS.n5978 0.287496
R21428 VSS.n4711 VSS.n4709 0.287496
R21429 VSS.n5954 VSS.n4720 0.287496
R21430 VSS.n5962 VSS.n5961 0.287496
R21431 VSS.n5931 VSS.n5930 0.287496
R21432 VSS.n4729 VSS.n4727 0.287496
R21433 VSS.n7550 VSS.n7524 0.287496
R21434 VSS.n7544 VSS.n7541 0.287496
R21435 VSS.n7579 VSS.n80 1.44407
R21436 VSS.n7515 VSS.n7514 0.287496
R21437 VSS.n7506 VSS.n7501 0.287496
R21438 VSS.n7478 VSS.n7477 0.287496
R21439 VSS.n6560 VSS.n6558 0.287496
R21440 VSS.n7425 VSS.n7424 0.287496
R21441 VSS.n6592 VSS.n6590 0.287496
R21442 VSS.n7400 VSS.n6601 0.287496
R21443 VSS.n7408 VSS.n7407 0.287496
R21444 VSS.n7377 VSS.n7376 0.287496
R21445 VSS.n6610 VSS.n6608 0.287496
R21446 VSS.n7324 VSS.n7323 0.287496
R21447 VSS.n6642 VSS.n6640 0.287496
R21448 VSS.n7299 VSS.n6651 0.287496
R21449 VSS.n7307 VSS.n7306 0.287496
R21450 VSS.n7276 VSS.n7275 0.287496
R21451 VSS.n6660 VSS.n6658 0.287496
R21452 VSS.n7223 VSS.n7222 0.287496
R21453 VSS.n6692 VSS.n6690 0.287496
R21454 VSS.n7198 VSS.n6701 0.287496
R21455 VSS.n7206 VSS.n7205 0.287496
R21456 VSS.n7175 VSS.n7174 0.287496
R21457 VSS.n6710 VSS.n6708 0.287496
R21458 VSS.n7122 VSS.n7121 0.287496
R21459 VSS.n6742 VSS.n6740 0.287496
R21460 VSS.n7097 VSS.n6751 0.287496
R21461 VSS.n7105 VSS.n7104 0.287496
R21462 VSS.n7074 VSS.n7073 0.287496
R21463 VSS.n6760 VSS.n6758 0.287496
R21464 VSS.n7021 VSS.n7020 0.287496
R21465 VSS.n6792 VSS.n6790 0.287496
R21466 VSS.n6996 VSS.n6801 0.287496
R21467 VSS.n7004 VSS.n7003 0.287496
R21468 VSS.n6973 VSS.n6972 0.287496
R21469 VSS.n6810 VSS.n6808 0.287496
R21470 VSS.n7636 VSS.n7610 0.287496
R21471 VSS.n7630 VSS.n7627 0.287496
R21472 VSS.n7665 VSS.n79 1.44407
R21473 VSS.n7685 VSS.n7684 0.287496
R21474 VSS.n7676 VSS.n2531 0.287496
R21475 VSS.n7709 VSS.n2518 0.287496
R21476 VSS.n7700 VSS.n7699 0.287496
R21477 VSS.n7770 VSS.n7769 0.287496
R21478 VSS.n7761 VSS.n7760 0.287496
R21479 VSS.n7791 VSS.n7790 0.287496
R21480 VSS.n7782 VSS.n2489 0.287496
R21481 VSS.n7815 VSS.n2476 0.287496
R21482 VSS.n7806 VSS.n7805 0.287496
R21483 VSS.n7876 VSS.n7875 0.287496
R21484 VSS.n7867 VSS.n7866 0.287496
R21485 VSS.n7897 VSS.n7896 0.287496
R21486 VSS.n7888 VSS.n2447 0.287496
R21487 VSS.n7921 VSS.n2434 0.287496
R21488 VSS.n7912 VSS.n7911 0.287496
R21489 VSS.n7982 VSS.n7981 0.287496
R21490 VSS.n7973 VSS.n7972 0.287496
R21491 VSS.n8003 VSS.n8002 0.287496
R21492 VSS.n7994 VSS.n2405 0.287496
R21493 VSS.n8027 VSS.n2392 0.287496
R21494 VSS.n8018 VSS.n8017 0.287496
R21495 VSS.n8088 VSS.n8087 0.287496
R21496 VSS.n8079 VSS.n8078 0.287496
R21497 VSS.n8109 VSS.n8108 0.287496
R21498 VSS.n8100 VSS.n2363 0.287496
R21499 VSS.n8133 VSS.n2350 0.287496
R21500 VSS.n8124 VSS.n8123 0.287496
R21501 VSS.n8194 VSS.n8193 0.287496
R21502 VSS.n8185 VSS.n8184 0.287496
R21503 VSS.n8215 VSS.n8214 0.287496
R21504 VSS.n8206 VSS.n2321 0.287496
R21505 VSS.n8239 VSS.n2308 0.287496
R21506 VSS.n8230 VSS.n8229 0.287496
R21507 VSS.n8679 VSS.n8653 0.287496
R21508 VSS.n8673 VSS.n8670 0.287496
R21509 VSS.n8708 VSS.n78 1.44407
R21510 VSS.n8723 VSS.n8722 0.287496
R21511 VSS.n8714 VSS.n8623 0.287496
R21512 VSS.n8747 VSS.n8610 0.287496
R21513 VSS.n8738 VSS.n8737 0.287496
R21514 VSS.n8808 VSS.n8807 0.287496
R21515 VSS.n8799 VSS.n8798 0.287496
R21516 VSS.n8829 VSS.n8828 0.287496
R21517 VSS.n8820 VSS.n8581 0.287496
R21518 VSS.n8853 VSS.n8568 0.287496
R21519 VSS.n8844 VSS.n8843 0.287496
R21520 VSS.n8914 VSS.n8913 0.287496
R21521 VSS.n8905 VSS.n8904 0.287496
R21522 VSS.n8935 VSS.n8934 0.287496
R21523 VSS.n8926 VSS.n8539 0.287496
R21524 VSS.n8959 VSS.n8526 0.287496
R21525 VSS.n8950 VSS.n8949 0.287496
R21526 VSS.n9020 VSS.n9019 0.287496
R21527 VSS.n9011 VSS.n9010 0.287496
R21528 VSS.n9041 VSS.n9040 0.287496
R21529 VSS.n9032 VSS.n8497 0.287496
R21530 VSS.n9065 VSS.n8484 0.287496
R21531 VSS.n9056 VSS.n9055 0.287496
R21532 VSS.n9126 VSS.n9125 0.287496
R21533 VSS.n9117 VSS.n9116 0.287496
R21534 VSS.n9147 VSS.n9146 0.287496
R21535 VSS.n9138 VSS.n8455 0.287496
R21536 VSS.n9171 VSS.n8442 0.287496
R21537 VSS.n9162 VSS.n9161 0.287496
R21538 VSS.n9232 VSS.n9231 0.287496
R21539 VSS.n9223 VSS.n9222 0.287496
R21540 VSS.n9253 VSS.n9252 0.287496
R21541 VSS.n9244 VSS.n8413 0.287496
R21542 VSS.n9277 VSS.n8400 0.287496
R21543 VSS.n9268 VSS.n9267 0.287496
R21544 VSS.n2239 VSS.n2238 0.287496
R21545 VSS.n2247 VSS.n2218 0.287496
R21546 VSS.n10028 VSS.n10002 0.287496
R21547 VSS.n10022 VSS.n10019 0.287496
R21548 VSS.n10057 VSS.n77 1.44407
R21549 VSS.n9993 VSS.n9992 0.287496
R21550 VSS.n9984 VSS.n9979 0.287496
R21551 VSS.n9956 VSS.n9955 0.287496
R21552 VSS.n1926 VSS.n1924 0.287496
R21553 VSS.n9903 VSS.n9902 0.287496
R21554 VSS.n1958 VSS.n1956 0.287496
R21555 VSS.n9878 VSS.n1967 0.287496
R21556 VSS.n9886 VSS.n9885 0.287496
R21557 VSS.n9855 VSS.n9854 0.287496
R21558 VSS.n1976 VSS.n1974 0.287496
R21559 VSS.n9802 VSS.n9801 0.287496
R21560 VSS.n2008 VSS.n2006 0.287496
R21561 VSS.n9777 VSS.n2017 0.287496
R21562 VSS.n9785 VSS.n9784 0.287496
R21563 VSS.n9754 VSS.n9753 0.287496
R21564 VSS.n2026 VSS.n2024 0.287496
R21565 VSS.n9701 VSS.n9700 0.287496
R21566 VSS.n2058 VSS.n2056 0.287496
R21567 VSS.n9676 VSS.n2067 0.287496
R21568 VSS.n9684 VSS.n9683 0.287496
R21569 VSS.n9653 VSS.n9652 0.287496
R21570 VSS.n2076 VSS.n2074 0.287496
R21571 VSS.n9600 VSS.n9599 0.287496
R21572 VSS.n2108 VSS.n2106 0.287496
R21573 VSS.n9575 VSS.n2117 0.287496
R21574 VSS.n9583 VSS.n9582 0.287496
R21575 VSS.n9552 VSS.n9551 0.287496
R21576 VSS.n2126 VSS.n2124 0.287496
R21577 VSS.n9499 VSS.n9498 0.287496
R21578 VSS.n2158 VSS.n2156 0.287496
R21579 VSS.n9474 VSS.n2167 0.287496
R21580 VSS.n9482 VSS.n9481 0.287496
R21581 VSS.n9451 VSS.n9450 0.287496
R21582 VSS.n2176 VSS.n2174 0.287496
R21583 VSS.n11070 VSS.n11044 0.287496
R21584 VSS.n11064 VSS.n11061 0.287496
R21585 VSS.n11099 VSS.n76 1.44407
R21586 VSS.n11035 VSS.n11034 0.287496
R21587 VSS.n11026 VSS.n11021 0.287496
R21588 VSS.n10998 VSS.n10997 0.287496
R21589 VSS.n10080 VSS.n10078 0.287496
R21590 VSS.n10945 VSS.n10944 0.287496
R21591 VSS.n10112 VSS.n10110 0.287496
R21592 VSS.n10920 VSS.n10121 0.287496
R21593 VSS.n10928 VSS.n10927 0.287496
R21594 VSS.n10897 VSS.n10896 0.287496
R21595 VSS.n10130 VSS.n10128 0.287496
R21596 VSS.n10844 VSS.n10843 0.287496
R21597 VSS.n10162 VSS.n10160 0.287496
R21598 VSS.n10819 VSS.n10171 0.287496
R21599 VSS.n10827 VSS.n10826 0.287496
R21600 VSS.n10796 VSS.n10795 0.287496
R21601 VSS.n10180 VSS.n10178 0.287496
R21602 VSS.n10743 VSS.n10742 0.287496
R21603 VSS.n10212 VSS.n10210 0.287496
R21604 VSS.n10718 VSS.n10221 0.287496
R21605 VSS.n10726 VSS.n10725 0.287496
R21606 VSS.n10695 VSS.n10694 0.287496
R21607 VSS.n10230 VSS.n10228 0.287496
R21608 VSS.n10642 VSS.n10641 0.287496
R21609 VSS.n10262 VSS.n10260 0.287496
R21610 VSS.n10617 VSS.n10271 0.287496
R21611 VSS.n10625 VSS.n10624 0.287496
R21612 VSS.n10594 VSS.n10593 0.287496
R21613 VSS.n10280 VSS.n10278 0.287496
R21614 VSS.n10541 VSS.n10540 0.287496
R21615 VSS.n10312 VSS.n10310 0.287496
R21616 VSS.n10516 VSS.n10321 0.287496
R21617 VSS.n10524 VSS.n10523 0.287496
R21618 VSS.n10493 VSS.n10492 0.287496
R21619 VSS.n10330 VSS.n10328 0.287496
R21620 VSS.n11156 VSS.n11130 0.287496
R21621 VSS.n11150 VSS.n11147 0.287496
R21622 VSS.n11185 VSS.n75 1.44407
R21623 VSS.n11205 VSS.n11204 0.287496
R21624 VSS.n11196 VSS.n1909 0.287496
R21625 VSS.n11229 VSS.n1896 0.287496
R21626 VSS.n11220 VSS.n11219 0.287496
R21627 VSS.n11290 VSS.n11289 0.287496
R21628 VSS.n11281 VSS.n11280 0.287496
R21629 VSS.n11311 VSS.n11310 0.287496
R21630 VSS.n11302 VSS.n1867 0.287496
R21631 VSS.n11335 VSS.n1854 0.287496
R21632 VSS.n11326 VSS.n11325 0.287496
R21633 VSS.n11396 VSS.n11395 0.287496
R21634 VSS.n11387 VSS.n11386 0.287496
R21635 VSS.n11417 VSS.n11416 0.287496
R21636 VSS.n11408 VSS.n1825 0.287496
R21637 VSS.n11441 VSS.n1812 0.287496
R21638 VSS.n11432 VSS.n11431 0.287496
R21639 VSS.n11502 VSS.n11501 0.287496
R21640 VSS.n11493 VSS.n11492 0.287496
R21641 VSS.n11523 VSS.n11522 0.287496
R21642 VSS.n11514 VSS.n1783 0.287496
R21643 VSS.n11547 VSS.n1770 0.287496
R21644 VSS.n11538 VSS.n11537 0.287496
R21645 VSS.n11608 VSS.n11607 0.287496
R21646 VSS.n11599 VSS.n11598 0.287496
R21647 VSS.n11629 VSS.n11628 0.287496
R21648 VSS.n11620 VSS.n1741 0.287496
R21649 VSS.n11653 VSS.n1728 0.287496
R21650 VSS.n11644 VSS.n11643 0.287496
R21651 VSS.n11714 VSS.n11713 0.287496
R21652 VSS.n11705 VSS.n11704 0.287496
R21653 VSS.n11735 VSS.n11734 0.287496
R21654 VSS.n11726 VSS.n1699 0.287496
R21655 VSS.n11759 VSS.n1686 0.287496
R21656 VSS.n11750 VSS.n11749 0.287496
R21657 VSS.n12199 VSS.n12173 0.287496
R21658 VSS.n12193 VSS.n12190 0.287496
R21659 VSS.n12228 VSS.n74 1.44407
R21660 VSS.n12243 VSS.n12242 0.287496
R21661 VSS.n12234 VSS.n12143 0.287496
R21662 VSS.n12267 VSS.n12130 0.287496
R21663 VSS.n12258 VSS.n12257 0.287496
R21664 VSS.n12328 VSS.n12327 0.287496
R21665 VSS.n12319 VSS.n12318 0.287496
R21666 VSS.n12349 VSS.n12348 0.287496
R21667 VSS.n12340 VSS.n12101 0.287496
R21668 VSS.n12373 VSS.n12088 0.287496
R21669 VSS.n12364 VSS.n12363 0.287496
R21670 VSS.n12434 VSS.n12433 0.287496
R21671 VSS.n12425 VSS.n12424 0.287496
R21672 VSS.n12455 VSS.n12454 0.287496
R21673 VSS.n12446 VSS.n12059 0.287496
R21674 VSS.n12479 VSS.n12046 0.287496
R21675 VSS.n12470 VSS.n12469 0.287496
R21676 VSS.n12540 VSS.n12539 0.287496
R21677 VSS.n12531 VSS.n12530 0.287496
R21678 VSS.n12561 VSS.n12560 0.287496
R21679 VSS.n12552 VSS.n12017 0.287496
R21680 VSS.n12585 VSS.n12004 0.287496
R21681 VSS.n12576 VSS.n12575 0.287496
R21682 VSS.n12646 VSS.n12645 0.287496
R21683 VSS.n12637 VSS.n12636 0.287496
R21684 VSS.n12667 VSS.n12666 0.287496
R21685 VSS.n12658 VSS.n11975 0.287496
R21686 VSS.n12691 VSS.n11962 0.287496
R21687 VSS.n12682 VSS.n12681 0.287496
R21688 VSS.n12752 VSS.n12751 0.287496
R21689 VSS.n12743 VSS.n12742 0.287496
R21690 VSS.n12773 VSS.n12772 0.287496
R21691 VSS.n12764 VSS.n11933 0.287496
R21692 VSS.n12797 VSS.n11920 0.287496
R21693 VSS.n12788 VSS.n12787 0.287496
R21694 VSS.n13548 VSS.n13522 0.287496
R21695 VSS.n13542 VSS.n13539 0.287496
R21696 VSS.n13577 VSS.n73 1.44407
R21697 VSS.n13513 VSS.n13512 0.287496
R21698 VSS.n13504 VSS.n13499 0.287496
R21699 VSS.n13476 VSS.n13475 0.287496
R21700 VSS.n1285 VSS.n1283 0.287496
R21701 VSS.n13423 VSS.n13422 0.287496
R21702 VSS.n1317 VSS.n1315 0.287496
R21703 VSS.n13398 VSS.n1326 0.287496
R21704 VSS.n13406 VSS.n13405 0.287496
R21705 VSS.n13375 VSS.n13374 0.287496
R21706 VSS.n1335 VSS.n1333 0.287496
R21707 VSS.n13322 VSS.n13321 0.287496
R21708 VSS.n1367 VSS.n1365 0.287496
R21709 VSS.n13297 VSS.n1376 0.287496
R21710 VSS.n13305 VSS.n13304 0.287496
R21711 VSS.n13274 VSS.n13273 0.287496
R21712 VSS.n1385 VSS.n1383 0.287496
R21713 VSS.n13221 VSS.n13220 0.287496
R21714 VSS.n1417 VSS.n1415 0.287496
R21715 VSS.n13196 VSS.n1426 0.287496
R21716 VSS.n13204 VSS.n13203 0.287496
R21717 VSS.n13173 VSS.n13172 0.287496
R21718 VSS.n1435 VSS.n1433 0.287496
R21719 VSS.n13120 VSS.n13119 0.287496
R21720 VSS.n1467 VSS.n1465 0.287496
R21721 VSS.n13095 VSS.n1476 0.287496
R21722 VSS.n13103 VSS.n13102 0.287496
R21723 VSS.n13072 VSS.n13071 0.287496
R21724 VSS.n1485 VSS.n1483 0.287496
R21725 VSS.n13019 VSS.n13018 0.287496
R21726 VSS.n1517 VSS.n1515 0.287496
R21727 VSS.n12994 VSS.n1526 0.287496
R21728 VSS.n13002 VSS.n13001 0.287496
R21729 VSS.n12971 VSS.n12970 0.287496
R21730 VSS.n1535 VSS.n1533 0.287496
R21731 VSS.n14513 VSS.n14487 0.287496
R21732 VSS.n14507 VSS.n14504 0.287496
R21733 VSS.n14542 VSS.n72 1.44407
R21734 VSS.n14478 VSS.n14477 0.287496
R21735 VSS.n14469 VSS.n14464 0.287496
R21736 VSS.n14441 VSS.n14440 0.287496
R21737 VSS.n13600 VSS.n13598 0.287496
R21738 VSS.n14388 VSS.n14387 0.287496
R21739 VSS.n13632 VSS.n13630 0.287496
R21740 VSS.n14363 VSS.n13641 0.287496
R21741 VSS.n14371 VSS.n14370 0.287496
R21742 VSS.n13650 VSS.n13648 0.287496
R21743 VSS.n14269 VSS.n13717 0.287496
R21744 VSS.n14222 VSS.n14221 0.287496
R21745 VSS.n13734 VSS.n13732 0.287496
R21746 VSS.n14200 VSS.n14150 0.287496
R21747 VSS.n14191 VSS.n14190 0.287496
R21748 VSS.n14129 VSS.n14128 0.287496
R21749 VSS.n13749 VSS.n13747 0.287496
R21750 VSS.n14104 VSS.n13758 0.287496
R21751 VSS.n14112 VSS.n14111 0.287496
R21752 VSS.n14081 VSS.n14080 0.287496
R21753 VSS.n13767 VSS.n13765 0.287496
R21754 VSS.n14028 VSS.n14027 0.287496
R21755 VSS.n13799 VSS.n13797 0.287496
R21756 VSS.n14003 VSS.n13808 0.287496
R21757 VSS.n14011 VSS.n14010 0.287496
R21758 VSS.n13980 VSS.n13979 0.287496
R21759 VSS.n13817 VSS.n13815 0.287496
R21760 VSS.n14596 VSS.n14570 0.287496
R21761 VSS.n14590 VSS.n14587 0.287496
R21762 VSS.n14625 VSS.n71 1.44407
R21763 VSS.n14645 VSS.n14644 0.287496
R21764 VSS.n14636 VSS.n457 0.287496
R21765 VSS.n14669 VSS.n444 0.287496
R21766 VSS.n14660 VSS.n14659 0.287496
R21767 VSS.n13714 VSS.t601 0.287496
R21768 VSS.n15296 VSS.t3115 0.263514
R21769 VSS.n15318 VSS.t3118 0.263514
R21770 VSS.n492 VSS.t392 0.263514
R21771 VSS.t386 VSS.n86 4.61524
R21772 VSS.n1259 VSS.t383 0.263514
R21773 VSS.n1244 VSS.t377 0.263514
R21774 VSS.t368 VSS.n1172 0.263514
R21775 VSS.t365 VSS.n1149 0.263514
R21776 VSS.n1078 VSS.t353 0.263514
R21777 VSS.n1103 VSS.t350 0.263514
R21778 VSS.t347 VSS.n1012 0.263514
R21779 VSS.n963 VSS.t338 0.263514
R21780 VSS.n988 VSS.t335 0.263514
R21781 VSS.n881 VSS.t329 0.263514
R21782 VSS.n851 VSS.t323 0.263514
R21783 VSS.n876 VSS.t320 0.263514
R21784 VSS.t314 VSS.n789 0.263514
R21785 VSS.t311 VSS.n762 0.263514
R21786 VSS.t305 VSS.n733 0.263514
R21787 VSS.t302 VSS.n710 0.263514
R21788 VSS.n692 VSS.t299 0.263514
R21789 VSS.n126 VSS.t287 4.61524
R21790 VSS.n15254 VSS.t284 0.263514
R21791 VSS.t2998 VSS.n3448 0.263514
R21792 VSS.t2985 VSS.n4339 0.263514
R21793 VSS.t2982 VSS.n4320 0.263514
R21794 VSS.t2970 VSS.n4238 0.263514
R21795 VSS.t2967 VSS.n4219 0.263514
R21796 VSS.t2955 VSS.n4137 0.263514
R21797 VSS.t2952 VSS.n4118 0.263514
R21798 VSS.t2940 VSS.n4036 0.263514
R21799 VSS.t2937 VSS.n4017 0.263514
R21800 VSS.t2925 VSS.n3935 0.263514
R21801 VSS.t2922 VSS.n3916 0.263514
R21802 VSS.t2910 VSS.n3834 0.263514
R21803 VSS.t2907 VSS.n3815 0.263514
R21804 VSS.t2783 VSS.n5116 0.263514
R21805 VSS.t2770 VSS.n5083 0.263514
R21806 VSS.t2767 VSS.n5075 0.263514
R21807 VSS.t2755 VSS.n5041 0.263514
R21808 VSS.t2752 VSS.n5033 0.263514
R21809 VSS.t2740 VSS.n4999 0.263514
R21810 VSS.t2737 VSS.n4991 0.263514
R21811 VSS.t2725 VSS.n4957 0.263514
R21812 VSS.t2722 VSS.n4949 0.263514
R21813 VSS.t2710 VSS.n4915 0.263514
R21814 VSS.t2707 VSS.n4907 0.263514
R21815 VSS.t2695 VSS.n4873 0.263514
R21816 VSS.t2692 VSS.n4868 0.263514
R21817 VSS.t2568 VSS.n4471 0.263514
R21818 VSS.t2555 VSS.n6420 0.263514
R21819 VSS.t2552 VSS.n6401 0.263514
R21820 VSS.t2540 VSS.n6319 0.263514
R21821 VSS.t2537 VSS.n6300 0.263514
R21822 VSS.t2525 VSS.n6218 0.263514
R21823 VSS.t2522 VSS.n6199 0.263514
R21824 VSS.t2510 VSS.n6117 0.263514
R21825 VSS.t2507 VSS.n6098 0.263514
R21826 VSS.t2495 VSS.n6016 0.263514
R21827 VSS.t2492 VSS.n5997 0.263514
R21828 VSS.t2480 VSS.n5915 0.263514
R21829 VSS.t2477 VSS.n5896 0.263514
R21830 VSS.t2353 VSS.n6552 0.263514
R21831 VSS.t2340 VSS.n7462 0.263514
R21832 VSS.t2337 VSS.n7443 0.263514
R21833 VSS.t2325 VSS.n7361 0.263514
R21834 VSS.t2322 VSS.n7342 0.263514
R21835 VSS.t2310 VSS.n7260 0.263514
R21836 VSS.t2307 VSS.n7241 0.263514
R21837 VSS.t2295 VSS.n7159 0.263514
R21838 VSS.t2292 VSS.n7140 0.263514
R21839 VSS.t2280 VSS.n7058 0.263514
R21840 VSS.t2277 VSS.n7039 0.263514
R21841 VSS.t2265 VSS.n6957 0.263514
R21842 VSS.t2262 VSS.n6938 0.263514
R21843 VSS.t2138 VSS.n7593 0.263514
R21844 VSS.t2125 VSS.n2511 0.263514
R21845 VSS.t2122 VSS.n2503 0.263514
R21846 VSS.t2110 VSS.n2469 0.263514
R21847 VSS.t2107 VSS.n2461 0.263514
R21848 VSS.t2095 VSS.n2427 0.263514
R21849 VSS.t2092 VSS.n2419 0.263514
R21850 VSS.t2080 VSS.n2385 0.263514
R21851 VSS.t2077 VSS.n2377 0.263514
R21852 VSS.t2065 VSS.n2343 0.263514
R21853 VSS.t2062 VSS.n2335 0.263514
R21854 VSS.t2050 VSS.n2301 0.263514
R21855 VSS.t2047 VSS.n2296 0.263514
R21856 VSS.t1923 VSS.n8636 0.263514
R21857 VSS.t1910 VSS.n8603 0.263514
R21858 VSS.t1907 VSS.n8595 0.263514
R21859 VSS.t1895 VSS.n8561 0.263514
R21860 VSS.t1892 VSS.n8553 0.263514
R21861 VSS.t1880 VSS.n8519 0.263514
R21862 VSS.t1877 VSS.n8511 0.263514
R21863 VSS.t1865 VSS.n8477 0.263514
R21864 VSS.t1862 VSS.n8469 0.263514
R21865 VSS.t1850 VSS.n8435 0.263514
R21866 VSS.t1847 VSS.n8427 0.263514
R21867 VSS.t1835 VSS.n8393 0.263514
R21868 VSS.t1832 VSS.n8388 0.263514
R21869 VSS.t1705 VSS.n1918 0.263514
R21870 VSS.t1692 VSS.n9940 0.263514
R21871 VSS.t1689 VSS.n9921 0.263514
R21872 VSS.t1677 VSS.n9839 0.263514
R21873 VSS.t1674 VSS.n9820 0.263514
R21874 VSS.t1662 VSS.n9738 0.263514
R21875 VSS.t1659 VSS.n9719 0.263514
R21876 VSS.t1647 VSS.n9637 0.263514
R21877 VSS.t1644 VSS.n9618 0.263514
R21878 VSS.t1632 VSS.n9536 0.263514
R21879 VSS.t1629 VSS.n9517 0.263514
R21880 VSS.t1617 VSS.n9435 0.263514
R21881 VSS.t1614 VSS.n9416 0.263514
R21882 VSS.t1490 VSS.n10072 0.263514
R21883 VSS.t1477 VSS.n10982 0.263514
R21884 VSS.t1474 VSS.n10963 0.263514
R21885 VSS.t1462 VSS.n10881 0.263514
R21886 VSS.t1459 VSS.n10862 0.263514
R21887 VSS.t1447 VSS.n10780 0.263514
R21888 VSS.t1444 VSS.n10761 0.263514
R21889 VSS.t1432 VSS.n10679 0.263514
R21890 VSS.t1429 VSS.n10660 0.263514
R21891 VSS.t1417 VSS.n10578 0.263514
R21892 VSS.t1414 VSS.n10559 0.263514
R21893 VSS.t1402 VSS.n10477 0.263514
R21894 VSS.t1399 VSS.n10458 0.263514
R21895 VSS.t1275 VSS.n11113 0.263514
R21896 VSS.t1262 VSS.n1889 0.263514
R21897 VSS.t1259 VSS.n1881 0.263514
R21898 VSS.t1247 VSS.n1847 0.263514
R21899 VSS.t1244 VSS.n1839 0.263514
R21900 VSS.t1232 VSS.n1805 0.263514
R21901 VSS.t1229 VSS.n1797 0.263514
R21902 VSS.t1217 VSS.n1763 0.263514
R21903 VSS.t1214 VSS.n1755 0.263514
R21904 VSS.t1202 VSS.n1721 0.263514
R21905 VSS.t1199 VSS.n1713 0.263514
R21906 VSS.t1187 VSS.n1679 0.263514
R21907 VSS.t1184 VSS.n1674 0.263514
R21908 VSS.t1060 VSS.n12156 0.263514
R21909 VSS.t1047 VSS.n12123 0.263514
R21910 VSS.t1044 VSS.n12115 0.263514
R21911 VSS.t1032 VSS.n12081 0.263514
R21912 VSS.t1029 VSS.n12073 0.263514
R21913 VSS.t1017 VSS.n12039 0.263514
R21914 VSS.t1014 VSS.n12031 0.263514
R21915 VSS.t1002 VSS.n11997 0.263514
R21916 VSS.t999 VSS.n11989 0.263514
R21917 VSS.t987 VSS.n11955 0.263514
R21918 VSS.t984 VSS.n11947 0.263514
R21919 VSS.t972 VSS.n11913 0.263514
R21920 VSS.t969 VSS.n11908 0.263514
R21921 VSS.t845 VSS.n1277 0.263514
R21922 VSS.t832 VSS.n13460 0.263514
R21923 VSS.t829 VSS.n13441 0.263514
R21924 VSS.t817 VSS.n13359 0.263514
R21925 VSS.t814 VSS.n13340 0.263514
R21926 VSS.t802 VSS.n13258 0.263514
R21927 VSS.t799 VSS.n13239 0.263514
R21928 VSS.t787 VSS.n13157 0.263514
R21929 VSS.t784 VSS.n13138 0.263514
R21930 VSS.t772 VSS.n13056 0.263514
R21931 VSS.t769 VSS.n13037 0.263514
R21932 VSS.t757 VSS.n12955 0.263514
R21933 VSS.t754 VSS.n12936 0.263514
R21934 VSS.t635 VSS.n13592 0.263514
R21935 VSS.t622 VSS.n14425 0.263514
R21936 VSS.t619 VSS.n14406 0.263514
R21937 VSS.t710 VSS.n14340 0.263514
R21938 VSS.n14321 VSS.t3339 0.263514
R21939 VSS.t698 VSS.n14295 0.263514
R21940 VSS.n14249 VSS.t693 0.263514
R21941 VSS.t589 VSS.n14147 0.263514
R21942 VSS.t577 VSS.n14065 0.263514
R21943 VSS.t574 VSS.n14046 0.263514
R21944 VSS.t562 VSS.n13964 0.263514
R21945 VSS.t559 VSS.n13945 0.263514
R21946 VSS.n15140 VSS.t477 0.263514
R21947 VSS.t465 VSS.n14556 0.263514
R21948 VSS.t452 VSS.n437 0.263514
R21949 VSS.t449 VSS.n430 0.263514
R21950 VSS.t446 VSS.n412 0.263514
R21951 VSS.n14747 VSS.t443 0.263514
R21952 VSS.t3385 VSS.n14907 0.263514
R21953 VSS.n14907 VSS.t501 0.263514
R21954 VSS.n14946 VSS.t418 0.263514
R21955 VSS.n15060 VSS.t491 0.263514
R21956 VSS.t278 VSS.n258 0.263514
R21957 VSS.t3121 VSS.n15344 0.263514
R21958 VSS.n125 VSS.t3124 4.61524
R21959 VSS.t3237 VSS.n2541 0.263514
R21960 VSS.t3231 VSS.n87 4.61524
R21961 VSS.n3430 VSS.t3228 0.263514
R21962 VSS.n2652 VSS.t3222 0.263514
R21963 VSS.t3219 VSS.n2608 0.263514
R21964 VSS.t3213 VSS.n3398 0.263514
R21965 VSS.t3210 VSS.n3375 0.263514
R21966 VSS.t3204 VSS.n3346 0.263514
R21967 VSS.t3201 VSS.n3323 0.263514
R21968 VSS.t3195 VSS.n3294 0.263514
R21969 VSS.t3192 VSS.n3271 0.263514
R21970 VSS.t3186 VSS.n3242 0.263514
R21971 VSS.t3183 VSS.n3219 0.263514
R21972 VSS.t3177 VSS.n3190 0.263514
R21973 VSS.t3174 VSS.n3167 0.263514
R21974 VSS.t3168 VSS.n3138 0.263514
R21975 VSS.t3165 VSS.n3115 0.263514
R21976 VSS.t3159 VSS.n3086 0.263514
R21977 VSS.t3156 VSS.n3063 0.263514
R21978 VSS.t3150 VSS.n3034 0.263514
R21979 VSS.t3147 VSS.n3011 0.263514
R21980 VSS.t3141 VSS.n2982 0.263514
R21981 VSS.t3138 VSS.n2959 0.263514
R21982 VSS.t3132 VSS.n2930 0.263514
R21983 VSS.t3129 VSS.n2907 0.263514
R21984 VSS.n3869 VSS.n3868 0.240317
R21985 VSS.n3869 VSS.n3699 0.240317
R21986 VSS.n3970 VSS.n3969 0.240317
R21987 VSS.n3970 VSS.n3649 0.240317
R21988 VSS.n4071 VSS.n4070 0.240317
R21989 VSS.n4071 VSS.n3599 0.240317
R21990 VSS.n4172 VSS.n4171 0.240317
R21991 VSS.n4172 VSS.n3549 0.240317
R21992 VSS.n4273 VSS.n4272 0.240317
R21993 VSS.n4273 VSS.n3499 0.240317
R21994 VSS.n4372 VSS.n3451 0.240317
R21995 VSS.n4394 VSS.n3451 0.240317
R21996 VSS.n4889 VSS.n4886 0.240317
R21997 VSS.n5735 VSS.n4889 0.240317
R21998 VSS.n4931 VSS.n4928 0.240317
R21999 VSS.n5629 VSS.n4931 0.240317
R22000 VSS.n4973 VSS.n4970 0.240317
R22001 VSS.n5523 VSS.n4973 0.240317
R22002 VSS.n5015 VSS.n5012 0.240317
R22003 VSS.n5417 VSS.n5015 0.240317
R22004 VSS.n5057 VSS.n5054 0.240317
R22005 VSS.n5311 VSS.n5057 0.240317
R22006 VSS.n5099 VSS.n5096 0.240317
R22007 VSS.n5205 VSS.n5099 0.240317
R22008 VSS.n5950 VSS.n5949 0.240317
R22009 VSS.n5950 VSS.n4722 0.240317
R22010 VSS.n6051 VSS.n6050 0.240317
R22011 VSS.n6051 VSS.n4672 0.240317
R22012 VSS.n6152 VSS.n6151 0.240317
R22013 VSS.n6152 VSS.n4622 0.240317
R22014 VSS.n6253 VSS.n6252 0.240317
R22015 VSS.n6253 VSS.n4572 0.240317
R22016 VSS.n6354 VSS.n6353 0.240317
R22017 VSS.n6354 VSS.n4522 0.240317
R22018 VSS.n6453 VSS.n4474 0.240317
R22019 VSS.n6475 VSS.n4474 0.240317
R22020 VSS.n6992 VSS.n6991 0.240317
R22021 VSS.n6992 VSS.n6803 0.240317
R22022 VSS.n7093 VSS.n7092 0.240317
R22023 VSS.n7093 VSS.n6753 0.240317
R22024 VSS.n7194 VSS.n7193 0.240317
R22025 VSS.n7194 VSS.n6703 0.240317
R22026 VSS.n7295 VSS.n7294 0.240317
R22027 VSS.n7295 VSS.n6653 0.240317
R22028 VSS.n7396 VSS.n7395 0.240317
R22029 VSS.n7396 VSS.n6603 0.240317
R22030 VSS.n7495 VSS.n6555 0.240317
R22031 VSS.n7517 VSS.n6555 0.240317
R22032 VSS.n2317 VSS.n2314 0.240317
R22033 VSS.n8217 VSS.n2317 0.240317
R22034 VSS.n2359 VSS.n2356 0.240317
R22035 VSS.n8111 VSS.n2359 0.240317
R22036 VSS.n2401 VSS.n2398 0.240317
R22037 VSS.n8005 VSS.n2401 0.240317
R22038 VSS.n2443 VSS.n2440 0.240317
R22039 VSS.n7899 VSS.n2443 0.240317
R22040 VSS.n2485 VSS.n2482 0.240317
R22041 VSS.n7793 VSS.n2485 0.240317
R22042 VSS.n2527 VSS.n2524 0.240317
R22043 VSS.n7687 VSS.n2527 0.240317
R22044 VSS.n8409 VSS.n8406 0.240317
R22045 VSS.n9255 VSS.n8409 0.240317
R22046 VSS.n8451 VSS.n8448 0.240317
R22047 VSS.n9149 VSS.n8451 0.240317
R22048 VSS.n8493 VSS.n8490 0.240317
R22049 VSS.n9043 VSS.n8493 0.240317
R22050 VSS.n8535 VSS.n8532 0.240317
R22051 VSS.n8937 VSS.n8535 0.240317
R22052 VSS.n8577 VSS.n8574 0.240317
R22053 VSS.n8831 VSS.n8577 0.240317
R22054 VSS.n8619 VSS.n8616 0.240317
R22055 VSS.n8725 VSS.n8619 0.240317
R22056 VSS.n9470 VSS.n9469 0.240317
R22057 VSS.n9470 VSS.n2169 0.240317
R22058 VSS.n9571 VSS.n9570 0.240317
R22059 VSS.n9571 VSS.n2119 0.240317
R22060 VSS.n9672 VSS.n9671 0.240317
R22061 VSS.n9672 VSS.n2069 0.240317
R22062 VSS.n9773 VSS.n9772 0.240317
R22063 VSS.n9773 VSS.n2019 0.240317
R22064 VSS.n9874 VSS.n9873 0.240317
R22065 VSS.n9874 VSS.n1969 0.240317
R22066 VSS.n9973 VSS.n1921 0.240317
R22067 VSS.n9995 VSS.n1921 0.240317
R22068 VSS.n10512 VSS.n10511 0.240317
R22069 VSS.n10512 VSS.n10323 0.240317
R22070 VSS.n10613 VSS.n10612 0.240317
R22071 VSS.n10613 VSS.n10273 0.240317
R22072 VSS.n10714 VSS.n10713 0.240317
R22073 VSS.n10714 VSS.n10223 0.240317
R22074 VSS.n10815 VSS.n10814 0.240317
R22075 VSS.n10815 VSS.n10173 0.240317
R22076 VSS.n10916 VSS.n10915 0.240317
R22077 VSS.n10916 VSS.n10123 0.240317
R22078 VSS.n11015 VSS.n10075 0.240317
R22079 VSS.n11037 VSS.n10075 0.240317
R22080 VSS.n1695 VSS.n1692 0.240317
R22081 VSS.n11737 VSS.n1695 0.240317
R22082 VSS.n1737 VSS.n1734 0.240317
R22083 VSS.n11631 VSS.n1737 0.240317
R22084 VSS.n1779 VSS.n1776 0.240317
R22085 VSS.n11525 VSS.n1779 0.240317
R22086 VSS.n1821 VSS.n1818 0.240317
R22087 VSS.n11419 VSS.n1821 0.240317
R22088 VSS.n1863 VSS.n1860 0.240317
R22089 VSS.n11313 VSS.n1863 0.240317
R22090 VSS.n1905 VSS.n1902 0.240317
R22091 VSS.n11207 VSS.n1905 0.240317
R22092 VSS.n11929 VSS.n11926 0.240317
R22093 VSS.n12775 VSS.n11929 0.240317
R22094 VSS.n11971 VSS.n11968 0.240317
R22095 VSS.n12669 VSS.n11971 0.240317
R22096 VSS.n12013 VSS.n12010 0.240317
R22097 VSS.n12563 VSS.n12013 0.240317
R22098 VSS.n12055 VSS.n12052 0.240317
R22099 VSS.n12457 VSS.n12055 0.240317
R22100 VSS.n12097 VSS.n12094 0.240317
R22101 VSS.n12351 VSS.n12097 0.240317
R22102 VSS.n12139 VSS.n12136 0.240317
R22103 VSS.n12245 VSS.n12139 0.240317
R22104 VSS.n12990 VSS.n12989 0.240317
R22105 VSS.n12990 VSS.n1528 0.240317
R22106 VSS.n13091 VSS.n13090 0.240317
R22107 VSS.n13091 VSS.n1478 0.240317
R22108 VSS.n13192 VSS.n13191 0.240317
R22109 VSS.n13192 VSS.n1428 0.240317
R22110 VSS.n13293 VSS.n13292 0.240317
R22111 VSS.n13293 VSS.n1378 0.240317
R22112 VSS.n13394 VSS.n13393 0.240317
R22113 VSS.n13394 VSS.n1328 0.240317
R22114 VSS.n13493 VSS.n1280 0.240317
R22115 VSS.n13515 VSS.n1280 0.240317
R22116 VSS.n13999 VSS.n13998 0.240317
R22117 VSS.n13999 VSS.n13810 0.240317
R22118 VSS.n14100 VSS.n14099 0.240317
R22119 VSS.n14100 VSS.n13760 0.240317
R22120 VSS.n14458 VSS.n13595 0.240317
R22121 VSS.n14480 VSS.n13595 0.240317
R22122 VSS.n15226 VSS.n302 0.240317
R22123 VSS.n15044 VSS.n15043 0.240317
R22124 VSS.n453 VSS.n450 0.240317
R22125 VSS.n14647 VSS.n453 0.240317
R22126 VSS.n290 VSS.n289 0.239726
R22127 VSS.n914 VSS.n578 0.239726
R22128 VSS.n995 VSS.n994 0.239726
R22129 VSS.n1217 VSS.n1211 0.239726
R22130 VSS.n14161 VSS.n13738 0.239726
R22131 VSS.n14344 VSS.n13649 0.239726
R22132 VSS.n14359 VSS.n14358 0.239726
R22133 VSS.n14898 VSS.n14897 0.239726
R22134 VSS.n14793 VSS.n14792 0.239726
R22135 VSS.n289 VSS.n288 0.239381
R22136 VSS.n914 VSS.n913 0.239381
R22137 VSS.n994 VSS.n993 0.239381
R22138 VSS.n1221 VSS.n1211 0.239381
R22139 VSS.n14162 VSS.n14159 0.239381
R22140 VSS.n14311 VSS.n13700 0.239381
R22141 VSS.n13688 VSS.n13671 0.239381
R22142 VSS.n14344 VSS.n14343 0.239381
R22143 VSS.n14358 VSS.n14357 0.239381
R22144 VSS.n14898 VSS.n351 0.239381
R22145 VSS.n14792 VSS.n383 0.239381
R22146 VSS.n5828 VSS.n5820 0.233227
R22147 VSS.n5836 VSS.n5835 0.233227
R22148 VSS.n5851 VSS.n5807 0.233227
R22149 VSS.n5859 VSS.n5858 0.233227
R22150 VSS.n4795 VSS.n4794 0.233227
R22151 VSS.n4783 VSS.n4781 0.233227
R22152 VSS.n4817 VSS.n4816 0.233227
R22153 VSS.n4769 VSS.n4767 0.233227
R22154 VSS.n6876 VSS.n6875 0.233227
R22155 VSS.n6864 VSS.n6862 0.233227
R22156 VSS.n6898 VSS.n6897 0.233227
R22157 VSS.n6850 VSS.n6848 0.233227
R22158 VSS.n8310 VSS.n8302 0.233227
R22159 VSS.n8318 VSS.n8317 0.233227
R22160 VSS.n8333 VSS.n8289 0.233227
R22161 VSS.n8341 VSS.n8340 0.233227
R22162 VSS.n9348 VSS.n9340 0.233227
R22163 VSS.n9356 VSS.n9355 0.233227
R22164 VSS.n9371 VSS.n9327 0.233227
R22165 VSS.n9379 VSS.n9378 0.233227
R22166 VSS.n10396 VSS.n10395 0.233227
R22167 VSS.n10384 VSS.n10382 0.233227
R22168 VSS.n10418 VSS.n10417 0.233227
R22169 VSS.n10370 VSS.n10368 0.233227
R22170 VSS.n11830 VSS.n11822 0.233227
R22171 VSS.n11838 VSS.n11837 0.233227
R22172 VSS.n11853 VSS.n11809 0.233227
R22173 VSS.n11861 VSS.n11860 0.233227
R22174 VSS.n12868 VSS.n12860 0.233227
R22175 VSS.n12876 VSS.n12875 0.233227
R22176 VSS.n12891 VSS.n12847 0.233227
R22177 VSS.n12899 VSS.n12898 0.233227
R22178 VSS.n1601 VSS.n1600 0.233227
R22179 VSS.n1589 VSS.n1587 0.233227
R22180 VSS.n1623 VSS.n1622 0.233227
R22181 VSS.n1575 VSS.n1573 0.233227
R22182 VSS.n13883 VSS.n13882 0.233227
R22183 VSS.n13871 VSS.n13869 0.233227
R22184 VSS.n13905 VSS.n13904 0.233227
R22185 VSS.n13857 VSS.n13855 0.233227
R22186 VSS.n15179 VSS.n15178 0.233227
R22187 VSS.n15167 VSS.n15165 0.233227
R22188 VSS.n15201 VSS.n15200 0.233227
R22189 VSS.n15153 VSS.n15151 0.233227
R22190 VSS.n14971 VSS.n14970 0.233227
R22191 VSS.n14958 VSS.n14957 0.233227
R22192 VSS.n14996 VSS.n320 0.233227
R22193 VSS.n14991 VSS.n14985 0.233227
R22194 VSS.n3779 VSS.t3004 0.225061
R22195 VSS.n3791 VSS.t2898 0.225061
R22196 VSS.n4414 VSS.t2997 0.225061
R22197 VSS.n4413 VSS.t3000 0.225061
R22198 VSS.n4409 VSS.t3107 0.225061
R22199 VSS.n4449 VSS.t3105 0.225061
R22200 VSS.n4445 VSS.t2995 0.225061
R22201 VSS.n4450 VSS.t3103 0.225061
R22202 VSS.t3100 VSS.n4381 0.225061
R22203 VSS.n4366 VSS.t2988 0.225061
R22204 VSS.n4370 VSS.t3097 0.225061
R22205 VSS.n4365 VSS.t2986 0.225061
R22206 VSS.n4336 VSS.t2983 0.225061
R22207 VSS.n4313 VSS.t3090 0.225061
R22208 VSS.n4317 VSS.t2980 0.225061
R22209 VSS.n4312 VSS.t3088 0.225061
R22210 VSS.n4289 VSS.t3085 0.225061
R22211 VSS.n4265 VSS.t2973 0.225061
R22212 VSS.n4270 VSS.t3082 0.225061
R22213 VSS.n4264 VSS.t2971 0.225061
R22214 VSS.n4235 VSS.t2968 0.225061
R22215 VSS.n4212 VSS.t3075 0.225061
R22216 VSS.n4216 VSS.t2965 0.225061
R22217 VSS.n4211 VSS.t3073 0.225061
R22218 VSS.n4188 VSS.t3070 0.225061
R22219 VSS.n4164 VSS.t2958 0.225061
R22220 VSS.n4169 VSS.t3067 0.225061
R22221 VSS.n4163 VSS.t2956 0.225061
R22222 VSS.n4134 VSS.t2953 0.225061
R22223 VSS.n4111 VSS.t3060 0.225061
R22224 VSS.n4115 VSS.t2950 0.225061
R22225 VSS.n4110 VSS.t3058 0.225061
R22226 VSS.n4087 VSS.t3055 0.225061
R22227 VSS.n4063 VSS.t2943 0.225061
R22228 VSS.n4068 VSS.t3052 0.225061
R22229 VSS.n4062 VSS.t2941 0.225061
R22230 VSS.n4033 VSS.t2938 0.225061
R22231 VSS.n4010 VSS.t3045 0.225061
R22232 VSS.n4014 VSS.t2935 0.225061
R22233 VSS.n4009 VSS.t3043 0.225061
R22234 VSS.n3986 VSS.t3040 0.225061
R22235 VSS.n3962 VSS.t2928 0.225061
R22236 VSS.n3967 VSS.t3037 0.225061
R22237 VSS.n3961 VSS.t2926 0.225061
R22238 VSS.n3932 VSS.t2923 0.225061
R22239 VSS.n3909 VSS.t3030 0.225061
R22240 VSS.n3913 VSS.t2920 0.225061
R22241 VSS.n3908 VSS.t3028 0.225061
R22242 VSS.n3885 VSS.t3025 0.225061
R22243 VSS.n3861 VSS.t2913 0.225061
R22244 VSS.n3866 VSS.t3022 0.225061
R22245 VSS.n3860 VSS.t2911 0.225061
R22246 VSS.n3831 VSS.t2908 0.225061
R22247 VSS.n3811 VSS.t3013 0.225061
R22248 VSS.n3802 VSS.t3009 0.225061
R22249 VSS.t2680 VSS.n5812 0.225061
R22250 VSS.n5869 VSS.t2683 0.225061
R22251 VSS.n5146 VSS.t2782 0.225061
R22252 VSS.n5145 VSS.t2785 0.225061
R22253 VSS.n5141 VSS.t2889 0.225061
R22254 VSS.n5181 VSS.t2887 0.225061
R22255 VSS.n5177 VSS.t2780 0.225061
R22256 VSS.n5182 VSS.t2885 0.225061
R22257 VSS.t2882 VSS.n5192 0.225061
R22258 VSS.n5212 VSS.t2773 0.225061
R22259 VSS.n5208 VSS.t2879 0.225061
R22260 VSS.n5213 VSS.t2771 0.225061
R22261 VSS.n5243 VSS.t2768 0.225061
R22262 VSS.n5273 VSS.t2872 0.225061
R22263 VSS.n5269 VSS.t2765 0.225061
R22264 VSS.n5274 VSS.t2870 0.225061
R22265 VSS.t2867 VSS.n5298 0.225061
R22266 VSS.n5318 VSS.t2758 0.225061
R22267 VSS.n5314 VSS.t2864 0.225061
R22268 VSS.n5319 VSS.t2756 0.225061
R22269 VSS.n5349 VSS.t2753 0.225061
R22270 VSS.n5379 VSS.t2857 0.225061
R22271 VSS.n5375 VSS.t2750 0.225061
R22272 VSS.n5380 VSS.t2855 0.225061
R22273 VSS.t2852 VSS.n5404 0.225061
R22274 VSS.n5424 VSS.t2743 0.225061
R22275 VSS.n5420 VSS.t2849 0.225061
R22276 VSS.n5425 VSS.t2741 0.225061
R22277 VSS.n5455 VSS.t2738 0.225061
R22278 VSS.n5485 VSS.t2842 0.225061
R22279 VSS.n5481 VSS.t2735 0.225061
R22280 VSS.n5486 VSS.t2840 0.225061
R22281 VSS.t2837 VSS.n5510 0.225061
R22282 VSS.n5530 VSS.t2728 0.225061
R22283 VSS.n5526 VSS.t2834 0.225061
R22284 VSS.n5531 VSS.t2726 0.225061
R22285 VSS.n5561 VSS.t2723 0.225061
R22286 VSS.n5591 VSS.t2827 0.225061
R22287 VSS.n5587 VSS.t2720 0.225061
R22288 VSS.n5592 VSS.t2825 0.225061
R22289 VSS.t2822 VSS.n5616 0.225061
R22290 VSS.n5636 VSS.t2713 0.225061
R22291 VSS.n5632 VSS.t2819 0.225061
R22292 VSS.n5637 VSS.t2711 0.225061
R22293 VSS.n5667 VSS.t2708 0.225061
R22294 VSS.n5697 VSS.t2812 0.225061
R22295 VSS.n5693 VSS.t2705 0.225061
R22296 VSS.n5698 VSS.t2810 0.225061
R22297 VSS.t2807 VSS.n5722 0.225061
R22298 VSS.n5742 VSS.t2698 0.225061
R22299 VSS.n5738 VSS.t2804 0.225061
R22300 VSS.n5743 VSS.t2696 0.225061
R22301 VSS.n5773 VSS.t2693 0.225061
R22302 VSS.n4864 VSS.t2795 0.225061
R22303 VSS.n5878 VSS.t2791 0.225061
R22304 VSS.n4811 VSS.t2465 0.225061
R22305 VSS.n4833 VSS.t2468 0.225061
R22306 VSS.n6495 VSS.t2567 0.225061
R22307 VSS.n6494 VSS.t2570 0.225061
R22308 VSS.n6490 VSS.t2674 0.225061
R22309 VSS.n6530 VSS.t2672 0.225061
R22310 VSS.n6526 VSS.t2565 0.225061
R22311 VSS.n6531 VSS.t2670 0.225061
R22312 VSS.t2667 VSS.n6462 0.225061
R22313 VSS.n6447 VSS.t2558 0.225061
R22314 VSS.n6451 VSS.t2664 0.225061
R22315 VSS.n6446 VSS.t2556 0.225061
R22316 VSS.n6417 VSS.t2553 0.225061
R22317 VSS.n6394 VSS.t2657 0.225061
R22318 VSS.n6398 VSS.t2550 0.225061
R22319 VSS.n6393 VSS.t2655 0.225061
R22320 VSS.n6370 VSS.t2652 0.225061
R22321 VSS.n6346 VSS.t2543 0.225061
R22322 VSS.n6351 VSS.t2649 0.225061
R22323 VSS.n6345 VSS.t2541 0.225061
R22324 VSS.n6316 VSS.t2538 0.225061
R22325 VSS.n6293 VSS.t2642 0.225061
R22326 VSS.n6297 VSS.t2535 0.225061
R22327 VSS.n6292 VSS.t2640 0.225061
R22328 VSS.n6269 VSS.t2637 0.225061
R22329 VSS.n6245 VSS.t2528 0.225061
R22330 VSS.n6250 VSS.t2634 0.225061
R22331 VSS.n6244 VSS.t2526 0.225061
R22332 VSS.n6215 VSS.t2523 0.225061
R22333 VSS.n6192 VSS.t2627 0.225061
R22334 VSS.n6196 VSS.t2520 0.225061
R22335 VSS.n6191 VSS.t2625 0.225061
R22336 VSS.n6168 VSS.t2622 0.225061
R22337 VSS.n6144 VSS.t2513 0.225061
R22338 VSS.n6149 VSS.t2619 0.225061
R22339 VSS.n6143 VSS.t2511 0.225061
R22340 VSS.n6114 VSS.t2508 0.225061
R22341 VSS.n6091 VSS.t2612 0.225061
R22342 VSS.n6095 VSS.t2505 0.225061
R22343 VSS.n6090 VSS.t2610 0.225061
R22344 VSS.n6067 VSS.t2607 0.225061
R22345 VSS.n6043 VSS.t2498 0.225061
R22346 VSS.n6048 VSS.t2604 0.225061
R22347 VSS.n6042 VSS.t2496 0.225061
R22348 VSS.n6013 VSS.t2493 0.225061
R22349 VSS.n5990 VSS.t2597 0.225061
R22350 VSS.n5994 VSS.t2490 0.225061
R22351 VSS.n5989 VSS.t2595 0.225061
R22352 VSS.n5966 VSS.t2592 0.225061
R22353 VSS.n5942 VSS.t2483 0.225061
R22354 VSS.n5947 VSS.t2589 0.225061
R22355 VSS.n5941 VSS.t2481 0.225061
R22356 VSS.n5912 VSS.t2478 0.225061
R22357 VSS.n5892 VSS.t2580 0.225061
R22358 VSS.n4844 VSS.t2576 0.225061
R22359 VSS.n6892 VSS.t2250 0.225061
R22360 VSS.n6914 VSS.t2253 0.225061
R22361 VSS.n7537 VSS.t2352 0.225061
R22362 VSS.n7536 VSS.t2355 0.225061
R22363 VSS.n7532 VSS.t2459 0.225061
R22364 VSS.n7572 VSS.t2457 0.225061
R22365 VSS.n7568 VSS.t2350 0.225061
R22366 VSS.n7573 VSS.t2455 0.225061
R22367 VSS.t2452 VSS.n7504 0.225061
R22368 VSS.n7489 VSS.t2343 0.225061
R22369 VSS.n7493 VSS.t2449 0.225061
R22370 VSS.n7488 VSS.t2341 0.225061
R22371 VSS.n7459 VSS.t2338 0.225061
R22372 VSS.n7436 VSS.t2442 0.225061
R22373 VSS.n7440 VSS.t2335 0.225061
R22374 VSS.n7435 VSS.t2440 0.225061
R22375 VSS.n7412 VSS.t2437 0.225061
R22376 VSS.n7388 VSS.t2328 0.225061
R22377 VSS.n7393 VSS.t2434 0.225061
R22378 VSS.n7387 VSS.t2326 0.225061
R22379 VSS.n7358 VSS.t2323 0.225061
R22380 VSS.n7335 VSS.t2427 0.225061
R22381 VSS.n7339 VSS.t2320 0.225061
R22382 VSS.n7334 VSS.t2425 0.225061
R22383 VSS.n7311 VSS.t2422 0.225061
R22384 VSS.n7287 VSS.t2313 0.225061
R22385 VSS.n7292 VSS.t2419 0.225061
R22386 VSS.n7286 VSS.t2311 0.225061
R22387 VSS.n7257 VSS.t2308 0.225061
R22388 VSS.n7234 VSS.t2412 0.225061
R22389 VSS.n7238 VSS.t2305 0.225061
R22390 VSS.n7233 VSS.t2410 0.225061
R22391 VSS.n7210 VSS.t2407 0.225061
R22392 VSS.n7186 VSS.t2298 0.225061
R22393 VSS.n7191 VSS.t2404 0.225061
R22394 VSS.n7185 VSS.t2296 0.225061
R22395 VSS.n7156 VSS.t2293 0.225061
R22396 VSS.n7133 VSS.t2397 0.225061
R22397 VSS.n7137 VSS.t2290 0.225061
R22398 VSS.n7132 VSS.t2395 0.225061
R22399 VSS.n7109 VSS.t2392 0.225061
R22400 VSS.n7085 VSS.t2283 0.225061
R22401 VSS.n7090 VSS.t2389 0.225061
R22402 VSS.n7084 VSS.t2281 0.225061
R22403 VSS.n7055 VSS.t2278 0.225061
R22404 VSS.n7032 VSS.t2382 0.225061
R22405 VSS.n7036 VSS.t2275 0.225061
R22406 VSS.n7031 VSS.t2380 0.225061
R22407 VSS.n7008 VSS.t2377 0.225061
R22408 VSS.n6984 VSS.t2268 0.225061
R22409 VSS.n6989 VSS.t2374 0.225061
R22410 VSS.n6983 VSS.t2266 0.225061
R22411 VSS.n6954 VSS.t2263 0.225061
R22412 VSS.n6934 VSS.t2365 0.225061
R22413 VSS.n6925 VSS.t2361 0.225061
R22414 VSS.t2035 VSS.n8294 0.225061
R22415 VSS.n8351 VSS.t2038 0.225061
R22416 VSS.n7623 VSS.t2137 0.225061
R22417 VSS.n7622 VSS.t2140 0.225061
R22418 VSS.n7618 VSS.t2244 0.225061
R22419 VSS.n7658 VSS.t2242 0.225061
R22420 VSS.n7654 VSS.t2135 0.225061
R22421 VSS.n7659 VSS.t2240 0.225061
R22422 VSS.t2237 VSS.n7674 0.225061
R22423 VSS.n7694 VSS.t2128 0.225061
R22424 VSS.n7690 VSS.t2234 0.225061
R22425 VSS.n7695 VSS.t2126 0.225061
R22426 VSS.n7725 VSS.t2123 0.225061
R22427 VSS.n7755 VSS.t2227 0.225061
R22428 VSS.n7751 VSS.t2120 0.225061
R22429 VSS.n7756 VSS.t2225 0.225061
R22430 VSS.t2222 VSS.n7780 0.225061
R22431 VSS.n7800 VSS.t2113 0.225061
R22432 VSS.n7796 VSS.t2219 0.225061
R22433 VSS.n7801 VSS.t2111 0.225061
R22434 VSS.n7831 VSS.t2108 0.225061
R22435 VSS.n7861 VSS.t2212 0.225061
R22436 VSS.n7857 VSS.t2105 0.225061
R22437 VSS.n7862 VSS.t2210 0.225061
R22438 VSS.t2207 VSS.n7886 0.225061
R22439 VSS.n7906 VSS.t2098 0.225061
R22440 VSS.n7902 VSS.t2204 0.225061
R22441 VSS.n7907 VSS.t2096 0.225061
R22442 VSS.n7937 VSS.t2093 0.225061
R22443 VSS.n7967 VSS.t2197 0.225061
R22444 VSS.n7963 VSS.t2090 0.225061
R22445 VSS.n7968 VSS.t2195 0.225061
R22446 VSS.t2192 VSS.n7992 0.225061
R22447 VSS.n8012 VSS.t2083 0.225061
R22448 VSS.n8008 VSS.t2189 0.225061
R22449 VSS.n8013 VSS.t2081 0.225061
R22450 VSS.n8043 VSS.t2078 0.225061
R22451 VSS.n8073 VSS.t2182 0.225061
R22452 VSS.n8069 VSS.t2075 0.225061
R22453 VSS.n8074 VSS.t2180 0.225061
R22454 VSS.t2177 VSS.n8098 0.225061
R22455 VSS.n8118 VSS.t2068 0.225061
R22456 VSS.n8114 VSS.t2174 0.225061
R22457 VSS.n8119 VSS.t2066 0.225061
R22458 VSS.n8149 VSS.t2063 0.225061
R22459 VSS.n8179 VSS.t2167 0.225061
R22460 VSS.n8175 VSS.t2060 0.225061
R22461 VSS.n8180 VSS.t2165 0.225061
R22462 VSS.t2162 VSS.n8204 0.225061
R22463 VSS.n8224 VSS.t2053 0.225061
R22464 VSS.n8220 VSS.t2159 0.225061
R22465 VSS.n8225 VSS.t2051 0.225061
R22466 VSS.n8255 VSS.t2048 0.225061
R22467 VSS.n2292 VSS.t2150 0.225061
R22468 VSS.n8360 VSS.t2146 0.225061
R22469 VSS.t1820 VSS.n9332 0.225061
R22470 VSS.n9389 VSS.t1823 0.225061
R22471 VSS.n8666 VSS.t1922 0.225061
R22472 VSS.n8665 VSS.t1925 0.225061
R22473 VSS.n8661 VSS.t2029 0.225061
R22474 VSS.n8701 VSS.t2027 0.225061
R22475 VSS.n8697 VSS.t1920 0.225061
R22476 VSS.n8702 VSS.t2025 0.225061
R22477 VSS.t2022 VSS.n8712 0.225061
R22478 VSS.n8732 VSS.t1913 0.225061
R22479 VSS.n8728 VSS.t2019 0.225061
R22480 VSS.n8733 VSS.t1911 0.225061
R22481 VSS.n8763 VSS.t1908 0.225061
R22482 VSS.n8793 VSS.t2012 0.225061
R22483 VSS.n8789 VSS.t1905 0.225061
R22484 VSS.n8794 VSS.t2010 0.225061
R22485 VSS.t2007 VSS.n8818 0.225061
R22486 VSS.n8838 VSS.t1898 0.225061
R22487 VSS.n8834 VSS.t2004 0.225061
R22488 VSS.n8839 VSS.t1896 0.225061
R22489 VSS.n8869 VSS.t1893 0.225061
R22490 VSS.n8899 VSS.t1997 0.225061
R22491 VSS.n8895 VSS.t1890 0.225061
R22492 VSS.n8900 VSS.t1995 0.225061
R22493 VSS.t1992 VSS.n8924 0.225061
R22494 VSS.n8944 VSS.t1883 0.225061
R22495 VSS.n8940 VSS.t1989 0.225061
R22496 VSS.n8945 VSS.t1881 0.225061
R22497 VSS.n8975 VSS.t1878 0.225061
R22498 VSS.n9005 VSS.t1982 0.225061
R22499 VSS.n9001 VSS.t1875 0.225061
R22500 VSS.n9006 VSS.t1980 0.225061
R22501 VSS.t1977 VSS.n9030 0.225061
R22502 VSS.n9050 VSS.t1868 0.225061
R22503 VSS.n9046 VSS.t1974 0.225061
R22504 VSS.n9051 VSS.t1866 0.225061
R22505 VSS.n9081 VSS.t1863 0.225061
R22506 VSS.n9111 VSS.t1967 0.225061
R22507 VSS.n9107 VSS.t1860 0.225061
R22508 VSS.n9112 VSS.t1965 0.225061
R22509 VSS.t1962 VSS.n9136 0.225061
R22510 VSS.n9156 VSS.t1853 0.225061
R22511 VSS.n9152 VSS.t1959 0.225061
R22512 VSS.n9157 VSS.t1851 0.225061
R22513 VSS.n9187 VSS.t1848 0.225061
R22514 VSS.n9217 VSS.t1952 0.225061
R22515 VSS.n9213 VSS.t1845 0.225061
R22516 VSS.n9218 VSS.t1950 0.225061
R22517 VSS.t1947 VSS.n9242 0.225061
R22518 VSS.n9262 VSS.t1838 0.225061
R22519 VSS.n9258 VSS.t1944 0.225061
R22520 VSS.n9263 VSS.t1836 0.225061
R22521 VSS.n9293 VSS.t1833 0.225061
R22522 VSS.n8384 VSS.t1935 0.225061
R22523 VSS.n9398 VSS.t1931 0.225061
R22524 VSS.n2249 VSS.t1711 0.225061
R22525 VSS.n2261 VSS.t1605 0.225061
R22526 VSS.n10015 VSS.t1704 0.225061
R22527 VSS.n10014 VSS.t1707 0.225061
R22528 VSS.n10010 VSS.t1814 0.225061
R22529 VSS.n10050 VSS.t1812 0.225061
R22530 VSS.n10046 VSS.t1702 0.225061
R22531 VSS.n10051 VSS.t1810 0.225061
R22532 VSS.t1807 VSS.n9982 0.225061
R22533 VSS.n9967 VSS.t1695 0.225061
R22534 VSS.n9971 VSS.t1804 0.225061
R22535 VSS.n9966 VSS.t1693 0.225061
R22536 VSS.n9937 VSS.t1690 0.225061
R22537 VSS.n9914 VSS.t1797 0.225061
R22538 VSS.n9918 VSS.t1687 0.225061
R22539 VSS.n9913 VSS.t1795 0.225061
R22540 VSS.n9890 VSS.t1792 0.225061
R22541 VSS.n9866 VSS.t1680 0.225061
R22542 VSS.n9871 VSS.t1789 0.225061
R22543 VSS.n9865 VSS.t1678 0.225061
R22544 VSS.n9836 VSS.t1675 0.225061
R22545 VSS.n9813 VSS.t1782 0.225061
R22546 VSS.n9817 VSS.t1672 0.225061
R22547 VSS.n9812 VSS.t1780 0.225061
R22548 VSS.n9789 VSS.t1777 0.225061
R22549 VSS.n9765 VSS.t1665 0.225061
R22550 VSS.n9770 VSS.t1774 0.225061
R22551 VSS.n9764 VSS.t1663 0.225061
R22552 VSS.n9735 VSS.t1660 0.225061
R22553 VSS.n9712 VSS.t1767 0.225061
R22554 VSS.n9716 VSS.t1657 0.225061
R22555 VSS.n9711 VSS.t1765 0.225061
R22556 VSS.n9688 VSS.t1762 0.225061
R22557 VSS.n9664 VSS.t1650 0.225061
R22558 VSS.n9669 VSS.t1759 0.225061
R22559 VSS.n9663 VSS.t1648 0.225061
R22560 VSS.n9634 VSS.t1645 0.225061
R22561 VSS.n9611 VSS.t1752 0.225061
R22562 VSS.n9615 VSS.t1642 0.225061
R22563 VSS.n9610 VSS.t1750 0.225061
R22564 VSS.n9587 VSS.t1747 0.225061
R22565 VSS.n9563 VSS.t1635 0.225061
R22566 VSS.n9568 VSS.t1744 0.225061
R22567 VSS.n9562 VSS.t1633 0.225061
R22568 VSS.n9533 VSS.t1630 0.225061
R22569 VSS.n9510 VSS.t1737 0.225061
R22570 VSS.n9514 VSS.t1627 0.225061
R22571 VSS.n9509 VSS.t1735 0.225061
R22572 VSS.n9486 VSS.t1732 0.225061
R22573 VSS.n9462 VSS.t1620 0.225061
R22574 VSS.n9467 VSS.t1729 0.225061
R22575 VSS.n9461 VSS.t1618 0.225061
R22576 VSS.n9432 VSS.t1615 0.225061
R22577 VSS.n9412 VSS.t1720 0.225061
R22578 VSS.n2272 VSS.t1716 0.225061
R22579 VSS.n10412 VSS.t1387 0.225061
R22580 VSS.n10434 VSS.t1390 0.225061
R22581 VSS.n11057 VSS.t1489 0.225061
R22582 VSS.n11056 VSS.t1492 0.225061
R22583 VSS.n11052 VSS.t1596 0.225061
R22584 VSS.n11092 VSS.t1594 0.225061
R22585 VSS.n11088 VSS.t1487 0.225061
R22586 VSS.n11093 VSS.t1592 0.225061
R22587 VSS.t1589 VSS.n11024 0.225061
R22588 VSS.n11009 VSS.t1480 0.225061
R22589 VSS.n11013 VSS.t1586 0.225061
R22590 VSS.n11008 VSS.t1478 0.225061
R22591 VSS.n10979 VSS.t1475 0.225061
R22592 VSS.n10956 VSS.t1579 0.225061
R22593 VSS.n10960 VSS.t1472 0.225061
R22594 VSS.n10955 VSS.t1577 0.225061
R22595 VSS.n10932 VSS.t1574 0.225061
R22596 VSS.n10908 VSS.t1465 0.225061
R22597 VSS.n10913 VSS.t1571 0.225061
R22598 VSS.n10907 VSS.t1463 0.225061
R22599 VSS.n10878 VSS.t1460 0.225061
R22600 VSS.n10855 VSS.t1564 0.225061
R22601 VSS.n10859 VSS.t1457 0.225061
R22602 VSS.n10854 VSS.t1562 0.225061
R22603 VSS.n10831 VSS.t1559 0.225061
R22604 VSS.n10807 VSS.t1450 0.225061
R22605 VSS.n10812 VSS.t1556 0.225061
R22606 VSS.n10806 VSS.t1448 0.225061
R22607 VSS.n10777 VSS.t1445 0.225061
R22608 VSS.n10754 VSS.t1549 0.225061
R22609 VSS.n10758 VSS.t1442 0.225061
R22610 VSS.n10753 VSS.t1547 0.225061
R22611 VSS.n10730 VSS.t1544 0.225061
R22612 VSS.n10706 VSS.t1435 0.225061
R22613 VSS.n10711 VSS.t1541 0.225061
R22614 VSS.n10705 VSS.t1433 0.225061
R22615 VSS.n10676 VSS.t1430 0.225061
R22616 VSS.n10653 VSS.t1534 0.225061
R22617 VSS.n10657 VSS.t1427 0.225061
R22618 VSS.n10652 VSS.t1532 0.225061
R22619 VSS.n10629 VSS.t1529 0.225061
R22620 VSS.n10605 VSS.t1420 0.225061
R22621 VSS.n10610 VSS.t1526 0.225061
R22622 VSS.n10604 VSS.t1418 0.225061
R22623 VSS.n10575 VSS.t1415 0.225061
R22624 VSS.n10552 VSS.t1519 0.225061
R22625 VSS.n10556 VSS.t1412 0.225061
R22626 VSS.n10551 VSS.t1517 0.225061
R22627 VSS.n10528 VSS.t1514 0.225061
R22628 VSS.n10504 VSS.t1405 0.225061
R22629 VSS.n10509 VSS.t1511 0.225061
R22630 VSS.n10503 VSS.t1403 0.225061
R22631 VSS.n10474 VSS.t1400 0.225061
R22632 VSS.n10454 VSS.t1502 0.225061
R22633 VSS.n10445 VSS.t1498 0.225061
R22634 VSS.t1172 VSS.n11814 0.225061
R22635 VSS.n11871 VSS.t1175 0.225061
R22636 VSS.n11143 VSS.t1274 0.225061
R22637 VSS.n11142 VSS.t1277 0.225061
R22638 VSS.n11138 VSS.t1381 0.225061
R22639 VSS.n11178 VSS.t1379 0.225061
R22640 VSS.n11174 VSS.t1272 0.225061
R22641 VSS.n11179 VSS.t1377 0.225061
R22642 VSS.t1374 VSS.n11194 0.225061
R22643 VSS.n11214 VSS.t1265 0.225061
R22644 VSS.n11210 VSS.t1371 0.225061
R22645 VSS.n11215 VSS.t1263 0.225061
R22646 VSS.n11245 VSS.t1260 0.225061
R22647 VSS.n11275 VSS.t1364 0.225061
R22648 VSS.n11271 VSS.t1257 0.225061
R22649 VSS.n11276 VSS.t1362 0.225061
R22650 VSS.t1359 VSS.n11300 0.225061
R22651 VSS.n11320 VSS.t1250 0.225061
R22652 VSS.n11316 VSS.t1356 0.225061
R22653 VSS.n11321 VSS.t1248 0.225061
R22654 VSS.n11351 VSS.t1245 0.225061
R22655 VSS.n11381 VSS.t1349 0.225061
R22656 VSS.n11377 VSS.t1242 0.225061
R22657 VSS.n11382 VSS.t1347 0.225061
R22658 VSS.t1344 VSS.n11406 0.225061
R22659 VSS.n11426 VSS.t1235 0.225061
R22660 VSS.n11422 VSS.t1341 0.225061
R22661 VSS.n11427 VSS.t1233 0.225061
R22662 VSS.n11457 VSS.t1230 0.225061
R22663 VSS.n11487 VSS.t1334 0.225061
R22664 VSS.n11483 VSS.t1227 0.225061
R22665 VSS.n11488 VSS.t1332 0.225061
R22666 VSS.t1329 VSS.n11512 0.225061
R22667 VSS.n11532 VSS.t1220 0.225061
R22668 VSS.n11528 VSS.t1326 0.225061
R22669 VSS.n11533 VSS.t1218 0.225061
R22670 VSS.n11563 VSS.t1215 0.225061
R22671 VSS.n11593 VSS.t1319 0.225061
R22672 VSS.n11589 VSS.t1212 0.225061
R22673 VSS.n11594 VSS.t1317 0.225061
R22674 VSS.t1314 VSS.n11618 0.225061
R22675 VSS.n11638 VSS.t1205 0.225061
R22676 VSS.n11634 VSS.t1311 0.225061
R22677 VSS.n11639 VSS.t1203 0.225061
R22678 VSS.n11669 VSS.t1200 0.225061
R22679 VSS.n11699 VSS.t1304 0.225061
R22680 VSS.n11695 VSS.t1197 0.225061
R22681 VSS.n11700 VSS.t1302 0.225061
R22682 VSS.t1299 VSS.n11724 0.225061
R22683 VSS.n11744 VSS.t1190 0.225061
R22684 VSS.n11740 VSS.t1296 0.225061
R22685 VSS.n11745 VSS.t1188 0.225061
R22686 VSS.n11775 VSS.t1185 0.225061
R22687 VSS.n1670 VSS.t1287 0.225061
R22688 VSS.n11880 VSS.t1283 0.225061
R22689 VSS.t957 VSS.n12852 0.225061
R22690 VSS.n12909 VSS.t960 0.225061
R22691 VSS.n12186 VSS.t1059 0.225061
R22692 VSS.n12185 VSS.t1062 0.225061
R22693 VSS.n12181 VSS.t1166 0.225061
R22694 VSS.n12221 VSS.t1164 0.225061
R22695 VSS.n12217 VSS.t1057 0.225061
R22696 VSS.n12222 VSS.t1162 0.225061
R22697 VSS.t1159 VSS.n12232 0.225061
R22698 VSS.n12252 VSS.t1050 0.225061
R22699 VSS.n12248 VSS.t1156 0.225061
R22700 VSS.n12253 VSS.t1048 0.225061
R22701 VSS.n12283 VSS.t1045 0.225061
R22702 VSS.n12313 VSS.t1149 0.225061
R22703 VSS.n12309 VSS.t1042 0.225061
R22704 VSS.n12314 VSS.t1147 0.225061
R22705 VSS.t1144 VSS.n12338 0.225061
R22706 VSS.n12358 VSS.t1035 0.225061
R22707 VSS.n12354 VSS.t1141 0.225061
R22708 VSS.n12359 VSS.t1033 0.225061
R22709 VSS.n12389 VSS.t1030 0.225061
R22710 VSS.n12419 VSS.t1134 0.225061
R22711 VSS.n12415 VSS.t1027 0.225061
R22712 VSS.n12420 VSS.t1132 0.225061
R22713 VSS.t1129 VSS.n12444 0.225061
R22714 VSS.n12464 VSS.t1020 0.225061
R22715 VSS.n12460 VSS.t1126 0.225061
R22716 VSS.n12465 VSS.t1018 0.225061
R22717 VSS.n12495 VSS.t1015 0.225061
R22718 VSS.n12525 VSS.t1119 0.225061
R22719 VSS.n12521 VSS.t1012 0.225061
R22720 VSS.n12526 VSS.t1117 0.225061
R22721 VSS.t1114 VSS.n12550 0.225061
R22722 VSS.n12570 VSS.t1005 0.225061
R22723 VSS.n12566 VSS.t1111 0.225061
R22724 VSS.n12571 VSS.t1003 0.225061
R22725 VSS.n12601 VSS.t1000 0.225061
R22726 VSS.n12631 VSS.t1104 0.225061
R22727 VSS.n12627 VSS.t997 0.225061
R22728 VSS.n12632 VSS.t1102 0.225061
R22729 VSS.t1099 VSS.n12656 0.225061
R22730 VSS.n12676 VSS.t990 0.225061
R22731 VSS.n12672 VSS.t1096 0.225061
R22732 VSS.n12677 VSS.t988 0.225061
R22733 VSS.n12707 VSS.t985 0.225061
R22734 VSS.n12737 VSS.t1089 0.225061
R22735 VSS.n12733 VSS.t982 0.225061
R22736 VSS.n12738 VSS.t1087 0.225061
R22737 VSS.t1084 VSS.n12762 0.225061
R22738 VSS.n12782 VSS.t975 0.225061
R22739 VSS.n12778 VSS.t1081 0.225061
R22740 VSS.n12783 VSS.t973 0.225061
R22741 VSS.n12813 VSS.t970 0.225061
R22742 VSS.n11904 VSS.t1072 0.225061
R22743 VSS.n12918 VSS.t1068 0.225061
R22744 VSS.n1617 VSS.t742 0.225061
R22745 VSS.n1639 VSS.t745 0.225061
R22746 VSS.n13535 VSS.t844 0.225061
R22747 VSS.n13534 VSS.t847 0.225061
R22748 VSS.n13530 VSS.t951 0.225061
R22749 VSS.n13570 VSS.t949 0.225061
R22750 VSS.n13566 VSS.t842 0.225061
R22751 VSS.n13571 VSS.t947 0.225061
R22752 VSS.t944 VSS.n13502 0.225061
R22753 VSS.n13487 VSS.t835 0.225061
R22754 VSS.n13491 VSS.t941 0.225061
R22755 VSS.n13486 VSS.t833 0.225061
R22756 VSS.n13457 VSS.t830 0.225061
R22757 VSS.n13434 VSS.t934 0.225061
R22758 VSS.n13438 VSS.t827 0.225061
R22759 VSS.n13433 VSS.t932 0.225061
R22760 VSS.n13410 VSS.t929 0.225061
R22761 VSS.n13386 VSS.t820 0.225061
R22762 VSS.n13391 VSS.t926 0.225061
R22763 VSS.n13385 VSS.t818 0.225061
R22764 VSS.n13356 VSS.t815 0.225061
R22765 VSS.n13333 VSS.t919 0.225061
R22766 VSS.n13337 VSS.t812 0.225061
R22767 VSS.n13332 VSS.t917 0.225061
R22768 VSS.n13309 VSS.t914 0.225061
R22769 VSS.n13285 VSS.t805 0.225061
R22770 VSS.n13290 VSS.t911 0.225061
R22771 VSS.n13284 VSS.t803 0.225061
R22772 VSS.n13255 VSS.t800 0.225061
R22773 VSS.n13232 VSS.t904 0.225061
R22774 VSS.n13236 VSS.t797 0.225061
R22775 VSS.n13231 VSS.t902 0.225061
R22776 VSS.n13208 VSS.t899 0.225061
R22777 VSS.n13184 VSS.t790 0.225061
R22778 VSS.n13189 VSS.t896 0.225061
R22779 VSS.n13183 VSS.t788 0.225061
R22780 VSS.n13154 VSS.t785 0.225061
R22781 VSS.n13131 VSS.t889 0.225061
R22782 VSS.n13135 VSS.t782 0.225061
R22783 VSS.n13130 VSS.t887 0.225061
R22784 VSS.n13107 VSS.t884 0.225061
R22785 VSS.n13083 VSS.t775 0.225061
R22786 VSS.n13088 VSS.t881 0.225061
R22787 VSS.n13082 VSS.t773 0.225061
R22788 VSS.n13053 VSS.t770 0.225061
R22789 VSS.n13030 VSS.t874 0.225061
R22790 VSS.n13034 VSS.t767 0.225061
R22791 VSS.n13029 VSS.t872 0.225061
R22792 VSS.n13006 VSS.t869 0.225061
R22793 VSS.n12982 VSS.t760 0.225061
R22794 VSS.n12987 VSS.t866 0.225061
R22795 VSS.n12981 VSS.t758 0.225061
R22796 VSS.n12952 VSS.t755 0.225061
R22797 VSS.n12932 VSS.t857 0.225061
R22798 VSS.n1650 VSS.t853 0.225061
R22799 VSS.n13899 VSS.t547 0.225061
R22800 VSS.n13921 VSS.t550 0.225061
R22801 VSS.n14500 VSS.t634 0.225061
R22802 VSS.n14499 VSS.t637 0.225061
R22803 VSS.n14495 VSS.t736 0.225061
R22804 VSS.n14535 VSS.t734 0.225061
R22805 VSS.n14531 VSS.t632 0.225061
R22806 VSS.n14536 VSS.t732 0.225061
R22807 VSS.t729 VSS.n14467 0.225061
R22808 VSS.n14452 VSS.t625 0.225061
R22809 VSS.n14456 VSS.t726 0.225061
R22810 VSS.n14451 VSS.t623 0.225061
R22811 VSS.n14422 VSS.t620 0.225061
R22812 VSS.n14399 VSS.t719 0.225061
R22813 VSS.n14403 VSS.t617 0.225061
R22814 VSS.n14398 VSS.t717 0.225061
R22815 VSS.n14375 VSS.t714 0.225061
R22816 VSS.n14356 VSS.t711 0.225061
R22817 VSS.n14233 VSS.t691 0.225061
R22818 VSS.n14238 VSS.t599 0.225061
R22819 VSS.n14232 VSS.t689 0.225061
R22820 VSS.n14185 VSS.t592 0.225061
R22821 VSS.n14181 VSS.t683 0.225061
R22822 VSS.n14186 VSS.t590 0.225061
R22823 VSS.n14140 VSS.t679 0.225061
R22824 VSS.n14144 VSS.t587 0.225061
R22825 VSS.n14139 VSS.t677 0.225061
R22826 VSS.n14116 VSS.t674 0.225061
R22827 VSS.n14092 VSS.t580 0.225061
R22828 VSS.n14097 VSS.t671 0.225061
R22829 VSS.n14091 VSS.t578 0.225061
R22830 VSS.n14062 VSS.t575 0.225061
R22831 VSS.n14039 VSS.t664 0.225061
R22832 VSS.n14043 VSS.t572 0.225061
R22833 VSS.n14038 VSS.t662 0.225061
R22834 VSS.n14015 VSS.t659 0.225061
R22835 VSS.n13991 VSS.t565 0.225061
R22836 VSS.n13996 VSS.t656 0.225061
R22837 VSS.n13990 VSS.t563 0.225061
R22838 VSS.n13961 VSS.t560 0.225061
R22839 VSS.n13941 VSS.t647 0.225061
R22840 VSS.n13932 VSS.t643 0.225061
R22841 VSS.n15195 VSS.t399 0.225061
R22842 VSS.n15217 VSS.t402 0.225061
R22843 VSS.n14583 VSS.t464 0.225061
R22844 VSS.n14582 VSS.t467 0.225061
R22845 VSS.n14578 VSS.t541 0.225061
R22846 VSS.n14618 VSS.t539 0.225061
R22847 VSS.n14614 VSS.t462 0.225061
R22848 VSS.n14619 VSS.t537 0.225061
R22849 VSS.t534 VSS.n14634 0.225061
R22850 VSS.n14654 VSS.t455 0.225061
R22851 VSS.n14650 VSS.t531 0.225061
R22852 VSS.n14655 VSS.t453 0.225061
R22853 VSS.n14685 VSS.t450 0.225061
R22854 VSS.n14711 VSS.t447 0.225061
R22855 VSS.n14730 VSS.t444 0.225061
R22856 VSS.n14808 VSS.t439 0.225061
R22857 VSS.t438 VSS.n14797 0.225061
R22858 VSS.n14828 VSS.t435 0.225061
R22859 VSS.n14823 VSS.t509 0.225061
R22860 VSS.n14867 VSS.t427 0.225061
R22861 VSS.t507 VSS.n14862 0.225061
R22862 VSS.n14890 VSS.t425 0.225061
R22863 VSS.n14947 VSS.t416 0.225061
R22864 VSS.n14975 VSS.t413 0.225061
R22865 VSS.n15033 VSS.t410 0.225061
R22866 VSS.n3793 VSS.n3740 0.180304
R22867 VSS.n3798 VSS.n3739 0.180304
R22868 VSS.n198 VSS.n197 0.180304
R22869 VSS.n3807 VSS.n197 0.180304
R22870 VSS.n5868 VSS.n5799 0.180304
R22871 VSS.n5874 VSS.n5873 0.180304
R22872 VSS.n4857 VSS.n199 0.180304
R22873 VSS.n4860 VSS.n4857 0.180304
R22874 VSS.n4835 VSS.n4763 0.180304
R22875 VSS.n4840 VSS.n4762 0.180304
R22876 VSS.n201 VSS.n200 0.180304
R22877 VSS.n5888 VSS.n200 0.180304
R22878 VSS.n6916 VSS.n6844 0.180304
R22879 VSS.n6921 VSS.n6843 0.180304
R22880 VSS.n203 VSS.n202 0.180304
R22881 VSS.n6930 VSS.n202 0.180304
R22882 VSS.n8350 VSS.n8281 0.180304
R22883 VSS.n8356 VSS.n8355 0.180304
R22884 VSS.n2285 VSS.n204 0.180304
R22885 VSS.n2288 VSS.n2285 0.180304
R22886 VSS.n9388 VSS.n9319 0.180304
R22887 VSS.n9394 VSS.n9393 0.180304
R22888 VSS.n8377 VSS.n205 0.180304
R22889 VSS.n8380 VSS.n8377 0.180304
R22890 VSS.n2263 VSS.n2210 0.180304
R22891 VSS.n2268 VSS.n2209 0.180304
R22892 VSS.n207 VSS.n206 0.180304
R22893 VSS.n9408 VSS.n206 0.180304
R22894 VSS.n10436 VSS.n10364 0.180304
R22895 VSS.n10441 VSS.n10363 0.180304
R22896 VSS.n209 VSS.n208 0.180304
R22897 VSS.n10450 VSS.n208 0.180304
R22898 VSS.n11870 VSS.n11801 0.180304
R22899 VSS.n11876 VSS.n11875 0.180304
R22900 VSS.n1663 VSS.n210 0.180304
R22901 VSS.n1666 VSS.n1663 0.180304
R22902 VSS.n12908 VSS.n12839 0.180304
R22903 VSS.n12914 VSS.n12913 0.180304
R22904 VSS.n11897 VSS.n211 0.180304
R22905 VSS.n11900 VSS.n11897 0.180304
R22906 VSS.n1641 VSS.n1569 0.180304
R22907 VSS.n1646 VSS.n1568 0.180304
R22908 VSS.n213 VSS.n212 0.180304
R22909 VSS.n12928 VSS.n212 0.180304
R22910 VSS.n13923 VSS.n13851 0.180304
R22911 VSS.n13928 VSS.n13850 0.180304
R22912 VSS.n215 VSS.n214 0.180304
R22913 VSS.n13937 VSS.n214 0.180304
R22914 VSS.n3766 VSS.n127 0.180304
R22915 VSS.n3767 VSS.n3766 0.180304
R22916 VSS.n3746 VSS.n3745 0.180304
R22917 VSS.n191 VSS.n3737 0.180304
R22918 VSS.n3813 VSS.n3735 0.180304
R22919 VSS.n3814 VSS.n3813 0.180304
R22920 VSS.n3868 VSS.n3702 0.180304
R22921 VSS.n3874 VSS.n3699 0.180304
R22922 VSS.n3969 VSS.n3652 0.180304
R22923 VSS.n3975 VSS.n3649 0.180304
R22924 VSS.n4070 VSS.n3602 0.180304
R22925 VSS.n4076 VSS.n3599 0.180304
R22926 VSS.n4171 VSS.n3552 0.180304
R22927 VSS.n4177 VSS.n3549 0.180304
R22928 VSS.n4272 VSS.n3502 0.180304
R22929 VSS.n4278 VSS.n3499 0.180304
R22930 VSS.n4372 VSS.n4371 0.180304
R22931 VSS.n4394 VSS.n4393 0.180304
R22932 VSS.n4380 VSS.n88 0.290602
R22933 VSS.n5880 VSS.n5879 0.180304
R22934 VSS.n4866 VSS.n4855 0.180304
R22935 VSS.n4867 VSS.n4866 0.180304
R22936 VSS.n5739 VSS.n4886 0.180304
R22937 VSS.n5735 VSS.n5734 0.180304
R22938 VSS.n5633 VSS.n4928 0.180304
R22939 VSS.n5629 VSS.n5628 0.180304
R22940 VSS.n5527 VSS.n4970 0.180304
R22941 VSS.n5523 VSS.n5522 0.180304
R22942 VSS.n5421 VSS.n5012 0.180304
R22943 VSS.n5417 VSS.n5416 0.180304
R22944 VSS.n5315 VSS.n5054 0.180304
R22945 VSS.n5311 VSS.n5310 0.180304
R22946 VSS.n5209 VSS.n5096 0.180304
R22947 VSS.n5205 VSS.n5204 0.180304
R22948 VSS.n5191 VSS.n89 0.290602
R22949 VSS.n186 VSS.n4760 0.180304
R22950 VSS.n5894 VSS.n4758 0.180304
R22951 VSS.n5895 VSS.n5894 0.180304
R22952 VSS.n5949 VSS.n4725 0.180304
R22953 VSS.n5955 VSS.n4722 0.180304
R22954 VSS.n6050 VSS.n4675 0.180304
R22955 VSS.n6056 VSS.n4672 0.180304
R22956 VSS.n6151 VSS.n4625 0.180304
R22957 VSS.n6157 VSS.n4622 0.180304
R22958 VSS.n6252 VSS.n4575 0.180304
R22959 VSS.n6258 VSS.n4572 0.180304
R22960 VSS.n6353 VSS.n4525 0.180304
R22961 VSS.n6359 VSS.n4522 0.180304
R22962 VSS.n6453 VSS.n6452 0.180304
R22963 VSS.n6475 VSS.n6474 0.180304
R22964 VSS.n6461 VSS.n90 0.290602
R22965 VSS.n183 VSS.n6841 0.180304
R22966 VSS.n6936 VSS.n6839 0.180304
R22967 VSS.n6937 VSS.n6936 0.180304
R22968 VSS.n6991 VSS.n6806 0.180304
R22969 VSS.n6997 VSS.n6803 0.180304
R22970 VSS.n7092 VSS.n6756 0.180304
R22971 VSS.n7098 VSS.n6753 0.180304
R22972 VSS.n7193 VSS.n6706 0.180304
R22973 VSS.n7199 VSS.n6703 0.180304
R22974 VSS.n7294 VSS.n6656 0.180304
R22975 VSS.n7300 VSS.n6653 0.180304
R22976 VSS.n7395 VSS.n6606 0.180304
R22977 VSS.n7401 VSS.n6603 0.180304
R22978 VSS.n7495 VSS.n7494 0.180304
R22979 VSS.n7517 VSS.n7516 0.180304
R22980 VSS.n7503 VSS.n91 0.290602
R22981 VSS.n8362 VSS.n8361 0.180304
R22982 VSS.n2294 VSS.n2283 0.180304
R22983 VSS.n2295 VSS.n2294 0.180304
R22984 VSS.n8221 VSS.n2314 0.180304
R22985 VSS.n8217 VSS.n8216 0.180304
R22986 VSS.n8115 VSS.n2356 0.180304
R22987 VSS.n8111 VSS.n8110 0.180304
R22988 VSS.n8009 VSS.n2398 0.180304
R22989 VSS.n8005 VSS.n8004 0.180304
R22990 VSS.n7903 VSS.n2440 0.180304
R22991 VSS.n7899 VSS.n7898 0.180304
R22992 VSS.n7797 VSS.n2482 0.180304
R22993 VSS.n7793 VSS.n7792 0.180304
R22994 VSS.n7691 VSS.n2524 0.180304
R22995 VSS.n7687 VSS.n7686 0.180304
R22996 VSS.n7673 VSS.n92 0.290602
R22997 VSS.n9400 VSS.n9399 0.180304
R22998 VSS.n8386 VSS.n8375 0.180304
R22999 VSS.n8387 VSS.n8386 0.180304
R23000 VSS.n9259 VSS.n8406 0.180304
R23001 VSS.n9255 VSS.n9254 0.180304
R23002 VSS.n9153 VSS.n8448 0.180304
R23003 VSS.n9149 VSS.n9148 0.180304
R23004 VSS.n9047 VSS.n8490 0.180304
R23005 VSS.n9043 VSS.n9042 0.180304
R23006 VSS.n8941 VSS.n8532 0.180304
R23007 VSS.n8937 VSS.n8936 0.180304
R23008 VSS.n8835 VSS.n8574 0.180304
R23009 VSS.n8831 VSS.n8830 0.180304
R23010 VSS.n8729 VSS.n8616 0.180304
R23011 VSS.n8725 VSS.n8724 0.180304
R23012 VSS.n8711 VSS.n93 0.290602
R23013 VSS.n2236 VSS.n128 0.180304
R23014 VSS.n2237 VSS.n2236 0.180304
R23015 VSS.n2216 VSS.n2215 0.180304
R23016 VSS.n176 VSS.n2207 0.180304
R23017 VSS.n9414 VSS.n2205 0.180304
R23018 VSS.n9415 VSS.n9414 0.180304
R23019 VSS.n9469 VSS.n2172 0.180304
R23020 VSS.n9475 VSS.n2169 0.180304
R23021 VSS.n9570 VSS.n2122 0.180304
R23022 VSS.n9576 VSS.n2119 0.180304
R23023 VSS.n9671 VSS.n2072 0.180304
R23024 VSS.n9677 VSS.n2069 0.180304
R23025 VSS.n9772 VSS.n2022 0.180304
R23026 VSS.n9778 VSS.n2019 0.180304
R23027 VSS.n9873 VSS.n1972 0.180304
R23028 VSS.n9879 VSS.n1969 0.180304
R23029 VSS.n9973 VSS.n9972 0.180304
R23030 VSS.n9995 VSS.n9994 0.180304
R23031 VSS.n9981 VSS.n94 0.290602
R23032 VSS.n173 VSS.n10361 0.180304
R23033 VSS.n10456 VSS.n10359 0.180304
R23034 VSS.n10457 VSS.n10456 0.180304
R23035 VSS.n10511 VSS.n10326 0.180304
R23036 VSS.n10517 VSS.n10323 0.180304
R23037 VSS.n10612 VSS.n10276 0.180304
R23038 VSS.n10618 VSS.n10273 0.180304
R23039 VSS.n10713 VSS.n10226 0.180304
R23040 VSS.n10719 VSS.n10223 0.180304
R23041 VSS.n10814 VSS.n10176 0.180304
R23042 VSS.n10820 VSS.n10173 0.180304
R23043 VSS.n10915 VSS.n10126 0.180304
R23044 VSS.n10921 VSS.n10123 0.180304
R23045 VSS.n11015 VSS.n11014 0.180304
R23046 VSS.n11037 VSS.n11036 0.180304
R23047 VSS.n11023 VSS.n95 0.290602
R23048 VSS.n11882 VSS.n11881 0.180304
R23049 VSS.n1672 VSS.n1661 0.180304
R23050 VSS.n1673 VSS.n1672 0.180304
R23051 VSS.n11741 VSS.n1692 0.180304
R23052 VSS.n11737 VSS.n11736 0.180304
R23053 VSS.n11635 VSS.n1734 0.180304
R23054 VSS.n11631 VSS.n11630 0.180304
R23055 VSS.n11529 VSS.n1776 0.180304
R23056 VSS.n11525 VSS.n11524 0.180304
R23057 VSS.n11423 VSS.n1818 0.180304
R23058 VSS.n11419 VSS.n11418 0.180304
R23059 VSS.n11317 VSS.n1860 0.180304
R23060 VSS.n11313 VSS.n11312 0.180304
R23061 VSS.n11211 VSS.n1902 0.180304
R23062 VSS.n11207 VSS.n11206 0.180304
R23063 VSS.n11193 VSS.n96 0.290602
R23064 VSS.n12920 VSS.n12919 0.180304
R23065 VSS.n11906 VSS.n11895 0.180304
R23066 VSS.n11907 VSS.n11906 0.180304
R23067 VSS.n12779 VSS.n11926 0.180304
R23068 VSS.n12775 VSS.n12774 0.180304
R23069 VSS.n12673 VSS.n11968 0.180304
R23070 VSS.n12669 VSS.n12668 0.180304
R23071 VSS.n12567 VSS.n12010 0.180304
R23072 VSS.n12563 VSS.n12562 0.180304
R23073 VSS.n12461 VSS.n12052 0.180304
R23074 VSS.n12457 VSS.n12456 0.180304
R23075 VSS.n12355 VSS.n12094 0.180304
R23076 VSS.n12351 VSS.n12350 0.180304
R23077 VSS.n12249 VSS.n12136 0.180304
R23078 VSS.n12245 VSS.n12244 0.180304
R23079 VSS.n12231 VSS.n97 0.290602
R23080 VSS.n166 VSS.n1566 0.180304
R23081 VSS.n12934 VSS.n1564 0.180304
R23082 VSS.n12935 VSS.n12934 0.180304
R23083 VSS.n12989 VSS.n1531 0.180304
R23084 VSS.n12995 VSS.n1528 0.180304
R23085 VSS.n13090 VSS.n1481 0.180304
R23086 VSS.n13096 VSS.n1478 0.180304
R23087 VSS.n13191 VSS.n1431 0.180304
R23088 VSS.n13197 VSS.n1428 0.180304
R23089 VSS.n13292 VSS.n1381 0.180304
R23090 VSS.n13298 VSS.n1378 0.180304
R23091 VSS.n13393 VSS.n1331 0.180304
R23092 VSS.n13399 VSS.n1328 0.180304
R23093 VSS.n13493 VSS.n13492 0.180304
R23094 VSS.n13515 VSS.n13514 0.180304
R23095 VSS.n13501 VSS.n98 0.290602
R23096 VSS.n163 VSS.n13848 0.180304
R23097 VSS.n13943 VSS.n13846 0.180304
R23098 VSS.n13944 VSS.n13943 0.180304
R23099 VSS.n13998 VSS.n13813 0.180304
R23100 VSS.n14004 VSS.n13810 0.180304
R23101 VSS.n14099 VSS.n13763 0.180304
R23102 VSS.n14105 VSS.n13760 0.180304
R23103 VSS.n14182 VSS.n14156 0.180304
R23104 VSS.n14177 VSS.n14156 0.180304
R23105 VSS.n14219 VSS.n13738 0.180304
R23106 VSS.n14220 VSS.n14219 0.180304
R23107 VSS.n14359 VSS.n13643 0.180304
R23108 VSS.n14364 VSS.n13643 0.180304
R23109 VSS.n14458 VSS.n14457 0.180304
R23110 VSS.n14480 VSS.n14479 0.180304
R23111 VSS.n14466 VSS.n99 0.290602
R23112 VSS.n302 VSS.n33 0.180304
R23113 VSS.n15226 VSS.n15225 0.180304
R23114 VSS.n15044 VSS.n316 0.180304
R23115 VSS.n15043 VSS.n15042 0.180304
R23116 VSS.n15027 VSS.n15026 0.180304
R23117 VSS.n14651 VSS.n450 0.180304
R23118 VSS.n14647 VSS.n14646 0.180304
R23119 VSS.n14633 VSS.n100 0.290602
R23120 VSS.t2994 VSS.n3442 0.172697
R23121 VSS.n4297 VSS.t2979 0.172697
R23122 VSS.n4196 VSS.t2964 0.172697
R23123 VSS.n4095 VSS.t2949 0.172697
R23124 VSS.n3994 VSS.t2934 0.172697
R23125 VSS.n3893 VSS.t2919 0.172697
R23126 VSS.t2779 VSS.n5110 0.172697
R23127 VSS.n5294 VSS.t2764 0.172697
R23128 VSS.n5400 VSS.t2749 0.172697
R23129 VSS.n5506 VSS.t2734 0.172697
R23130 VSS.n5612 VSS.t2719 0.172697
R23131 VSS.n5718 VSS.t2704 0.172697
R23132 VSS.t2564 VSS.n4465 0.172697
R23133 VSS.n6378 VSS.t2549 0.172697
R23134 VSS.n6277 VSS.t2534 0.172697
R23135 VSS.n6176 VSS.t2519 0.172697
R23136 VSS.n6075 VSS.t2504 0.172697
R23137 VSS.n5974 VSS.t2489 0.172697
R23138 VSS.t2349 VSS.n6546 0.172697
R23139 VSS.n7420 VSS.t2334 0.172697
R23140 VSS.n7319 VSS.t2319 0.172697
R23141 VSS.n7218 VSS.t2304 0.172697
R23142 VSS.n7117 VSS.t2289 0.172697
R23143 VSS.n7016 VSS.t2274 0.172697
R23144 VSS.n7671 VSS.t2134 0.172697
R23145 VSS.n7776 VSS.t2119 0.172697
R23146 VSS.n7882 VSS.t2104 0.172697
R23147 VSS.n7988 VSS.t2089 0.172697
R23148 VSS.n8094 VSS.t2074 0.172697
R23149 VSS.n8200 VSS.t2059 0.172697
R23150 VSS.t1919 VSS.n8630 0.172697
R23151 VSS.n8814 VSS.t1904 0.172697
R23152 VSS.n8920 VSS.t1889 0.172697
R23153 VSS.n9026 VSS.t1874 0.172697
R23154 VSS.n9132 VSS.t1859 0.172697
R23155 VSS.n9238 VSS.t1844 0.172697
R23156 VSS.t1701 VSS.n1912 0.172697
R23157 VSS.n9898 VSS.t1686 0.172697
R23158 VSS.n9797 VSS.t1671 0.172697
R23159 VSS.n9696 VSS.t1656 0.172697
R23160 VSS.n9595 VSS.t1641 0.172697
R23161 VSS.n9494 VSS.t1626 0.172697
R23162 VSS.t1486 VSS.n10066 0.172697
R23163 VSS.n10940 VSS.t1471 0.172697
R23164 VSS.n10839 VSS.t1456 0.172697
R23165 VSS.n10738 VSS.t1441 0.172697
R23166 VSS.n10637 VSS.t1426 0.172697
R23167 VSS.n10536 VSS.t1411 0.172697
R23168 VSS.n11191 VSS.t1271 0.172697
R23169 VSS.n11296 VSS.t1256 0.172697
R23170 VSS.n11402 VSS.t1241 0.172697
R23171 VSS.n11508 VSS.t1226 0.172697
R23172 VSS.n11614 VSS.t1211 0.172697
R23173 VSS.n11720 VSS.t1196 0.172697
R23174 VSS.t1056 VSS.n12150 0.172697
R23175 VSS.n12334 VSS.t1041 0.172697
R23176 VSS.n12440 VSS.t1026 0.172697
R23177 VSS.n12546 VSS.t1011 0.172697
R23178 VSS.n12652 VSS.t996 0.172697
R23179 VSS.n12758 VSS.t981 0.172697
R23180 VSS.t841 VSS.n1271 0.172697
R23181 VSS.n13418 VSS.t826 0.172697
R23182 VSS.n13317 VSS.t811 0.172697
R23183 VSS.n13216 VSS.t796 0.172697
R23184 VSS.n13115 VSS.t781 0.172697
R23185 VSS.n13014 VSS.t766 0.172697
R23186 VSS.t631 VSS.n13586 0.172697
R23187 VSS.n14383 VSS.t616 0.172697
R23188 VSS.t602 VSS.n14266 0.172697
R23189 VSS.n14124 VSS.t586 0.172697
R23190 VSS.n14023 VSS.t571 0.172697
R23191 VSS.n14631 VSS.t461 0.172697
R23192 VSS.n224 VSS.n4463 0.1603
R23193 VSS.n6544 VSS.n224 0.1603
R23194 VSS.n7586 VSS.n6544 0.1603
R23195 VSS.n7672 VSS.n7586 0.1603
R23196 VSS.n7672 VSS.n223 0.1603
R23197 VSS.n10064 VSS.n223 0.1603
R23198 VSS.n11106 VSS.n10064 0.1603
R23199 VSS.n11192 VSS.n11106 0.1603
R23200 VSS.n11192 VSS.n222 0.1603
R23201 VSS.n13584 VSS.n222 0.1603
R23202 VSS.n14549 VSS.n13584 0.1603
R23203 VSS.n14632 VSS.n14549 0.1603
R23204 VSS.n14632 VSS.n37 2.73036
R23205 VSS.t707 VSS.n217 0.263514
R23206 VSS.n5883 VSS.n228 0.1603
R23207 VSS.n5884 VSS.n5883 0.1603
R23208 VSS.n5884 VSS.n227 0.1603
R23209 VSS.n8365 VSS.n227 0.1603
R23210 VSS.n9403 VSS.n8365 0.1603
R23211 VSS.n9404 VSS.n9403 0.1603
R23212 VSS.n9404 VSS.n226 0.1603
R23213 VSS.n11885 VSS.n226 0.1603
R23214 VSS.n12923 VSS.n11885 0.1603
R23215 VSS.n12924 VSS.n12923 0.1603
R23216 VSS.n12924 VSS.n225 0.1603
R23217 VSS.n15240 VSS.n225 0.1603
R23218 VSS VSS.n228 0.1603
R23219 VSS.n4463 VSS 0.1603
R23220 VSS.n192 VSS.n191 0.151658
R23221 VSS.n5880 VSS.n189 0.151658
R23222 VSS.n187 VSS.n186 0.151658
R23223 VSS.n184 VSS.n183 0.151658
R23224 VSS.n8362 VSS.n181 0.151658
R23225 VSS.n9400 VSS.n179 0.151658
R23226 VSS.n177 VSS.n176 0.151658
R23227 VSS.n174 VSS.n173 0.151658
R23228 VSS.n11882 VSS.n171 0.151658
R23229 VSS.n12920 VSS.n169 0.151658
R23230 VSS.n167 VSS.n166 0.151658
R23231 VSS.n164 VSS.n163 0.151658
R23232 VSS.t2684 VSS.n5847 0.140136
R23233 VSS.n4812 VSS.t2469 0.140136
R23234 VSS.n6893 VSS.t2254 0.140136
R23235 VSS.t2039 VSS.n8329 0.140136
R23236 VSS.t1824 VSS.n9367 0.140136
R23237 VSS.n10413 VSS.t1391 0.140136
R23238 VSS.t1176 VSS.n11849 0.140136
R23239 VSS.t961 VSS.n12887 0.140136
R23240 VSS.n1618 VSS.t746 0.140136
R23241 VSS.n13900 VSS.t551 0.140136
R23242 VSS.n15196 VSS.t403 0.140136
R23243 VSS.n14974 VSS.t415 0.140136
R23244 VSS.n15038 VSS.t412 0.140136
R23245 VSS.n215 VSS.n123 0.0694316
R23246 VSS.n213 VSS.n121 0.0694316
R23247 VSS.n119 VSS.n211 0.0694316
R23248 VSS.n117 VSS.n210 0.0694316
R23249 VSS.n209 VSS.n115 0.0694316
R23250 VSS.n207 VSS.n113 0.0694316
R23251 VSS.n111 VSS.n205 0.0694316
R23252 VSS.n109 VSS.n204 0.0694316
R23253 VSS.n203 VSS.n107 0.0694316
R23254 VSS.n201 VSS.n105 0.0694316
R23255 VSS.n103 VSS.n199 0.0694316
R23256 VSS.n198 VSS.n101 0.0694316
R23257 VSS.n14276 VSS.t223 0.13667
R23258 VSS.n15076 VSS.t24 0.13667
R23259 VSS.n15293 VSS.n15292 0.120292
R23260 VSS.n15297 VSS.n15292 0.120292
R23261 VSS.n15298 VSS.n15297 0.120292
R23262 VSS.n15299 VSS.n15298 0.120292
R23263 VSS.n15299 VSS.n15286 0.120292
R23264 VSS.n15307 VSS.n15286 0.120292
R23265 VSS.n15308 VSS.n15307 0.120292
R23266 VSS.n15309 VSS.n15308 0.120292
R23267 VSS.n15309 VSS.n15284 0.120292
R23268 VSS.n15313 VSS.n15284 0.120292
R23269 VSS.n15314 VSS.n15313 0.120292
R23270 VSS.n15315 VSS.n15314 0.120292
R23271 VSS.n15315 VSS.n15282 0.120292
R23272 VSS.n15319 VSS.n15282 0.120292
R23273 VSS.n15320 VSS.n15319 0.120292
R23274 VSS.n15321 VSS.n15320 0.120292
R23275 VSS.n15321 VSS.n15276 0.120292
R23276 VSS.n15329 VSS.n15276 0.120292
R23277 VSS.n15330 VSS.n15329 0.120292
R23278 VSS.n15331 VSS.n15330 0.120292
R23279 VSS.n15331 VSS.n15274 0.120292
R23280 VSS.n15335 VSS.n15274 0.120292
R23281 VSS.n15336 VSS.n15335 0.120292
R23282 VSS.n15337 VSS.n15336 0.120292
R23283 VSS.n15337 VSS.n15272 0.120292
R23284 VSS.n15341 VSS.n15272 0.120292
R23285 VSS.n15342 VSS.n15341 0.120292
R23286 VSS.n15343 VSS.n15342 0.120292
R23287 VSS.n15343 VSS.n239 0.120292
R23288 VSS.n15349 VSS.n239 0.120292
R23289 VSS.n15350 VSS.n15349 0.120292
R23290 VSS.n15350 VSS.n238 0.120292
R23291 VSS.n2899 VSS.n2898 0.120292
R23292 VSS.n2900 VSS.n2899 0.120292
R23293 VSS.n2900 VSS.n2886 0.120292
R23294 VSS.n2904 VSS.n2886 0.120292
R23295 VSS.n2905 VSS.n2904 0.120292
R23296 VSS.n2906 VSS.n2905 0.120292
R23297 VSS.n2906 VSS.n2874 0.120292
R23298 VSS.n2912 VSS.n2874 0.120292
R23299 VSS.n2913 VSS.n2912 0.120292
R23300 VSS.n2913 VSS.n2873 0.120292
R23301 VSS.n2873 VSS.n2869 0.120292
R23302 VSS.n2921 VSS.n2869 0.120292
R23303 VSS.n2922 VSS.n2921 0.120292
R23304 VSS.n2923 VSS.n2922 0.120292
R23305 VSS.n2923 VSS.n2867 0.120292
R23306 VSS.n2927 VSS.n2867 0.120292
R23307 VSS.n2928 VSS.n2927 0.120292
R23308 VSS.n2929 VSS.n2928 0.120292
R23309 VSS.n2929 VSS.n2865 0.120292
R23310 VSS.n2935 VSS.n2865 0.120292
R23311 VSS.n2936 VSS.n2935 0.120292
R23312 VSS.n2936 VSS.n2864 0.120292
R23313 VSS.n2864 VSS.n2860 0.120292
R23314 VSS.n2944 VSS.n2860 0.120292
R23315 VSS.n2945 VSS.n2944 0.120292
R23316 VSS.n2946 VSS.n2945 0.120292
R23317 VSS.n2946 VSS.n2858 0.120292
R23318 VSS.n2950 VSS.n2858 0.120292
R23319 VSS.n2951 VSS.n2950 0.120292
R23320 VSS.n2952 VSS.n2951 0.120292
R23321 VSS.n2952 VSS.n2856 0.120292
R23322 VSS.n2956 VSS.n2856 0.120292
R23323 VSS.n2957 VSS.n2956 0.120292
R23324 VSS.n2958 VSS.n2957 0.120292
R23325 VSS.n2958 VSS.n2854 0.120292
R23326 VSS.n2964 VSS.n2854 0.120292
R23327 VSS.n2965 VSS.n2964 0.120292
R23328 VSS.n2965 VSS.n2853 0.120292
R23329 VSS.n2853 VSS.n2849 0.120292
R23330 VSS.n2973 VSS.n2849 0.120292
R23331 VSS.n2974 VSS.n2973 0.120292
R23332 VSS.n2975 VSS.n2974 0.120292
R23333 VSS.n2975 VSS.n2847 0.120292
R23334 VSS.n2979 VSS.n2847 0.120292
R23335 VSS.n2980 VSS.n2979 0.120292
R23336 VSS.n2981 VSS.n2980 0.120292
R23337 VSS.n2981 VSS.n2845 0.120292
R23338 VSS.n2987 VSS.n2845 0.120292
R23339 VSS.n2988 VSS.n2987 0.120292
R23340 VSS.n2988 VSS.n2844 0.120292
R23341 VSS.n2844 VSS.n2840 0.120292
R23342 VSS.n2996 VSS.n2840 0.120292
R23343 VSS.n2997 VSS.n2996 0.120292
R23344 VSS.n2998 VSS.n2997 0.120292
R23345 VSS.n2998 VSS.n2838 0.120292
R23346 VSS.n3002 VSS.n2838 0.120292
R23347 VSS.n3003 VSS.n3002 0.120292
R23348 VSS.n3004 VSS.n3003 0.120292
R23349 VSS.n3004 VSS.n2836 0.120292
R23350 VSS.n3008 VSS.n2836 0.120292
R23351 VSS.n3009 VSS.n3008 0.120292
R23352 VSS.n3010 VSS.n3009 0.120292
R23353 VSS.n3010 VSS.n2834 0.120292
R23354 VSS.n3016 VSS.n2834 0.120292
R23355 VSS.n3017 VSS.n3016 0.120292
R23356 VSS.n3017 VSS.n2833 0.120292
R23357 VSS.n2833 VSS.n2829 0.120292
R23358 VSS.n3025 VSS.n2829 0.120292
R23359 VSS.n3026 VSS.n3025 0.120292
R23360 VSS.n3027 VSS.n3026 0.120292
R23361 VSS.n3027 VSS.n2827 0.120292
R23362 VSS.n3031 VSS.n2827 0.120292
R23363 VSS.n3032 VSS.n3031 0.120292
R23364 VSS.n3033 VSS.n3032 0.120292
R23365 VSS.n3033 VSS.n2825 0.120292
R23366 VSS.n3039 VSS.n2825 0.120292
R23367 VSS.n3040 VSS.n3039 0.120292
R23368 VSS.n3040 VSS.n2824 0.120292
R23369 VSS.n2824 VSS.n2820 0.120292
R23370 VSS.n3048 VSS.n2820 0.120292
R23371 VSS.n3049 VSS.n3048 0.120292
R23372 VSS.n3050 VSS.n3049 0.120292
R23373 VSS.n3050 VSS.n2818 0.120292
R23374 VSS.n3054 VSS.n2818 0.120292
R23375 VSS.n3055 VSS.n3054 0.120292
R23376 VSS.n3056 VSS.n3055 0.120292
R23377 VSS.n3056 VSS.n2816 0.120292
R23378 VSS.n3060 VSS.n2816 0.120292
R23379 VSS.n3061 VSS.n3060 0.120292
R23380 VSS.n3062 VSS.n3061 0.120292
R23381 VSS.n3062 VSS.n2814 0.120292
R23382 VSS.n3068 VSS.n2814 0.120292
R23383 VSS.n3069 VSS.n3068 0.120292
R23384 VSS.n3069 VSS.n2813 0.120292
R23385 VSS.n2813 VSS.n2809 0.120292
R23386 VSS.n3077 VSS.n2809 0.120292
R23387 VSS.n3078 VSS.n3077 0.120292
R23388 VSS.n3079 VSS.n3078 0.120292
R23389 VSS.n3079 VSS.n2807 0.120292
R23390 VSS.n3083 VSS.n2807 0.120292
R23391 VSS.n3084 VSS.n3083 0.120292
R23392 VSS.n3085 VSS.n3084 0.120292
R23393 VSS.n3085 VSS.n2805 0.120292
R23394 VSS.n3091 VSS.n2805 0.120292
R23395 VSS.n3092 VSS.n3091 0.120292
R23396 VSS.n3092 VSS.n2804 0.120292
R23397 VSS.n2804 VSS.n2800 0.120292
R23398 VSS.n3100 VSS.n2800 0.120292
R23399 VSS.n3101 VSS.n3100 0.120292
R23400 VSS.n3102 VSS.n3101 0.120292
R23401 VSS.n3102 VSS.n2798 0.120292
R23402 VSS.n3106 VSS.n2798 0.120292
R23403 VSS.n3107 VSS.n3106 0.120292
R23404 VSS.n3108 VSS.n3107 0.120292
R23405 VSS.n3108 VSS.n2796 0.120292
R23406 VSS.n3112 VSS.n2796 0.120292
R23407 VSS.n3113 VSS.n3112 0.120292
R23408 VSS.n3114 VSS.n3113 0.120292
R23409 VSS.n3114 VSS.n2794 0.120292
R23410 VSS.n3120 VSS.n2794 0.120292
R23411 VSS.n3121 VSS.n3120 0.120292
R23412 VSS.n3121 VSS.n2793 0.120292
R23413 VSS.n2793 VSS.n2789 0.120292
R23414 VSS.n3129 VSS.n2789 0.120292
R23415 VSS.n3130 VSS.n3129 0.120292
R23416 VSS.n3131 VSS.n3130 0.120292
R23417 VSS.n3131 VSS.n2787 0.120292
R23418 VSS.n3135 VSS.n2787 0.120292
R23419 VSS.n3136 VSS.n3135 0.120292
R23420 VSS.n3137 VSS.n3136 0.120292
R23421 VSS.n3137 VSS.n2785 0.120292
R23422 VSS.n3143 VSS.n2785 0.120292
R23423 VSS.n3144 VSS.n3143 0.120292
R23424 VSS.n3144 VSS.n2784 0.120292
R23425 VSS.n2784 VSS.n2780 0.120292
R23426 VSS.n3152 VSS.n2780 0.120292
R23427 VSS.n3153 VSS.n3152 0.120292
R23428 VSS.n3154 VSS.n3153 0.120292
R23429 VSS.n3154 VSS.n2778 0.120292
R23430 VSS.n3158 VSS.n2778 0.120292
R23431 VSS.n3159 VSS.n3158 0.120292
R23432 VSS.n3160 VSS.n3159 0.120292
R23433 VSS.n3160 VSS.n2776 0.120292
R23434 VSS.n3164 VSS.n2776 0.120292
R23435 VSS.n3165 VSS.n3164 0.120292
R23436 VSS.n3166 VSS.n3165 0.120292
R23437 VSS.n3166 VSS.n2774 0.120292
R23438 VSS.n3172 VSS.n2774 0.120292
R23439 VSS.n3173 VSS.n3172 0.120292
R23440 VSS.n3173 VSS.n2773 0.120292
R23441 VSS.n2773 VSS.n2769 0.120292
R23442 VSS.n3181 VSS.n2769 0.120292
R23443 VSS.n3182 VSS.n3181 0.120292
R23444 VSS.n3183 VSS.n3182 0.120292
R23445 VSS.n3183 VSS.n2767 0.120292
R23446 VSS.n3187 VSS.n2767 0.120292
R23447 VSS.n3188 VSS.n3187 0.120292
R23448 VSS.n3189 VSS.n3188 0.120292
R23449 VSS.n3189 VSS.n2765 0.120292
R23450 VSS.n3195 VSS.n2765 0.120292
R23451 VSS.n3196 VSS.n3195 0.120292
R23452 VSS.n3196 VSS.n2764 0.120292
R23453 VSS.n2764 VSS.n2760 0.120292
R23454 VSS.n3204 VSS.n2760 0.120292
R23455 VSS.n3205 VSS.n3204 0.120292
R23456 VSS.n3206 VSS.n3205 0.120292
R23457 VSS.n3206 VSS.n2758 0.120292
R23458 VSS.n3210 VSS.n2758 0.120292
R23459 VSS.n3211 VSS.n3210 0.120292
R23460 VSS.n3212 VSS.n3211 0.120292
R23461 VSS.n3212 VSS.n2756 0.120292
R23462 VSS.n3216 VSS.n2756 0.120292
R23463 VSS.n3217 VSS.n3216 0.120292
R23464 VSS.n3218 VSS.n3217 0.120292
R23465 VSS.n3218 VSS.n2754 0.120292
R23466 VSS.n3224 VSS.n2754 0.120292
R23467 VSS.n3225 VSS.n3224 0.120292
R23468 VSS.n3225 VSS.n2753 0.120292
R23469 VSS.n2753 VSS.n2749 0.120292
R23470 VSS.n3233 VSS.n2749 0.120292
R23471 VSS.n3234 VSS.n3233 0.120292
R23472 VSS.n3235 VSS.n3234 0.120292
R23473 VSS.n3235 VSS.n2747 0.120292
R23474 VSS.n3239 VSS.n2747 0.120292
R23475 VSS.n3240 VSS.n3239 0.120292
R23476 VSS.n3241 VSS.n3240 0.120292
R23477 VSS.n3241 VSS.n2745 0.120292
R23478 VSS.n3247 VSS.n2745 0.120292
R23479 VSS.n3248 VSS.n3247 0.120292
R23480 VSS.n3248 VSS.n2744 0.120292
R23481 VSS.n2744 VSS.n2740 0.120292
R23482 VSS.n3256 VSS.n2740 0.120292
R23483 VSS.n3257 VSS.n3256 0.120292
R23484 VSS.n3258 VSS.n3257 0.120292
R23485 VSS.n3258 VSS.n2738 0.120292
R23486 VSS.n3262 VSS.n2738 0.120292
R23487 VSS.n3263 VSS.n3262 0.120292
R23488 VSS.n3264 VSS.n3263 0.120292
R23489 VSS.n3264 VSS.n2736 0.120292
R23490 VSS.n3268 VSS.n2736 0.120292
R23491 VSS.n3269 VSS.n3268 0.120292
R23492 VSS.n3270 VSS.n3269 0.120292
R23493 VSS.n3270 VSS.n2734 0.120292
R23494 VSS.n3276 VSS.n2734 0.120292
R23495 VSS.n3277 VSS.n3276 0.120292
R23496 VSS.n3277 VSS.n2733 0.120292
R23497 VSS.n2733 VSS.n2729 0.120292
R23498 VSS.n3285 VSS.n2729 0.120292
R23499 VSS.n3286 VSS.n3285 0.120292
R23500 VSS.n3287 VSS.n3286 0.120292
R23501 VSS.n3287 VSS.n2727 0.120292
R23502 VSS.n3291 VSS.n2727 0.120292
R23503 VSS.n3292 VSS.n3291 0.120292
R23504 VSS.n3293 VSS.n3292 0.120292
R23505 VSS.n3293 VSS.n2725 0.120292
R23506 VSS.n3299 VSS.n2725 0.120292
R23507 VSS.n3300 VSS.n3299 0.120292
R23508 VSS.n3300 VSS.n2724 0.120292
R23509 VSS.n2724 VSS.n2720 0.120292
R23510 VSS.n3308 VSS.n2720 0.120292
R23511 VSS.n3309 VSS.n3308 0.120292
R23512 VSS.n3310 VSS.n3309 0.120292
R23513 VSS.n3310 VSS.n2718 0.120292
R23514 VSS.n3314 VSS.n2718 0.120292
R23515 VSS.n3315 VSS.n3314 0.120292
R23516 VSS.n3316 VSS.n3315 0.120292
R23517 VSS.n3316 VSS.n2716 0.120292
R23518 VSS.n3320 VSS.n2716 0.120292
R23519 VSS.n3321 VSS.n3320 0.120292
R23520 VSS.n3322 VSS.n3321 0.120292
R23521 VSS.n3322 VSS.n2714 0.120292
R23522 VSS.n3328 VSS.n2714 0.120292
R23523 VSS.n3329 VSS.n3328 0.120292
R23524 VSS.n3329 VSS.n2713 0.120292
R23525 VSS.n2713 VSS.n2709 0.120292
R23526 VSS.n3337 VSS.n2709 0.120292
R23527 VSS.n3338 VSS.n3337 0.120292
R23528 VSS.n3339 VSS.n3338 0.120292
R23529 VSS.n3339 VSS.n2707 0.120292
R23530 VSS.n3343 VSS.n2707 0.120292
R23531 VSS.n3344 VSS.n3343 0.120292
R23532 VSS.n3345 VSS.n3344 0.120292
R23533 VSS.n3345 VSS.n2705 0.120292
R23534 VSS.n3351 VSS.n2705 0.120292
R23535 VSS.n3352 VSS.n3351 0.120292
R23536 VSS.n3352 VSS.n2704 0.120292
R23537 VSS.n2704 VSS.n2700 0.120292
R23538 VSS.n3360 VSS.n2700 0.120292
R23539 VSS.n3361 VSS.n3360 0.120292
R23540 VSS.n3362 VSS.n3361 0.120292
R23541 VSS.n3362 VSS.n2698 0.120292
R23542 VSS.n3366 VSS.n2698 0.120292
R23543 VSS.n3367 VSS.n3366 0.120292
R23544 VSS.n3368 VSS.n3367 0.120292
R23545 VSS.n3368 VSS.n2696 0.120292
R23546 VSS.n3372 VSS.n2696 0.120292
R23547 VSS.n3373 VSS.n3372 0.120292
R23548 VSS.n3374 VSS.n3373 0.120292
R23549 VSS.n3374 VSS.n2694 0.120292
R23550 VSS.n3380 VSS.n2694 0.120292
R23551 VSS.n3381 VSS.n3380 0.120292
R23552 VSS.n3381 VSS.n2693 0.120292
R23553 VSS.n2693 VSS.n2689 0.120292
R23554 VSS.n3389 VSS.n2689 0.120292
R23555 VSS.n3390 VSS.n3389 0.120292
R23556 VSS.n3391 VSS.n3390 0.120292
R23557 VSS.n3391 VSS.n2687 0.120292
R23558 VSS.n3395 VSS.n2687 0.120292
R23559 VSS.n3396 VSS.n3395 0.120292
R23560 VSS.n3397 VSS.n3396 0.120292
R23561 VSS.n3397 VSS.n2685 0.120292
R23562 VSS.n3403 VSS.n2685 0.120292
R23563 VSS.n3404 VSS.n3403 0.120292
R23564 VSS.n3404 VSS.n2684 0.120292
R23565 VSS.n2684 VSS.n2680 0.120292
R23566 VSS.n3412 VSS.n2680 0.120292
R23567 VSS.n3413 VSS.n3412 0.120292
R23568 VSS.n3414 VSS.n3413 0.120292
R23569 VSS.n3414 VSS.n2678 0.120292
R23570 VSS.n3418 VSS.n2678 0.120292
R23571 VSS.n3419 VSS.n3418 0.120292
R23572 VSS.n3419 VSS.n2677 0.120292
R23573 VSS.n3423 VSS.n2677 0.120292
R23574 VSS.n3424 VSS.n3423 0.120292
R23575 VSS.n3425 VSS.n3424 0.120292
R23576 VSS.n3425 VSS.n2676 0.120292
R23577 VSS.n2676 VSS.n2675 0.120292
R23578 VSS.n2675 VSS.n2609 0.120292
R23579 VSS.n2669 VSS.n2609 0.120292
R23580 VSS.n2669 VSS.n2668 0.120292
R23581 VSS.n2668 VSS.n2613 0.120292
R23582 VSS.n2661 VSS.n2613 0.120292
R23583 VSS.n2661 VSS.n2660 0.120292
R23584 VSS.n2660 VSS.n2659 0.120292
R23585 VSS.n2659 VSS.n2615 0.120292
R23586 VSS.n2655 VSS.n2615 0.120292
R23587 VSS.n2655 VSS.n2654 0.120292
R23588 VSS.n2654 VSS.n2616 0.120292
R23589 VSS.n2646 VSS.n2616 0.120292
R23590 VSS.n2647 VSS.n2646 0.120292
R23591 VSS.n2647 VSS.n2645 0.120292
R23592 VSS.n2645 VSS.n2644 0.120292
R23593 VSS.n2644 VSS.n2620 0.120292
R23594 VSS.n2636 VSS.n2620 0.120292
R23595 VSS.n2636 VSS.n2635 0.120292
R23596 VSS.n2635 VSS.n2634 0.120292
R23597 VSS.n2634 VSS.n2622 0.120292
R23598 VSS.n2630 VSS.n2622 0.120292
R23599 VSS.n2630 VSS.n2629 0.120292
R23600 VSS.n2629 VSS.n2623 0.120292
R23601 VSS.n2625 VSS.n2623 0.120292
R23602 VSS.n2625 VSS.n2624 0.120292
R23603 VSS.n2624 VSS.n2538 0.120292
R23604 VSS.n3431 VSS.n2538 0.120292
R23605 VSS.n3432 VSS.n3431 0.120292
R23606 VSS.n3433 VSS.n3432 0.120292
R23607 VSS.n2594 VSS.n2593 0.120292
R23608 VSS.n2594 VSS.n2582 0.120292
R23609 VSS.n2598 VSS.n2582 0.120292
R23610 VSS.n2599 VSS.n2598 0.120292
R23611 VSS.n2599 VSS.n2581 0.120292
R23612 VSS.n2603 VSS.n2581 0.120292
R23613 VSS.n2604 VSS.n2603 0.120292
R23614 VSS.n2605 VSS.n2604 0.120292
R23615 VSS.n2605 VSS.n2580 0.120292
R23616 VSS.n2580 VSS.n2579 0.120292
R23617 VSS.n2579 VSS.n2542 0.120292
R23618 VSS.n2573 VSS.n2542 0.120292
R23619 VSS.n2573 VSS.n2572 0.120292
R23620 VSS.n2572 VSS.n2546 0.120292
R23621 VSS.n2565 VSS.n2546 0.120292
R23622 VSS.n2565 VSS.n2564 0.120292
R23623 VSS.n2564 VSS.n2563 0.120292
R23624 VSS.n2563 VSS.n2548 0.120292
R23625 VSS.n2559 VSS.n2548 0.120292
R23626 VSS.n2559 VSS.n2558 0.120292
R23627 VSS.n2558 VSS.n2549 0.120292
R23628 VSS.n2554 VSS.n2549 0.120292
R23629 VSS.n2554 VSS.n2553 0.120292
R23630 VSS.n2553 VSS.n2552 0.120292
R23631 VSS.n256 VSS.n255 0.120292
R23632 VSS.n257 VSS.n256 0.120292
R23633 VSS.n257 VSS.n252 0.120292
R23634 VSS.n263 VSS.n252 0.120292
R23635 VSS.n264 VSS.n263 0.120292
R23636 VSS.n264 VSS.n251 0.120292
R23637 VSS.n251 VSS.n247 0.120292
R23638 VSS.n272 VSS.n247 0.120292
R23639 VSS.n273 VSS.n272 0.120292
R23640 VSS.n274 VSS.n273 0.120292
R23641 VSS.n274 VSS.n245 0.120292
R23642 VSS.n278 VSS.n245 0.120292
R23643 VSS.n279 VSS.n278 0.120292
R23644 VSS.n279 VSS.n244 0.120292
R23645 VSS.n283 VSS.n244 0.120292
R23646 VSS.n284 VSS.n283 0.120292
R23647 VSS.n285 VSS.n284 0.120292
R23648 VSS.n285 VSS.n243 0.120292
R23649 VSS.n288 VSS.n243 0.120292
R23650 VSS.n290 VSS.n241 0.120292
R23651 VSS.n294 VSS.n241 0.120292
R23652 VSS.n295 VSS.n294 0.120292
R23653 VSS.n296 VSS.n295 0.120292
R23654 VSS.n15253 VSS.n296 0.120292
R23655 VSS.n15253 VSS.n15252 0.120292
R23656 VSS.n15252 VSS.n297 0.120292
R23657 VSS.n15246 VSS.n297 0.120292
R23658 VSS.n15246 VSS.n15245 0.120292
R23659 VSS.n657 VSS.n656 0.120292
R23660 VSS.n657 VSS.n646 0.120292
R23661 VSS.n661 VSS.n646 0.120292
R23662 VSS.n662 VSS.n661 0.120292
R23663 VSS.n662 VSS.n645 0.120292
R23664 VSS.n669 VSS.n645 0.120292
R23665 VSS.n670 VSS.n669 0.120292
R23666 VSS.n670 VSS.n644 0.120292
R23667 VSS.n673 VSS.n644 0.120292
R23668 VSS.n674 VSS.n673 0.120292
R23669 VSS.n675 VSS.n674 0.120292
R23670 VSS.n675 VSS.n642 0.120292
R23671 VSS.n678 VSS.n642 0.120292
R23672 VSS.n679 VSS.n678 0.120292
R23673 VSS.n680 VSS.n679 0.120292
R23674 VSS.n680 VSS.n640 0.120292
R23675 VSS.n684 VSS.n640 0.120292
R23676 VSS.n685 VSS.n684 0.120292
R23677 VSS.n685 VSS.n639 0.120292
R23678 VSS.n688 VSS.n639 0.120292
R23679 VSS.n689 VSS.n688 0.120292
R23680 VSS.n690 VSS.n689 0.120292
R23681 VSS.n690 VSS.n637 0.120292
R23682 VSS.n693 VSS.n637 0.120292
R23683 VSS.n694 VSS.n693 0.120292
R23684 VSS.n694 VSS.n636 0.120292
R23685 VSS.n636 VSS.n633 0.120292
R23686 VSS.n701 VSS.n633 0.120292
R23687 VSS.n702 VSS.n701 0.120292
R23688 VSS.n703 VSS.n702 0.120292
R23689 VSS.n703 VSS.n631 0.120292
R23690 VSS.n707 VSS.n631 0.120292
R23691 VSS.n708 VSS.n707 0.120292
R23692 VSS.n709 VSS.n708 0.120292
R23693 VSS.n709 VSS.n629 0.120292
R23694 VSS.n715 VSS.n629 0.120292
R23695 VSS.n716 VSS.n715 0.120292
R23696 VSS.n716 VSS.n628 0.120292
R23697 VSS.n628 VSS.n624 0.120292
R23698 VSS.n724 VSS.n624 0.120292
R23699 VSS.n725 VSS.n724 0.120292
R23700 VSS.n726 VSS.n725 0.120292
R23701 VSS.n726 VSS.n622 0.120292
R23702 VSS.n730 VSS.n622 0.120292
R23703 VSS.n731 VSS.n730 0.120292
R23704 VSS.n732 VSS.n731 0.120292
R23705 VSS.n732 VSS.n620 0.120292
R23706 VSS.n738 VSS.n620 0.120292
R23707 VSS.n739 VSS.n738 0.120292
R23708 VSS.n739 VSS.n619 0.120292
R23709 VSS.n619 VSS.n615 0.120292
R23710 VSS.n747 VSS.n615 0.120292
R23711 VSS.n748 VSS.n747 0.120292
R23712 VSS.n749 VSS.n748 0.120292
R23713 VSS.n749 VSS.n613 0.120292
R23714 VSS.n753 VSS.n613 0.120292
R23715 VSS.n754 VSS.n753 0.120292
R23716 VSS.n755 VSS.n754 0.120292
R23717 VSS.n755 VSS.n611 0.120292
R23718 VSS.n759 VSS.n611 0.120292
R23719 VSS.n760 VSS.n759 0.120292
R23720 VSS.n761 VSS.n760 0.120292
R23721 VSS.n761 VSS.n609 0.120292
R23722 VSS.n767 VSS.n609 0.120292
R23723 VSS.n768 VSS.n767 0.120292
R23724 VSS.n768 VSS.n608 0.120292
R23725 VSS.n608 VSS.n604 0.120292
R23726 VSS.n776 VSS.n604 0.120292
R23727 VSS.n777 VSS.n776 0.120292
R23728 VSS.n778 VSS.n777 0.120292
R23729 VSS.n778 VSS.n602 0.120292
R23730 VSS.n782 VSS.n602 0.120292
R23731 VSS.n783 VSS.n782 0.120292
R23732 VSS.n784 VSS.n783 0.120292
R23733 VSS.n784 VSS.n600 0.120292
R23734 VSS.n786 VSS.n600 0.120292
R23735 VSS.n787 VSS.n786 0.120292
R23736 VSS.n788 VSS.n787 0.120292
R23737 VSS.n788 VSS.n596 0.120292
R23738 VSS.n794 VSS.n596 0.120292
R23739 VSS.n795 VSS.n794 0.120292
R23740 VSS.n796 VSS.n795 0.120292
R23741 VSS.n796 VSS.n594 0.120292
R23742 VSS.n800 VSS.n594 0.120292
R23743 VSS.n801 VSS.n800 0.120292
R23744 VSS.n801 VSS.n593 0.120292
R23745 VSS.n805 VSS.n593 0.120292
R23746 VSS.n806 VSS.n805 0.120292
R23747 VSS.n807 VSS.n806 0.120292
R23748 VSS.n875 VSS.n807 0.120292
R23749 VSS.n875 VSS.n874 0.120292
R23750 VSS.n874 VSS.n808 0.120292
R23751 VSS.n868 VSS.n808 0.120292
R23752 VSS.n868 VSS.n867 0.120292
R23753 VSS.n867 VSS.n812 0.120292
R23754 VSS.n860 VSS.n812 0.120292
R23755 VSS.n860 VSS.n859 0.120292
R23756 VSS.n859 VSS.n858 0.120292
R23757 VSS.n858 VSS.n814 0.120292
R23758 VSS.n854 VSS.n814 0.120292
R23759 VSS.n854 VSS.n853 0.120292
R23760 VSS.n853 VSS.n815 0.120292
R23761 VSS.n845 VSS.n815 0.120292
R23762 VSS.n846 VSS.n845 0.120292
R23763 VSS.n846 VSS.n844 0.120292
R23764 VSS.n844 VSS.n843 0.120292
R23765 VSS.n843 VSS.n819 0.120292
R23766 VSS.n835 VSS.n819 0.120292
R23767 VSS.n835 VSS.n834 0.120292
R23768 VSS.n834 VSS.n833 0.120292
R23769 VSS.n833 VSS.n821 0.120292
R23770 VSS.n829 VSS.n821 0.120292
R23771 VSS.n829 VSS.n828 0.120292
R23772 VSS.n828 VSS.n822 0.120292
R23773 VSS.n824 VSS.n822 0.120292
R23774 VSS.n824 VSS.n823 0.120292
R23775 VSS.n823 VSS.n590 0.120292
R23776 VSS.n882 VSS.n590 0.120292
R23777 VSS.n883 VSS.n882 0.120292
R23778 VSS.n883 VSS.n587 0.120292
R23779 VSS.n889 VSS.n587 0.120292
R23780 VSS.n890 VSS.n889 0.120292
R23781 VSS.n891 VSS.n890 0.120292
R23782 VSS.n891 VSS.n585 0.120292
R23783 VSS.n895 VSS.n585 0.120292
R23784 VSS.n896 VSS.n895 0.120292
R23785 VSS.n897 VSS.n896 0.120292
R23786 VSS.n897 VSS.n583 0.120292
R23787 VSS.n900 VSS.n583 0.120292
R23788 VSS.n901 VSS.n900 0.120292
R23789 VSS.n902 VSS.n901 0.120292
R23790 VSS.n902 VSS.n582 0.120292
R23791 VSS.n906 VSS.n582 0.120292
R23792 VSS.n907 VSS.n906 0.120292
R23793 VSS.n908 VSS.n907 0.120292
R23794 VSS.n908 VSS.n580 0.120292
R23795 VSS.n912 VSS.n580 0.120292
R23796 VSS.n913 VSS.n912 0.120292
R23797 VSS.n918 VSS.n578 0.120292
R23798 VSS.n919 VSS.n918 0.120292
R23799 VSS.n920 VSS.n919 0.120292
R23800 VSS.n987 VSS.n920 0.120292
R23801 VSS.n987 VSS.n986 0.120292
R23802 VSS.n986 VSS.n921 0.120292
R23803 VSS.n980 VSS.n921 0.120292
R23804 VSS.n980 VSS.n979 0.120292
R23805 VSS.n979 VSS.n925 0.120292
R23806 VSS.n972 VSS.n925 0.120292
R23807 VSS.n972 VSS.n971 0.120292
R23808 VSS.n971 VSS.n970 0.120292
R23809 VSS.n970 VSS.n927 0.120292
R23810 VSS.n966 VSS.n927 0.120292
R23811 VSS.n966 VSS.n965 0.120292
R23812 VSS.n965 VSS.n928 0.120292
R23813 VSS.n957 VSS.n928 0.120292
R23814 VSS.n958 VSS.n957 0.120292
R23815 VSS.n958 VSS.n956 0.120292
R23816 VSS.n956 VSS.n955 0.120292
R23817 VSS.n955 VSS.n932 0.120292
R23818 VSS.n947 VSS.n932 0.120292
R23819 VSS.n947 VSS.n946 0.120292
R23820 VSS.n946 VSS.n945 0.120292
R23821 VSS.n945 VSS.n934 0.120292
R23822 VSS.n941 VSS.n934 0.120292
R23823 VSS.n941 VSS.n940 0.120292
R23824 VSS.n940 VSS.n935 0.120292
R23825 VSS.n936 VSS.n935 0.120292
R23826 VSS.n936 VSS.n575 0.120292
R23827 VSS.n993 VSS.n575 0.120292
R23828 VSS.n995 VSS.n573 0.120292
R23829 VSS.n999 VSS.n573 0.120292
R23830 VSS.n1000 VSS.n999 0.120292
R23831 VSS.n1001 VSS.n1000 0.120292
R23832 VSS.n1001 VSS.n571 0.120292
R23833 VSS.n1004 VSS.n571 0.120292
R23834 VSS.n1005 VSS.n1004 0.120292
R23835 VSS.n1006 VSS.n1005 0.120292
R23836 VSS.n1006 VSS.n569 0.120292
R23837 VSS.n1009 VSS.n569 0.120292
R23838 VSS.n1010 VSS.n1009 0.120292
R23839 VSS.n1011 VSS.n1010 0.120292
R23840 VSS.n1011 VSS.n568 0.120292
R23841 VSS.n1017 VSS.n568 0.120292
R23842 VSS.n1018 VSS.n1017 0.120292
R23843 VSS.n1018 VSS.n567 0.120292
R23844 VSS.n567 VSS.n563 0.120292
R23845 VSS.n1026 VSS.n563 0.120292
R23846 VSS.n1027 VSS.n1026 0.120292
R23847 VSS.n1028 VSS.n1027 0.120292
R23848 VSS.n1028 VSS.n561 0.120292
R23849 VSS.n1032 VSS.n561 0.120292
R23850 VSS.n1033 VSS.n1032 0.120292
R23851 VSS.n1034 VSS.n1033 0.120292
R23852 VSS.n1102 VSS.n1034 0.120292
R23853 VSS.n1102 VSS.n1101 0.120292
R23854 VSS.n1101 VSS.n1035 0.120292
R23855 VSS.n1095 VSS.n1035 0.120292
R23856 VSS.n1095 VSS.n1094 0.120292
R23857 VSS.n1094 VSS.n1039 0.120292
R23858 VSS.n1087 VSS.n1039 0.120292
R23859 VSS.n1087 VSS.n1086 0.120292
R23860 VSS.n1086 VSS.n1085 0.120292
R23861 VSS.n1085 VSS.n1041 0.120292
R23862 VSS.n1081 VSS.n1041 0.120292
R23863 VSS.n1081 VSS.n1080 0.120292
R23864 VSS.n1080 VSS.n1042 0.120292
R23865 VSS.n1072 VSS.n1042 0.120292
R23866 VSS.n1073 VSS.n1072 0.120292
R23867 VSS.n1073 VSS.n1071 0.120292
R23868 VSS.n1071 VSS.n1070 0.120292
R23869 VSS.n1070 VSS.n1046 0.120292
R23870 VSS.n1062 VSS.n1046 0.120292
R23871 VSS.n1062 VSS.n1061 0.120292
R23872 VSS.n1061 VSS.n1060 0.120292
R23873 VSS.n1060 VSS.n1048 0.120292
R23874 VSS.n1056 VSS.n1048 0.120292
R23875 VSS.n1056 VSS.n1055 0.120292
R23876 VSS.n1055 VSS.n1049 0.120292
R23877 VSS.n1051 VSS.n1049 0.120292
R23878 VSS.n1051 VSS.n1050 0.120292
R23879 VSS.n1050 VSS.n557 0.120292
R23880 VSS.n1109 VSS.n557 0.120292
R23881 VSS.n1110 VSS.n1109 0.120292
R23882 VSS.n1111 VSS.n1110 0.120292
R23883 VSS.n1111 VSS.n555 0.120292
R23884 VSS.n1114 VSS.n555 0.120292
R23885 VSS.n1115 VSS.n1114 0.120292
R23886 VSS.n1116 VSS.n1115 0.120292
R23887 VSS.n1116 VSS.n553 0.120292
R23888 VSS.n1119 VSS.n553 0.120292
R23889 VSS.n1120 VSS.n1119 0.120292
R23890 VSS.n1121 VSS.n1120 0.120292
R23891 VSS.n1121 VSS.n552 0.120292
R23892 VSS.n1125 VSS.n552 0.120292
R23893 VSS.n1126 VSS.n1125 0.120292
R23894 VSS.n1126 VSS.n551 0.120292
R23895 VSS.n1130 VSS.n551 0.120292
R23896 VSS.n1131 VSS.n1130 0.120292
R23897 VSS.n1132 VSS.n1131 0.120292
R23898 VSS.n1132 VSS.n550 0.120292
R23899 VSS.n1136 VSS.n550 0.120292
R23900 VSS.n1137 VSS.n1136 0.120292
R23901 VSS.n1138 VSS.n1137 0.120292
R23902 VSS.n1138 VSS.n548 0.120292
R23903 VSS.n1141 VSS.n548 0.120292
R23904 VSS.n1142 VSS.n1141 0.120292
R23905 VSS.n1142 VSS.n547 0.120292
R23906 VSS.n1146 VSS.n547 0.120292
R23907 VSS.n1147 VSS.n1146 0.120292
R23908 VSS.n1148 VSS.n1147 0.120292
R23909 VSS.n1148 VSS.n545 0.120292
R23910 VSS.n1154 VSS.n545 0.120292
R23911 VSS.n1155 VSS.n1154 0.120292
R23912 VSS.n1155 VSS.n544 0.120292
R23913 VSS.n544 VSS.n540 0.120292
R23914 VSS.n1163 VSS.n540 0.120292
R23915 VSS.n1164 VSS.n1163 0.120292
R23916 VSS.n1165 VSS.n1164 0.120292
R23917 VSS.n1165 VSS.n538 0.120292
R23918 VSS.n1169 VSS.n538 0.120292
R23919 VSS.n1170 VSS.n1169 0.120292
R23920 VSS.n1171 VSS.n1170 0.120292
R23921 VSS.n1171 VSS.n536 0.120292
R23922 VSS.n1177 VSS.n536 0.120292
R23923 VSS.n1178 VSS.n1177 0.120292
R23924 VSS.n1178 VSS.n535 0.120292
R23925 VSS.n535 VSS.n531 0.120292
R23926 VSS.n1186 VSS.n531 0.120292
R23927 VSS.n1187 VSS.n1186 0.120292
R23928 VSS.n1188 VSS.n1187 0.120292
R23929 VSS.n1188 VSS.n529 0.120292
R23930 VSS.n1192 VSS.n529 0.120292
R23931 VSS.n1193 VSS.n1192 0.120292
R23932 VSS.n1193 VSS.n528 0.120292
R23933 VSS.n1197 VSS.n528 0.120292
R23934 VSS.n1198 VSS.n1197 0.120292
R23935 VSS.n1199 VSS.n1198 0.120292
R23936 VSS.n1253 VSS.n1199 0.120292
R23937 VSS.n1253 VSS.n1252 0.120292
R23938 VSS.n1252 VSS.n1200 0.120292
R23939 VSS.n1248 VSS.n1200 0.120292
R23940 VSS.n1248 VSS.n1247 0.120292
R23941 VSS.n1247 VSS.n1246 0.120292
R23942 VSS.n1246 VSS.n1202 0.120292
R23943 VSS.n1203 VSS.n1202 0.120292
R23944 VSS.n1243 VSS.n1203 0.120292
R23945 VSS.n1243 VSS.n1242 0.120292
R23946 VSS.n1242 VSS.n1204 0.120292
R23947 VSS.n1236 VSS.n1204 0.120292
R23948 VSS.n1236 VSS.n1235 0.120292
R23949 VSS.n1235 VSS.n1208 0.120292
R23950 VSS.n1228 VSS.n1208 0.120292
R23951 VSS.n1228 VSS.n1227 0.120292
R23952 VSS.n1227 VSS.n1226 0.120292
R23953 VSS.n1226 VSS.n1210 0.120292
R23954 VSS.n1222 VSS.n1210 0.120292
R23955 VSS.n1222 VSS.n1221 0.120292
R23956 VSS.n1217 VSS.n1216 0.120292
R23957 VSS.n1216 VSS.n1215 0.120292
R23958 VSS.n1215 VSS.n1213 0.120292
R23959 VSS.n1213 VSS.n464 0.120292
R23960 VSS.n1260 VSS.n464 0.120292
R23961 VSS.n1261 VSS.n1260 0.120292
R23962 VSS.n1262 VSS.n1261 0.120292
R23963 VSS.n514 VSS.n513 0.120292
R23964 VSS.n514 VSS.n502 0.120292
R23965 VSS.n518 VSS.n502 0.120292
R23966 VSS.n519 VSS.n518 0.120292
R23967 VSS.n519 VSS.n501 0.120292
R23968 VSS.n523 VSS.n501 0.120292
R23969 VSS.n524 VSS.n523 0.120292
R23970 VSS.n525 VSS.n524 0.120292
R23971 VSS.n525 VSS.n500 0.120292
R23972 VSS.n500 VSS.n499 0.120292
R23973 VSS.n499 VSS.n468 0.120292
R23974 VSS.n469 VSS.n468 0.120292
R23975 VSS.n495 VSS.n469 0.120292
R23976 VSS.n495 VSS.n494 0.120292
R23977 VSS.n494 VSS.n493 0.120292
R23978 VSS.n493 VSS.n470 0.120292
R23979 VSS.n487 VSS.n470 0.120292
R23980 VSS.n487 VSS.n486 0.120292
R23981 VSS.n486 VSS.n473 0.120292
R23982 VSS.n482 VSS.n473 0.120292
R23983 VSS.n482 VSS.n481 0.120292
R23984 VSS.n481 VSS.n480 0.120292
R23985 VSS.n480 VSS.n475 0.120292
R23986 VSS.n476 VSS.n475 0.120292
R23987 VSS.n3757 VSS.n3756 0.120292
R23988 VSS.n3757 VSS.n127 0.120292
R23989 VSS.n3767 VSS.n3749 0.120292
R23990 VSS.n3775 VSS.n3749 0.120292
R23991 VSS.n3776 VSS.n3775 0.120292
R23992 VSS.n3776 VSS.n3747 0.120292
R23993 VSS.n3780 VSS.n3747 0.120292
R23994 VSS.n3745 VSS.n3743 0.120292
R23995 VSS.n3787 VSS.n3743 0.120292
R23996 VSS.n3788 VSS.n3787 0.120292
R23997 VSS.n3789 VSS.n3788 0.120292
R23998 VSS.n3789 VSS.n3740 0.120292
R23999 VSS.n3799 VSS.n3798 0.120292
R24000 VSS.n3800 VSS.n3799 0.120292
R24001 VSS.n3800 VSS.n3737 0.120292
R24002 VSS.n3808 VSS.n3807 0.120292
R24003 VSS.n3809 VSS.n3808 0.120292
R24004 VSS.n3809 VSS.n3735 0.120292
R24005 VSS.n3814 VSS.n3734 0.120292
R24006 VSS.n3734 VSS.n3725 0.120292
R24007 VSS.n3820 VSS.n3725 0.120292
R24008 VSS.n3821 VSS.n3820 0.120292
R24009 VSS.n3821 VSS.n3724 0.120292
R24010 VSS.n3724 VSS.n3719 0.120292
R24011 VSS.n3826 VSS.n3719 0.120292
R24012 VSS.n3827 VSS.n3826 0.120292
R24013 VSS.n3828 VSS.n3827 0.120292
R24014 VSS.n3828 VSS.n3717 0.120292
R24015 VSS.n3832 VSS.n3717 0.120292
R24016 VSS.n3833 VSS.n3832 0.120292
R24017 VSS.n3833 VSS.n3715 0.120292
R24018 VSS.n3839 VSS.n3715 0.120292
R24019 VSS.n3840 VSS.n3839 0.120292
R24020 VSS.n3840 VSS.n3710 0.120292
R24021 VSS.n3847 VSS.n3710 0.120292
R24022 VSS.n3848 VSS.n3847 0.120292
R24023 VSS.n3848 VSS.n3705 0.120292
R24024 VSS.n3856 VSS.n3705 0.120292
R24025 VSS.n3857 VSS.n3856 0.120292
R24026 VSS.n3858 VSS.n3857 0.120292
R24027 VSS.n3858 VSS.n3703 0.120292
R24028 VSS.n3862 VSS.n3703 0.120292
R24029 VSS.n3863 VSS.n3862 0.120292
R24030 VSS.n3864 VSS.n3863 0.120292
R24031 VSS.n3864 VSS.n3702 0.120292
R24032 VSS.n3875 VSS.n3874 0.120292
R24033 VSS.n3875 VSS.n3698 0.120292
R24034 VSS.n3698 VSS.n3694 0.120292
R24035 VSS.n3883 VSS.n3694 0.120292
R24036 VSS.n3884 VSS.n3883 0.120292
R24037 VSS.n3895 VSS.n3894 0.120292
R24038 VSS.n3896 VSS.n3895 0.120292
R24039 VSS.n3896 VSS.n3687 0.120292
R24040 VSS.n3904 VSS.n3687 0.120292
R24041 VSS.n3905 VSS.n3904 0.120292
R24042 VSS.n3906 VSS.n3905 0.120292
R24043 VSS.n3906 VSS.n3685 0.120292
R24044 VSS.n3910 VSS.n3685 0.120292
R24045 VSS.n3911 VSS.n3910 0.120292
R24046 VSS.n3911 VSS.n3684 0.120292
R24047 VSS.n3914 VSS.n3684 0.120292
R24048 VSS.n3915 VSS.n3914 0.120292
R24049 VSS.n3915 VSS.n3683 0.120292
R24050 VSS.n3683 VSS.n3675 0.120292
R24051 VSS.n3921 VSS.n3675 0.120292
R24052 VSS.n3922 VSS.n3921 0.120292
R24053 VSS.n3922 VSS.n3674 0.120292
R24054 VSS.n3674 VSS.n3669 0.120292
R24055 VSS.n3927 VSS.n3669 0.120292
R24056 VSS.n3928 VSS.n3927 0.120292
R24057 VSS.n3929 VSS.n3928 0.120292
R24058 VSS.n3929 VSS.n3667 0.120292
R24059 VSS.n3933 VSS.n3667 0.120292
R24060 VSS.n3934 VSS.n3933 0.120292
R24061 VSS.n3934 VSS.n3665 0.120292
R24062 VSS.n3940 VSS.n3665 0.120292
R24063 VSS.n3941 VSS.n3940 0.120292
R24064 VSS.n3941 VSS.n3660 0.120292
R24065 VSS.n3948 VSS.n3660 0.120292
R24066 VSS.n3949 VSS.n3948 0.120292
R24067 VSS.n3949 VSS.n3655 0.120292
R24068 VSS.n3957 VSS.n3655 0.120292
R24069 VSS.n3958 VSS.n3957 0.120292
R24070 VSS.n3959 VSS.n3958 0.120292
R24071 VSS.n3959 VSS.n3653 0.120292
R24072 VSS.n3963 VSS.n3653 0.120292
R24073 VSS.n3964 VSS.n3963 0.120292
R24074 VSS.n3965 VSS.n3964 0.120292
R24075 VSS.n3965 VSS.n3652 0.120292
R24076 VSS.n3976 VSS.n3975 0.120292
R24077 VSS.n3976 VSS.n3648 0.120292
R24078 VSS.n3648 VSS.n3644 0.120292
R24079 VSS.n3984 VSS.n3644 0.120292
R24080 VSS.n3985 VSS.n3984 0.120292
R24081 VSS.n3996 VSS.n3995 0.120292
R24082 VSS.n3997 VSS.n3996 0.120292
R24083 VSS.n3997 VSS.n3637 0.120292
R24084 VSS.n4005 VSS.n3637 0.120292
R24085 VSS.n4006 VSS.n4005 0.120292
R24086 VSS.n4007 VSS.n4006 0.120292
R24087 VSS.n4007 VSS.n3635 0.120292
R24088 VSS.n4011 VSS.n3635 0.120292
R24089 VSS.n4012 VSS.n4011 0.120292
R24090 VSS.n4012 VSS.n3634 0.120292
R24091 VSS.n4015 VSS.n3634 0.120292
R24092 VSS.n4016 VSS.n4015 0.120292
R24093 VSS.n4016 VSS.n3633 0.120292
R24094 VSS.n3633 VSS.n3625 0.120292
R24095 VSS.n4022 VSS.n3625 0.120292
R24096 VSS.n4023 VSS.n4022 0.120292
R24097 VSS.n4023 VSS.n3624 0.120292
R24098 VSS.n3624 VSS.n3619 0.120292
R24099 VSS.n4028 VSS.n3619 0.120292
R24100 VSS.n4029 VSS.n4028 0.120292
R24101 VSS.n4030 VSS.n4029 0.120292
R24102 VSS.n4030 VSS.n3617 0.120292
R24103 VSS.n4034 VSS.n3617 0.120292
R24104 VSS.n4035 VSS.n4034 0.120292
R24105 VSS.n4035 VSS.n3615 0.120292
R24106 VSS.n4041 VSS.n3615 0.120292
R24107 VSS.n4042 VSS.n4041 0.120292
R24108 VSS.n4042 VSS.n3610 0.120292
R24109 VSS.n4049 VSS.n3610 0.120292
R24110 VSS.n4050 VSS.n4049 0.120292
R24111 VSS.n4050 VSS.n3605 0.120292
R24112 VSS.n4058 VSS.n3605 0.120292
R24113 VSS.n4059 VSS.n4058 0.120292
R24114 VSS.n4060 VSS.n4059 0.120292
R24115 VSS.n4060 VSS.n3603 0.120292
R24116 VSS.n4064 VSS.n3603 0.120292
R24117 VSS.n4065 VSS.n4064 0.120292
R24118 VSS.n4066 VSS.n4065 0.120292
R24119 VSS.n4066 VSS.n3602 0.120292
R24120 VSS.n4077 VSS.n4076 0.120292
R24121 VSS.n4077 VSS.n3598 0.120292
R24122 VSS.n3598 VSS.n3594 0.120292
R24123 VSS.n4085 VSS.n3594 0.120292
R24124 VSS.n4086 VSS.n4085 0.120292
R24125 VSS.n4097 VSS.n4096 0.120292
R24126 VSS.n4098 VSS.n4097 0.120292
R24127 VSS.n4098 VSS.n3587 0.120292
R24128 VSS.n4106 VSS.n3587 0.120292
R24129 VSS.n4107 VSS.n4106 0.120292
R24130 VSS.n4108 VSS.n4107 0.120292
R24131 VSS.n4108 VSS.n3585 0.120292
R24132 VSS.n4112 VSS.n3585 0.120292
R24133 VSS.n4113 VSS.n4112 0.120292
R24134 VSS.n4113 VSS.n3584 0.120292
R24135 VSS.n4116 VSS.n3584 0.120292
R24136 VSS.n4117 VSS.n4116 0.120292
R24137 VSS.n4117 VSS.n3583 0.120292
R24138 VSS.n3583 VSS.n3575 0.120292
R24139 VSS.n4123 VSS.n3575 0.120292
R24140 VSS.n4124 VSS.n4123 0.120292
R24141 VSS.n4124 VSS.n3574 0.120292
R24142 VSS.n3574 VSS.n3569 0.120292
R24143 VSS.n4129 VSS.n3569 0.120292
R24144 VSS.n4130 VSS.n4129 0.120292
R24145 VSS.n4131 VSS.n4130 0.120292
R24146 VSS.n4131 VSS.n3567 0.120292
R24147 VSS.n4135 VSS.n3567 0.120292
R24148 VSS.n4136 VSS.n4135 0.120292
R24149 VSS.n4136 VSS.n3565 0.120292
R24150 VSS.n4142 VSS.n3565 0.120292
R24151 VSS.n4143 VSS.n4142 0.120292
R24152 VSS.n4143 VSS.n3560 0.120292
R24153 VSS.n4150 VSS.n3560 0.120292
R24154 VSS.n4151 VSS.n4150 0.120292
R24155 VSS.n4151 VSS.n3555 0.120292
R24156 VSS.n4159 VSS.n3555 0.120292
R24157 VSS.n4160 VSS.n4159 0.120292
R24158 VSS.n4161 VSS.n4160 0.120292
R24159 VSS.n4161 VSS.n3553 0.120292
R24160 VSS.n4165 VSS.n3553 0.120292
R24161 VSS.n4166 VSS.n4165 0.120292
R24162 VSS.n4167 VSS.n4166 0.120292
R24163 VSS.n4167 VSS.n3552 0.120292
R24164 VSS.n4178 VSS.n4177 0.120292
R24165 VSS.n4178 VSS.n3548 0.120292
R24166 VSS.n3548 VSS.n3544 0.120292
R24167 VSS.n4186 VSS.n3544 0.120292
R24168 VSS.n4187 VSS.n4186 0.120292
R24169 VSS.n4198 VSS.n4197 0.120292
R24170 VSS.n4199 VSS.n4198 0.120292
R24171 VSS.n4199 VSS.n3537 0.120292
R24172 VSS.n4207 VSS.n3537 0.120292
R24173 VSS.n4208 VSS.n4207 0.120292
R24174 VSS.n4209 VSS.n4208 0.120292
R24175 VSS.n4209 VSS.n3535 0.120292
R24176 VSS.n4213 VSS.n3535 0.120292
R24177 VSS.n4214 VSS.n4213 0.120292
R24178 VSS.n4214 VSS.n3534 0.120292
R24179 VSS.n4217 VSS.n3534 0.120292
R24180 VSS.n4218 VSS.n4217 0.120292
R24181 VSS.n4218 VSS.n3533 0.120292
R24182 VSS.n3533 VSS.n3525 0.120292
R24183 VSS.n4224 VSS.n3525 0.120292
R24184 VSS.n4225 VSS.n4224 0.120292
R24185 VSS.n4225 VSS.n3524 0.120292
R24186 VSS.n3524 VSS.n3519 0.120292
R24187 VSS.n4230 VSS.n3519 0.120292
R24188 VSS.n4231 VSS.n4230 0.120292
R24189 VSS.n4232 VSS.n4231 0.120292
R24190 VSS.n4232 VSS.n3517 0.120292
R24191 VSS.n4236 VSS.n3517 0.120292
R24192 VSS.n4237 VSS.n4236 0.120292
R24193 VSS.n4237 VSS.n3515 0.120292
R24194 VSS.n4243 VSS.n3515 0.120292
R24195 VSS.n4244 VSS.n4243 0.120292
R24196 VSS.n4244 VSS.n3510 0.120292
R24197 VSS.n4251 VSS.n3510 0.120292
R24198 VSS.n4252 VSS.n4251 0.120292
R24199 VSS.n4252 VSS.n3505 0.120292
R24200 VSS.n4260 VSS.n3505 0.120292
R24201 VSS.n4261 VSS.n4260 0.120292
R24202 VSS.n4262 VSS.n4261 0.120292
R24203 VSS.n4262 VSS.n3503 0.120292
R24204 VSS.n4266 VSS.n3503 0.120292
R24205 VSS.n4267 VSS.n4266 0.120292
R24206 VSS.n4268 VSS.n4267 0.120292
R24207 VSS.n4268 VSS.n3502 0.120292
R24208 VSS.n4279 VSS.n4278 0.120292
R24209 VSS.n4279 VSS.n3498 0.120292
R24210 VSS.n3498 VSS.n3494 0.120292
R24211 VSS.n4287 VSS.n3494 0.120292
R24212 VSS.n4288 VSS.n4287 0.120292
R24213 VSS.n4299 VSS.n4298 0.120292
R24214 VSS.n4300 VSS.n4299 0.120292
R24215 VSS.n4300 VSS.n3487 0.120292
R24216 VSS.n4308 VSS.n3487 0.120292
R24217 VSS.n4309 VSS.n4308 0.120292
R24218 VSS.n4310 VSS.n4309 0.120292
R24219 VSS.n4310 VSS.n3485 0.120292
R24220 VSS.n4314 VSS.n3485 0.120292
R24221 VSS.n4315 VSS.n4314 0.120292
R24222 VSS.n4315 VSS.n3484 0.120292
R24223 VSS.n4318 VSS.n3484 0.120292
R24224 VSS.n4319 VSS.n4318 0.120292
R24225 VSS.n4319 VSS.n3483 0.120292
R24226 VSS.n3483 VSS.n3475 0.120292
R24227 VSS.n4325 VSS.n3475 0.120292
R24228 VSS.n4326 VSS.n4325 0.120292
R24229 VSS.n4326 VSS.n3474 0.120292
R24230 VSS.n3474 VSS.n3469 0.120292
R24231 VSS.n4331 VSS.n3469 0.120292
R24232 VSS.n4332 VSS.n4331 0.120292
R24233 VSS.n4333 VSS.n4332 0.120292
R24234 VSS.n4333 VSS.n3467 0.120292
R24235 VSS.n4337 VSS.n3467 0.120292
R24236 VSS.n4338 VSS.n4337 0.120292
R24237 VSS.n4338 VSS.n3465 0.120292
R24238 VSS.n4344 VSS.n3465 0.120292
R24239 VSS.n4345 VSS.n4344 0.120292
R24240 VSS.n4345 VSS.n3460 0.120292
R24241 VSS.n4352 VSS.n3460 0.120292
R24242 VSS.n4353 VSS.n4352 0.120292
R24243 VSS.n4353 VSS.n3455 0.120292
R24244 VSS.n4361 VSS.n3455 0.120292
R24245 VSS.n4362 VSS.n4361 0.120292
R24246 VSS.n4363 VSS.n4362 0.120292
R24247 VSS.n4363 VSS.n3453 0.120292
R24248 VSS.n4367 VSS.n3453 0.120292
R24249 VSS.n4368 VSS.n4367 0.120292
R24250 VSS.n4368 VSS.n3452 0.120292
R24251 VSS.n4371 VSS.n3452 0.120292
R24252 VSS.n4393 VSS.n4375 0.120292
R24253 VSS.n4385 VSS.n4375 0.120292
R24254 VSS.n4385 VSS.n4384 0.120292
R24255 VSS.n4384 VSS.n4379 0.120292
R24256 VSS.n4380 VSS.n4379 0.120292
R24257 VSS.n4448 VSS.n5 0.120292
R24258 VSS.n4448 VSS.n4447 0.120292
R24259 VSS.n4447 VSS.n4446 0.120292
R24260 VSS.n4446 VSS.n3447 0.120292
R24261 VSS.n4438 VSS.n3447 0.120292
R24262 VSS.n4439 VSS.n4438 0.120292
R24263 VSS.n4439 VSS.n4437 0.120292
R24264 VSS.n4437 VSS.n4436 0.120292
R24265 VSS.n4436 VSS.n4399 0.120292
R24266 VSS.n4424 VSS.n4399 0.120292
R24267 VSS.n4425 VSS.n4424 0.120292
R24268 VSS.n4425 VSS.n4423 0.120292
R24269 VSS.n4423 VSS.n4404 0.120292
R24270 VSS.n4416 VSS.n4404 0.120292
R24271 VSS.n4416 VSS.n4415 0.120292
R24272 VSS.n4415 VSS.n4405 0.120292
R24273 VSS.n4412 VSS.n4405 0.120292
R24274 VSS.n4412 VSS.n4411 0.120292
R24275 VSS.n4411 VSS.n4410 0.120292
R24276 VSS.n4410 VSS.n4407 0.120292
R24277 VSS.n5829 VSS.n5822 0.120292
R24278 VSS.n5830 VSS.n5829 0.120292
R24279 VSS.n5830 VSS.n5821 0.120292
R24280 VSS.n5821 VSS.n5815 0.120292
R24281 VSS.n5838 VSS.n5815 0.120292
R24282 VSS.n5839 VSS.n5838 0.120292
R24283 VSS.n5840 VSS.n5839 0.120292
R24284 VSS.n5840 VSS.n5813 0.120292
R24285 VSS.n5844 VSS.n5813 0.120292
R24286 VSS.n5845 VSS.n5844 0.120292
R24287 VSS.n5846 VSS.n5845 0.120292
R24288 VSS.n5846 VSS.n5809 0.120292
R24289 VSS.n5852 VSS.n5809 0.120292
R24290 VSS.n5853 VSS.n5852 0.120292
R24291 VSS.n5853 VSS.n5808 0.120292
R24292 VSS.n5808 VSS.n5802 0.120292
R24293 VSS.n5861 VSS.n5802 0.120292
R24294 VSS.n5862 VSS.n5861 0.120292
R24295 VSS.n5863 VSS.n5862 0.120292
R24296 VSS.n5863 VSS.n5800 0.120292
R24297 VSS.n5867 VSS.n5800 0.120292
R24298 VSS.n5868 VSS.n5867 0.120292
R24299 VSS.n5875 VSS.n5874 0.120292
R24300 VSS.n5875 VSS.n4846 0.120292
R24301 VSS.n5879 VSS.n4846 0.120292
R24302 VSS.n4861 VSS.n4860 0.120292
R24303 VSS.n4862 VSS.n4861 0.120292
R24304 VSS.n4862 VSS.n4855 0.120292
R24305 VSS.n4867 VSS.n4852 0.120292
R24306 VSS.n5794 VSS.n4852 0.120292
R24307 VSS.n5795 VSS.n5794 0.120292
R24308 VSS.n5795 VSS.n4851 0.120292
R24309 VSS.n5782 VSS.n4851 0.120292
R24310 VSS.n5783 VSS.n5782 0.120292
R24311 VSS.n5783 VSS.n5781 0.120292
R24312 VSS.n5781 VSS.n5780 0.120292
R24313 VSS.n5780 VSS.n4871 0.120292
R24314 VSS.n5775 VSS.n4871 0.120292
R24315 VSS.n5775 VSS.n5774 0.120292
R24316 VSS.n5774 VSS.n4872 0.120292
R24317 VSS.n5770 VSS.n4872 0.120292
R24318 VSS.n5770 VSS.n5769 0.120292
R24319 VSS.n5769 VSS.n5768 0.120292
R24320 VSS.n5768 VSS.n4876 0.120292
R24321 VSS.n5755 VSS.n4876 0.120292
R24322 VSS.n5756 VSS.n5755 0.120292
R24323 VSS.n5756 VSS.n5754 0.120292
R24324 VSS.n5754 VSS.n4881 0.120292
R24325 VSS.n5746 VSS.n4881 0.120292
R24326 VSS.n5746 VSS.n5745 0.120292
R24327 VSS.n5745 VSS.n5744 0.120292
R24328 VSS.n5744 VSS.n4884 0.120292
R24329 VSS.n5741 VSS.n4884 0.120292
R24330 VSS.n5741 VSS.n5740 0.120292
R24331 VSS.n5740 VSS.n5739 0.120292
R24332 VSS.n5734 VSS.n4890 0.120292
R24333 VSS.n5726 VSS.n4890 0.120292
R24334 VSS.n5726 VSS.n5725 0.120292
R24335 VSS.n5725 VSS.n4894 0.120292
R24336 VSS.n5721 VSS.n4894 0.120292
R24337 VSS.n5719 VSS.n4896 0.120292
R24338 VSS.n5710 VSS.n4896 0.120292
R24339 VSS.n5710 VSS.n5709 0.120292
R24340 VSS.n5709 VSS.n5708 0.120292
R24341 VSS.n5708 VSS.n4903 0.120292
R24342 VSS.n5700 VSS.n4903 0.120292
R24343 VSS.n5700 VSS.n5699 0.120292
R24344 VSS.n5699 VSS.n4904 0.120292
R24345 VSS.n5696 VSS.n4904 0.120292
R24346 VSS.n5696 VSS.n5695 0.120292
R24347 VSS.n5695 VSS.n5694 0.120292
R24348 VSS.n5694 VSS.n4906 0.120292
R24349 VSS.n5686 VSS.n4906 0.120292
R24350 VSS.n5687 VSS.n5686 0.120292
R24351 VSS.n5687 VSS.n5685 0.120292
R24352 VSS.n5685 VSS.n5684 0.120292
R24353 VSS.n5684 VSS.n4911 0.120292
R24354 VSS.n5676 VSS.n4911 0.120292
R24355 VSS.n5676 VSS.n5675 0.120292
R24356 VSS.n5675 VSS.n5674 0.120292
R24357 VSS.n5674 VSS.n4913 0.120292
R24358 VSS.n5669 VSS.n4913 0.120292
R24359 VSS.n5669 VSS.n5668 0.120292
R24360 VSS.n5668 VSS.n4914 0.120292
R24361 VSS.n5664 VSS.n4914 0.120292
R24362 VSS.n5664 VSS.n5663 0.120292
R24363 VSS.n5663 VSS.n5662 0.120292
R24364 VSS.n5662 VSS.n4918 0.120292
R24365 VSS.n5649 VSS.n4918 0.120292
R24366 VSS.n5650 VSS.n5649 0.120292
R24367 VSS.n5650 VSS.n5648 0.120292
R24368 VSS.n5648 VSS.n4923 0.120292
R24369 VSS.n5640 VSS.n4923 0.120292
R24370 VSS.n5640 VSS.n5639 0.120292
R24371 VSS.n5639 VSS.n5638 0.120292
R24372 VSS.n5638 VSS.n4926 0.120292
R24373 VSS.n5635 VSS.n4926 0.120292
R24374 VSS.n5635 VSS.n5634 0.120292
R24375 VSS.n5634 VSS.n5633 0.120292
R24376 VSS.n5628 VSS.n4932 0.120292
R24377 VSS.n5620 VSS.n4932 0.120292
R24378 VSS.n5620 VSS.n5619 0.120292
R24379 VSS.n5619 VSS.n4936 0.120292
R24380 VSS.n5615 VSS.n4936 0.120292
R24381 VSS.n5613 VSS.n4938 0.120292
R24382 VSS.n5604 VSS.n4938 0.120292
R24383 VSS.n5604 VSS.n5603 0.120292
R24384 VSS.n5603 VSS.n5602 0.120292
R24385 VSS.n5602 VSS.n4945 0.120292
R24386 VSS.n5594 VSS.n4945 0.120292
R24387 VSS.n5594 VSS.n5593 0.120292
R24388 VSS.n5593 VSS.n4946 0.120292
R24389 VSS.n5590 VSS.n4946 0.120292
R24390 VSS.n5590 VSS.n5589 0.120292
R24391 VSS.n5589 VSS.n5588 0.120292
R24392 VSS.n5588 VSS.n4948 0.120292
R24393 VSS.n5580 VSS.n4948 0.120292
R24394 VSS.n5581 VSS.n5580 0.120292
R24395 VSS.n5581 VSS.n5579 0.120292
R24396 VSS.n5579 VSS.n5578 0.120292
R24397 VSS.n5578 VSS.n4953 0.120292
R24398 VSS.n5570 VSS.n4953 0.120292
R24399 VSS.n5570 VSS.n5569 0.120292
R24400 VSS.n5569 VSS.n5568 0.120292
R24401 VSS.n5568 VSS.n4955 0.120292
R24402 VSS.n5563 VSS.n4955 0.120292
R24403 VSS.n5563 VSS.n5562 0.120292
R24404 VSS.n5562 VSS.n4956 0.120292
R24405 VSS.n5558 VSS.n4956 0.120292
R24406 VSS.n5558 VSS.n5557 0.120292
R24407 VSS.n5557 VSS.n5556 0.120292
R24408 VSS.n5556 VSS.n4960 0.120292
R24409 VSS.n5543 VSS.n4960 0.120292
R24410 VSS.n5544 VSS.n5543 0.120292
R24411 VSS.n5544 VSS.n5542 0.120292
R24412 VSS.n5542 VSS.n4965 0.120292
R24413 VSS.n5534 VSS.n4965 0.120292
R24414 VSS.n5534 VSS.n5533 0.120292
R24415 VSS.n5533 VSS.n5532 0.120292
R24416 VSS.n5532 VSS.n4968 0.120292
R24417 VSS.n5529 VSS.n4968 0.120292
R24418 VSS.n5529 VSS.n5528 0.120292
R24419 VSS.n5528 VSS.n5527 0.120292
R24420 VSS.n5522 VSS.n4974 0.120292
R24421 VSS.n5514 VSS.n4974 0.120292
R24422 VSS.n5514 VSS.n5513 0.120292
R24423 VSS.n5513 VSS.n4978 0.120292
R24424 VSS.n5509 VSS.n4978 0.120292
R24425 VSS.n5507 VSS.n4980 0.120292
R24426 VSS.n5498 VSS.n4980 0.120292
R24427 VSS.n5498 VSS.n5497 0.120292
R24428 VSS.n5497 VSS.n5496 0.120292
R24429 VSS.n5496 VSS.n4987 0.120292
R24430 VSS.n5488 VSS.n4987 0.120292
R24431 VSS.n5488 VSS.n5487 0.120292
R24432 VSS.n5487 VSS.n4988 0.120292
R24433 VSS.n5484 VSS.n4988 0.120292
R24434 VSS.n5484 VSS.n5483 0.120292
R24435 VSS.n5483 VSS.n5482 0.120292
R24436 VSS.n5482 VSS.n4990 0.120292
R24437 VSS.n5474 VSS.n4990 0.120292
R24438 VSS.n5475 VSS.n5474 0.120292
R24439 VSS.n5475 VSS.n5473 0.120292
R24440 VSS.n5473 VSS.n5472 0.120292
R24441 VSS.n5472 VSS.n4995 0.120292
R24442 VSS.n5464 VSS.n4995 0.120292
R24443 VSS.n5464 VSS.n5463 0.120292
R24444 VSS.n5463 VSS.n5462 0.120292
R24445 VSS.n5462 VSS.n4997 0.120292
R24446 VSS.n5457 VSS.n4997 0.120292
R24447 VSS.n5457 VSS.n5456 0.120292
R24448 VSS.n5456 VSS.n4998 0.120292
R24449 VSS.n5452 VSS.n4998 0.120292
R24450 VSS.n5452 VSS.n5451 0.120292
R24451 VSS.n5451 VSS.n5450 0.120292
R24452 VSS.n5450 VSS.n5002 0.120292
R24453 VSS.n5437 VSS.n5002 0.120292
R24454 VSS.n5438 VSS.n5437 0.120292
R24455 VSS.n5438 VSS.n5436 0.120292
R24456 VSS.n5436 VSS.n5007 0.120292
R24457 VSS.n5428 VSS.n5007 0.120292
R24458 VSS.n5428 VSS.n5427 0.120292
R24459 VSS.n5427 VSS.n5426 0.120292
R24460 VSS.n5426 VSS.n5010 0.120292
R24461 VSS.n5423 VSS.n5010 0.120292
R24462 VSS.n5423 VSS.n5422 0.120292
R24463 VSS.n5422 VSS.n5421 0.120292
R24464 VSS.n5416 VSS.n5016 0.120292
R24465 VSS.n5408 VSS.n5016 0.120292
R24466 VSS.n5408 VSS.n5407 0.120292
R24467 VSS.n5407 VSS.n5020 0.120292
R24468 VSS.n5403 VSS.n5020 0.120292
R24469 VSS.n5401 VSS.n5022 0.120292
R24470 VSS.n5392 VSS.n5022 0.120292
R24471 VSS.n5392 VSS.n5391 0.120292
R24472 VSS.n5391 VSS.n5390 0.120292
R24473 VSS.n5390 VSS.n5029 0.120292
R24474 VSS.n5382 VSS.n5029 0.120292
R24475 VSS.n5382 VSS.n5381 0.120292
R24476 VSS.n5381 VSS.n5030 0.120292
R24477 VSS.n5378 VSS.n5030 0.120292
R24478 VSS.n5378 VSS.n5377 0.120292
R24479 VSS.n5377 VSS.n5376 0.120292
R24480 VSS.n5376 VSS.n5032 0.120292
R24481 VSS.n5368 VSS.n5032 0.120292
R24482 VSS.n5369 VSS.n5368 0.120292
R24483 VSS.n5369 VSS.n5367 0.120292
R24484 VSS.n5367 VSS.n5366 0.120292
R24485 VSS.n5366 VSS.n5037 0.120292
R24486 VSS.n5358 VSS.n5037 0.120292
R24487 VSS.n5358 VSS.n5357 0.120292
R24488 VSS.n5357 VSS.n5356 0.120292
R24489 VSS.n5356 VSS.n5039 0.120292
R24490 VSS.n5351 VSS.n5039 0.120292
R24491 VSS.n5351 VSS.n5350 0.120292
R24492 VSS.n5350 VSS.n5040 0.120292
R24493 VSS.n5346 VSS.n5040 0.120292
R24494 VSS.n5346 VSS.n5345 0.120292
R24495 VSS.n5345 VSS.n5344 0.120292
R24496 VSS.n5344 VSS.n5044 0.120292
R24497 VSS.n5331 VSS.n5044 0.120292
R24498 VSS.n5332 VSS.n5331 0.120292
R24499 VSS.n5332 VSS.n5330 0.120292
R24500 VSS.n5330 VSS.n5049 0.120292
R24501 VSS.n5322 VSS.n5049 0.120292
R24502 VSS.n5322 VSS.n5321 0.120292
R24503 VSS.n5321 VSS.n5320 0.120292
R24504 VSS.n5320 VSS.n5052 0.120292
R24505 VSS.n5317 VSS.n5052 0.120292
R24506 VSS.n5317 VSS.n5316 0.120292
R24507 VSS.n5316 VSS.n5315 0.120292
R24508 VSS.n5310 VSS.n5058 0.120292
R24509 VSS.n5302 VSS.n5058 0.120292
R24510 VSS.n5302 VSS.n5301 0.120292
R24511 VSS.n5301 VSS.n5062 0.120292
R24512 VSS.n5297 VSS.n5062 0.120292
R24513 VSS.n5295 VSS.n5064 0.120292
R24514 VSS.n5286 VSS.n5064 0.120292
R24515 VSS.n5286 VSS.n5285 0.120292
R24516 VSS.n5285 VSS.n5284 0.120292
R24517 VSS.n5284 VSS.n5071 0.120292
R24518 VSS.n5276 VSS.n5071 0.120292
R24519 VSS.n5276 VSS.n5275 0.120292
R24520 VSS.n5275 VSS.n5072 0.120292
R24521 VSS.n5272 VSS.n5072 0.120292
R24522 VSS.n5272 VSS.n5271 0.120292
R24523 VSS.n5271 VSS.n5270 0.120292
R24524 VSS.n5270 VSS.n5074 0.120292
R24525 VSS.n5262 VSS.n5074 0.120292
R24526 VSS.n5263 VSS.n5262 0.120292
R24527 VSS.n5263 VSS.n5261 0.120292
R24528 VSS.n5261 VSS.n5260 0.120292
R24529 VSS.n5260 VSS.n5079 0.120292
R24530 VSS.n5252 VSS.n5079 0.120292
R24531 VSS.n5252 VSS.n5251 0.120292
R24532 VSS.n5251 VSS.n5250 0.120292
R24533 VSS.n5250 VSS.n5081 0.120292
R24534 VSS.n5245 VSS.n5081 0.120292
R24535 VSS.n5245 VSS.n5244 0.120292
R24536 VSS.n5244 VSS.n5082 0.120292
R24537 VSS.n5240 VSS.n5082 0.120292
R24538 VSS.n5240 VSS.n5239 0.120292
R24539 VSS.n5239 VSS.n5238 0.120292
R24540 VSS.n5238 VSS.n5086 0.120292
R24541 VSS.n5225 VSS.n5086 0.120292
R24542 VSS.n5226 VSS.n5225 0.120292
R24543 VSS.n5226 VSS.n5224 0.120292
R24544 VSS.n5224 VSS.n5091 0.120292
R24545 VSS.n5216 VSS.n5091 0.120292
R24546 VSS.n5216 VSS.n5215 0.120292
R24547 VSS.n5215 VSS.n5214 0.120292
R24548 VSS.n5214 VSS.n5094 0.120292
R24549 VSS.n5211 VSS.n5094 0.120292
R24550 VSS.n5211 VSS.n5210 0.120292
R24551 VSS.n5210 VSS.n5209 0.120292
R24552 VSS.n5204 VSS.n5100 0.120292
R24553 VSS.n5196 VSS.n5100 0.120292
R24554 VSS.n5196 VSS.n5195 0.120292
R24555 VSS.n5195 VSS.n5104 0.120292
R24556 VSS.n5191 VSS.n5104 0.120292
R24557 VSS.n5180 VSS.n7 0.120292
R24558 VSS.n5180 VSS.n5179 0.120292
R24559 VSS.n5179 VSS.n5178 0.120292
R24560 VSS.n5178 VSS.n5115 0.120292
R24561 VSS.n5170 VSS.n5115 0.120292
R24562 VSS.n5171 VSS.n5170 0.120292
R24563 VSS.n5171 VSS.n5169 0.120292
R24564 VSS.n5169 VSS.n5168 0.120292
R24565 VSS.n5168 VSS.n5131 0.120292
R24566 VSS.n5156 VSS.n5131 0.120292
R24567 VSS.n5157 VSS.n5156 0.120292
R24568 VSS.n5157 VSS.n5155 0.120292
R24569 VSS.n5155 VSS.n5136 0.120292
R24570 VSS.n5148 VSS.n5136 0.120292
R24571 VSS.n5148 VSS.n5147 0.120292
R24572 VSS.n5147 VSS.n5137 0.120292
R24573 VSS.n5144 VSS.n5137 0.120292
R24574 VSS.n5144 VSS.n5143 0.120292
R24575 VSS.n5143 VSS.n5142 0.120292
R24576 VSS.n5142 VSS.n5139 0.120292
R24577 VSS.n4793 VSS.n4792 0.120292
R24578 VSS.n4793 VSS.n4782 0.120292
R24579 VSS.n4801 VSS.n4782 0.120292
R24580 VSS.n4802 VSS.n4801 0.120292
R24581 VSS.n4803 VSS.n4802 0.120292
R24582 VSS.n4803 VSS.n4780 0.120292
R24583 VSS.n4807 VSS.n4780 0.120292
R24584 VSS.n4808 VSS.n4807 0.120292
R24585 VSS.n4809 VSS.n4808 0.120292
R24586 VSS.n4809 VSS.n4778 0.120292
R24587 VSS.n4813 VSS.n4778 0.120292
R24588 VSS.n4814 VSS.n4813 0.120292
R24589 VSS.n4815 VSS.n4814 0.120292
R24590 VSS.n4815 VSS.n4768 0.120292
R24591 VSS.n4823 VSS.n4768 0.120292
R24592 VSS.n4824 VSS.n4823 0.120292
R24593 VSS.n4825 VSS.n4824 0.120292
R24594 VSS.n4825 VSS.n4766 0.120292
R24595 VSS.n4829 VSS.n4766 0.120292
R24596 VSS.n4830 VSS.n4829 0.120292
R24597 VSS.n4831 VSS.n4830 0.120292
R24598 VSS.n4831 VSS.n4763 0.120292
R24599 VSS.n4841 VSS.n4840 0.120292
R24600 VSS.n4842 VSS.n4841 0.120292
R24601 VSS.n4842 VSS.n4760 0.120292
R24602 VSS.n5889 VSS.n5888 0.120292
R24603 VSS.n5890 VSS.n5889 0.120292
R24604 VSS.n5890 VSS.n4758 0.120292
R24605 VSS.n5895 VSS.n4757 0.120292
R24606 VSS.n4757 VSS.n4748 0.120292
R24607 VSS.n5901 VSS.n4748 0.120292
R24608 VSS.n5902 VSS.n5901 0.120292
R24609 VSS.n5902 VSS.n4747 0.120292
R24610 VSS.n4747 VSS.n4742 0.120292
R24611 VSS.n5907 VSS.n4742 0.120292
R24612 VSS.n5908 VSS.n5907 0.120292
R24613 VSS.n5909 VSS.n5908 0.120292
R24614 VSS.n5909 VSS.n4740 0.120292
R24615 VSS.n5913 VSS.n4740 0.120292
R24616 VSS.n5914 VSS.n5913 0.120292
R24617 VSS.n5914 VSS.n4738 0.120292
R24618 VSS.n5920 VSS.n4738 0.120292
R24619 VSS.n5921 VSS.n5920 0.120292
R24620 VSS.n5921 VSS.n4733 0.120292
R24621 VSS.n5928 VSS.n4733 0.120292
R24622 VSS.n5929 VSS.n5928 0.120292
R24623 VSS.n5929 VSS.n4728 0.120292
R24624 VSS.n5937 VSS.n4728 0.120292
R24625 VSS.n5938 VSS.n5937 0.120292
R24626 VSS.n5939 VSS.n5938 0.120292
R24627 VSS.n5939 VSS.n4726 0.120292
R24628 VSS.n5943 VSS.n4726 0.120292
R24629 VSS.n5944 VSS.n5943 0.120292
R24630 VSS.n5945 VSS.n5944 0.120292
R24631 VSS.n5945 VSS.n4725 0.120292
R24632 VSS.n5956 VSS.n5955 0.120292
R24633 VSS.n5956 VSS.n4721 0.120292
R24634 VSS.n4721 VSS.n4717 0.120292
R24635 VSS.n5964 VSS.n4717 0.120292
R24636 VSS.n5965 VSS.n5964 0.120292
R24637 VSS.n5976 VSS.n5975 0.120292
R24638 VSS.n5977 VSS.n5976 0.120292
R24639 VSS.n5977 VSS.n4710 0.120292
R24640 VSS.n5985 VSS.n4710 0.120292
R24641 VSS.n5986 VSS.n5985 0.120292
R24642 VSS.n5987 VSS.n5986 0.120292
R24643 VSS.n5987 VSS.n4708 0.120292
R24644 VSS.n5991 VSS.n4708 0.120292
R24645 VSS.n5992 VSS.n5991 0.120292
R24646 VSS.n5992 VSS.n4707 0.120292
R24647 VSS.n5995 VSS.n4707 0.120292
R24648 VSS.n5996 VSS.n5995 0.120292
R24649 VSS.n5996 VSS.n4706 0.120292
R24650 VSS.n4706 VSS.n4698 0.120292
R24651 VSS.n6002 VSS.n4698 0.120292
R24652 VSS.n6003 VSS.n6002 0.120292
R24653 VSS.n6003 VSS.n4697 0.120292
R24654 VSS.n4697 VSS.n4692 0.120292
R24655 VSS.n6008 VSS.n4692 0.120292
R24656 VSS.n6009 VSS.n6008 0.120292
R24657 VSS.n6010 VSS.n6009 0.120292
R24658 VSS.n6010 VSS.n4690 0.120292
R24659 VSS.n6014 VSS.n4690 0.120292
R24660 VSS.n6015 VSS.n6014 0.120292
R24661 VSS.n6015 VSS.n4688 0.120292
R24662 VSS.n6021 VSS.n4688 0.120292
R24663 VSS.n6022 VSS.n6021 0.120292
R24664 VSS.n6022 VSS.n4683 0.120292
R24665 VSS.n6029 VSS.n4683 0.120292
R24666 VSS.n6030 VSS.n6029 0.120292
R24667 VSS.n6030 VSS.n4678 0.120292
R24668 VSS.n6038 VSS.n4678 0.120292
R24669 VSS.n6039 VSS.n6038 0.120292
R24670 VSS.n6040 VSS.n6039 0.120292
R24671 VSS.n6040 VSS.n4676 0.120292
R24672 VSS.n6044 VSS.n4676 0.120292
R24673 VSS.n6045 VSS.n6044 0.120292
R24674 VSS.n6046 VSS.n6045 0.120292
R24675 VSS.n6046 VSS.n4675 0.120292
R24676 VSS.n6057 VSS.n6056 0.120292
R24677 VSS.n6057 VSS.n4671 0.120292
R24678 VSS.n4671 VSS.n4667 0.120292
R24679 VSS.n6065 VSS.n4667 0.120292
R24680 VSS.n6066 VSS.n6065 0.120292
R24681 VSS.n6077 VSS.n6076 0.120292
R24682 VSS.n6078 VSS.n6077 0.120292
R24683 VSS.n6078 VSS.n4660 0.120292
R24684 VSS.n6086 VSS.n4660 0.120292
R24685 VSS.n6087 VSS.n6086 0.120292
R24686 VSS.n6088 VSS.n6087 0.120292
R24687 VSS.n6088 VSS.n4658 0.120292
R24688 VSS.n6092 VSS.n4658 0.120292
R24689 VSS.n6093 VSS.n6092 0.120292
R24690 VSS.n6093 VSS.n4657 0.120292
R24691 VSS.n6096 VSS.n4657 0.120292
R24692 VSS.n6097 VSS.n6096 0.120292
R24693 VSS.n6097 VSS.n4656 0.120292
R24694 VSS.n4656 VSS.n4648 0.120292
R24695 VSS.n6103 VSS.n4648 0.120292
R24696 VSS.n6104 VSS.n6103 0.120292
R24697 VSS.n6104 VSS.n4647 0.120292
R24698 VSS.n4647 VSS.n4642 0.120292
R24699 VSS.n6109 VSS.n4642 0.120292
R24700 VSS.n6110 VSS.n6109 0.120292
R24701 VSS.n6111 VSS.n6110 0.120292
R24702 VSS.n6111 VSS.n4640 0.120292
R24703 VSS.n6115 VSS.n4640 0.120292
R24704 VSS.n6116 VSS.n6115 0.120292
R24705 VSS.n6116 VSS.n4638 0.120292
R24706 VSS.n6122 VSS.n4638 0.120292
R24707 VSS.n6123 VSS.n6122 0.120292
R24708 VSS.n6123 VSS.n4633 0.120292
R24709 VSS.n6130 VSS.n4633 0.120292
R24710 VSS.n6131 VSS.n6130 0.120292
R24711 VSS.n6131 VSS.n4628 0.120292
R24712 VSS.n6139 VSS.n4628 0.120292
R24713 VSS.n6140 VSS.n6139 0.120292
R24714 VSS.n6141 VSS.n6140 0.120292
R24715 VSS.n6141 VSS.n4626 0.120292
R24716 VSS.n6145 VSS.n4626 0.120292
R24717 VSS.n6146 VSS.n6145 0.120292
R24718 VSS.n6147 VSS.n6146 0.120292
R24719 VSS.n6147 VSS.n4625 0.120292
R24720 VSS.n6158 VSS.n6157 0.120292
R24721 VSS.n6158 VSS.n4621 0.120292
R24722 VSS.n4621 VSS.n4617 0.120292
R24723 VSS.n6166 VSS.n4617 0.120292
R24724 VSS.n6167 VSS.n6166 0.120292
R24725 VSS.n6178 VSS.n6177 0.120292
R24726 VSS.n6179 VSS.n6178 0.120292
R24727 VSS.n6179 VSS.n4610 0.120292
R24728 VSS.n6187 VSS.n4610 0.120292
R24729 VSS.n6188 VSS.n6187 0.120292
R24730 VSS.n6189 VSS.n6188 0.120292
R24731 VSS.n6189 VSS.n4608 0.120292
R24732 VSS.n6193 VSS.n4608 0.120292
R24733 VSS.n6194 VSS.n6193 0.120292
R24734 VSS.n6194 VSS.n4607 0.120292
R24735 VSS.n6197 VSS.n4607 0.120292
R24736 VSS.n6198 VSS.n6197 0.120292
R24737 VSS.n6198 VSS.n4606 0.120292
R24738 VSS.n4606 VSS.n4598 0.120292
R24739 VSS.n6204 VSS.n4598 0.120292
R24740 VSS.n6205 VSS.n6204 0.120292
R24741 VSS.n6205 VSS.n4597 0.120292
R24742 VSS.n4597 VSS.n4592 0.120292
R24743 VSS.n6210 VSS.n4592 0.120292
R24744 VSS.n6211 VSS.n6210 0.120292
R24745 VSS.n6212 VSS.n6211 0.120292
R24746 VSS.n6212 VSS.n4590 0.120292
R24747 VSS.n6216 VSS.n4590 0.120292
R24748 VSS.n6217 VSS.n6216 0.120292
R24749 VSS.n6217 VSS.n4588 0.120292
R24750 VSS.n6223 VSS.n4588 0.120292
R24751 VSS.n6224 VSS.n6223 0.120292
R24752 VSS.n6224 VSS.n4583 0.120292
R24753 VSS.n6231 VSS.n4583 0.120292
R24754 VSS.n6232 VSS.n6231 0.120292
R24755 VSS.n6232 VSS.n4578 0.120292
R24756 VSS.n6240 VSS.n4578 0.120292
R24757 VSS.n6241 VSS.n6240 0.120292
R24758 VSS.n6242 VSS.n6241 0.120292
R24759 VSS.n6242 VSS.n4576 0.120292
R24760 VSS.n6246 VSS.n4576 0.120292
R24761 VSS.n6247 VSS.n6246 0.120292
R24762 VSS.n6248 VSS.n6247 0.120292
R24763 VSS.n6248 VSS.n4575 0.120292
R24764 VSS.n6259 VSS.n6258 0.120292
R24765 VSS.n6259 VSS.n4571 0.120292
R24766 VSS.n4571 VSS.n4567 0.120292
R24767 VSS.n6267 VSS.n4567 0.120292
R24768 VSS.n6268 VSS.n6267 0.120292
R24769 VSS.n6279 VSS.n6278 0.120292
R24770 VSS.n6280 VSS.n6279 0.120292
R24771 VSS.n6280 VSS.n4560 0.120292
R24772 VSS.n6288 VSS.n4560 0.120292
R24773 VSS.n6289 VSS.n6288 0.120292
R24774 VSS.n6290 VSS.n6289 0.120292
R24775 VSS.n6290 VSS.n4558 0.120292
R24776 VSS.n6294 VSS.n4558 0.120292
R24777 VSS.n6295 VSS.n6294 0.120292
R24778 VSS.n6295 VSS.n4557 0.120292
R24779 VSS.n6298 VSS.n4557 0.120292
R24780 VSS.n6299 VSS.n6298 0.120292
R24781 VSS.n6299 VSS.n4556 0.120292
R24782 VSS.n4556 VSS.n4548 0.120292
R24783 VSS.n6305 VSS.n4548 0.120292
R24784 VSS.n6306 VSS.n6305 0.120292
R24785 VSS.n6306 VSS.n4547 0.120292
R24786 VSS.n4547 VSS.n4542 0.120292
R24787 VSS.n6311 VSS.n4542 0.120292
R24788 VSS.n6312 VSS.n6311 0.120292
R24789 VSS.n6313 VSS.n6312 0.120292
R24790 VSS.n6313 VSS.n4540 0.120292
R24791 VSS.n6317 VSS.n4540 0.120292
R24792 VSS.n6318 VSS.n6317 0.120292
R24793 VSS.n6318 VSS.n4538 0.120292
R24794 VSS.n6324 VSS.n4538 0.120292
R24795 VSS.n6325 VSS.n6324 0.120292
R24796 VSS.n6325 VSS.n4533 0.120292
R24797 VSS.n6332 VSS.n4533 0.120292
R24798 VSS.n6333 VSS.n6332 0.120292
R24799 VSS.n6333 VSS.n4528 0.120292
R24800 VSS.n6341 VSS.n4528 0.120292
R24801 VSS.n6342 VSS.n6341 0.120292
R24802 VSS.n6343 VSS.n6342 0.120292
R24803 VSS.n6343 VSS.n4526 0.120292
R24804 VSS.n6347 VSS.n4526 0.120292
R24805 VSS.n6348 VSS.n6347 0.120292
R24806 VSS.n6349 VSS.n6348 0.120292
R24807 VSS.n6349 VSS.n4525 0.120292
R24808 VSS.n6360 VSS.n6359 0.120292
R24809 VSS.n6360 VSS.n4521 0.120292
R24810 VSS.n4521 VSS.n4517 0.120292
R24811 VSS.n6368 VSS.n4517 0.120292
R24812 VSS.n6369 VSS.n6368 0.120292
R24813 VSS.n6380 VSS.n6379 0.120292
R24814 VSS.n6381 VSS.n6380 0.120292
R24815 VSS.n6381 VSS.n4510 0.120292
R24816 VSS.n6389 VSS.n4510 0.120292
R24817 VSS.n6390 VSS.n6389 0.120292
R24818 VSS.n6391 VSS.n6390 0.120292
R24819 VSS.n6391 VSS.n4508 0.120292
R24820 VSS.n6395 VSS.n4508 0.120292
R24821 VSS.n6396 VSS.n6395 0.120292
R24822 VSS.n6396 VSS.n4507 0.120292
R24823 VSS.n6399 VSS.n4507 0.120292
R24824 VSS.n6400 VSS.n6399 0.120292
R24825 VSS.n6400 VSS.n4506 0.120292
R24826 VSS.n4506 VSS.n4498 0.120292
R24827 VSS.n6406 VSS.n4498 0.120292
R24828 VSS.n6407 VSS.n6406 0.120292
R24829 VSS.n6407 VSS.n4497 0.120292
R24830 VSS.n4497 VSS.n4492 0.120292
R24831 VSS.n6412 VSS.n4492 0.120292
R24832 VSS.n6413 VSS.n6412 0.120292
R24833 VSS.n6414 VSS.n6413 0.120292
R24834 VSS.n6414 VSS.n4490 0.120292
R24835 VSS.n6418 VSS.n4490 0.120292
R24836 VSS.n6419 VSS.n6418 0.120292
R24837 VSS.n6419 VSS.n4488 0.120292
R24838 VSS.n6425 VSS.n4488 0.120292
R24839 VSS.n6426 VSS.n6425 0.120292
R24840 VSS.n6426 VSS.n4483 0.120292
R24841 VSS.n6433 VSS.n4483 0.120292
R24842 VSS.n6434 VSS.n6433 0.120292
R24843 VSS.n6434 VSS.n4478 0.120292
R24844 VSS.n6442 VSS.n4478 0.120292
R24845 VSS.n6443 VSS.n6442 0.120292
R24846 VSS.n6444 VSS.n6443 0.120292
R24847 VSS.n6444 VSS.n4476 0.120292
R24848 VSS.n6448 VSS.n4476 0.120292
R24849 VSS.n6449 VSS.n6448 0.120292
R24850 VSS.n6449 VSS.n4475 0.120292
R24851 VSS.n6452 VSS.n4475 0.120292
R24852 VSS.n6474 VSS.n6456 0.120292
R24853 VSS.n6466 VSS.n6456 0.120292
R24854 VSS.n6466 VSS.n6465 0.120292
R24855 VSS.n6465 VSS.n6460 0.120292
R24856 VSS.n6461 VSS.n6460 0.120292
R24857 VSS.n6529 VSS.n9 0.120292
R24858 VSS.n6529 VSS.n6528 0.120292
R24859 VSS.n6528 VSS.n6527 0.120292
R24860 VSS.n6527 VSS.n4470 0.120292
R24861 VSS.n6519 VSS.n4470 0.120292
R24862 VSS.n6520 VSS.n6519 0.120292
R24863 VSS.n6520 VSS.n6518 0.120292
R24864 VSS.n6518 VSS.n6517 0.120292
R24865 VSS.n6517 VSS.n6480 0.120292
R24866 VSS.n6505 VSS.n6480 0.120292
R24867 VSS.n6506 VSS.n6505 0.120292
R24868 VSS.n6506 VSS.n6504 0.120292
R24869 VSS.n6504 VSS.n6485 0.120292
R24870 VSS.n6497 VSS.n6485 0.120292
R24871 VSS.n6497 VSS.n6496 0.120292
R24872 VSS.n6496 VSS.n6486 0.120292
R24873 VSS.n6493 VSS.n6486 0.120292
R24874 VSS.n6493 VSS.n6492 0.120292
R24875 VSS.n6492 VSS.n6491 0.120292
R24876 VSS.n6491 VSS.n6488 0.120292
R24877 VSS.n6874 VSS.n6873 0.120292
R24878 VSS.n6874 VSS.n6863 0.120292
R24879 VSS.n6882 VSS.n6863 0.120292
R24880 VSS.n6883 VSS.n6882 0.120292
R24881 VSS.n6884 VSS.n6883 0.120292
R24882 VSS.n6884 VSS.n6861 0.120292
R24883 VSS.n6888 VSS.n6861 0.120292
R24884 VSS.n6889 VSS.n6888 0.120292
R24885 VSS.n6890 VSS.n6889 0.120292
R24886 VSS.n6890 VSS.n6859 0.120292
R24887 VSS.n6894 VSS.n6859 0.120292
R24888 VSS.n6895 VSS.n6894 0.120292
R24889 VSS.n6896 VSS.n6895 0.120292
R24890 VSS.n6896 VSS.n6849 0.120292
R24891 VSS.n6904 VSS.n6849 0.120292
R24892 VSS.n6905 VSS.n6904 0.120292
R24893 VSS.n6906 VSS.n6905 0.120292
R24894 VSS.n6906 VSS.n6847 0.120292
R24895 VSS.n6910 VSS.n6847 0.120292
R24896 VSS.n6911 VSS.n6910 0.120292
R24897 VSS.n6912 VSS.n6911 0.120292
R24898 VSS.n6912 VSS.n6844 0.120292
R24899 VSS.n6922 VSS.n6921 0.120292
R24900 VSS.n6923 VSS.n6922 0.120292
R24901 VSS.n6923 VSS.n6841 0.120292
R24902 VSS.n6931 VSS.n6930 0.120292
R24903 VSS.n6932 VSS.n6931 0.120292
R24904 VSS.n6932 VSS.n6839 0.120292
R24905 VSS.n6937 VSS.n6838 0.120292
R24906 VSS.n6838 VSS.n6829 0.120292
R24907 VSS.n6943 VSS.n6829 0.120292
R24908 VSS.n6944 VSS.n6943 0.120292
R24909 VSS.n6944 VSS.n6828 0.120292
R24910 VSS.n6828 VSS.n6823 0.120292
R24911 VSS.n6949 VSS.n6823 0.120292
R24912 VSS.n6950 VSS.n6949 0.120292
R24913 VSS.n6951 VSS.n6950 0.120292
R24914 VSS.n6951 VSS.n6821 0.120292
R24915 VSS.n6955 VSS.n6821 0.120292
R24916 VSS.n6956 VSS.n6955 0.120292
R24917 VSS.n6956 VSS.n6819 0.120292
R24918 VSS.n6962 VSS.n6819 0.120292
R24919 VSS.n6963 VSS.n6962 0.120292
R24920 VSS.n6963 VSS.n6814 0.120292
R24921 VSS.n6970 VSS.n6814 0.120292
R24922 VSS.n6971 VSS.n6970 0.120292
R24923 VSS.n6971 VSS.n6809 0.120292
R24924 VSS.n6979 VSS.n6809 0.120292
R24925 VSS.n6980 VSS.n6979 0.120292
R24926 VSS.n6981 VSS.n6980 0.120292
R24927 VSS.n6981 VSS.n6807 0.120292
R24928 VSS.n6985 VSS.n6807 0.120292
R24929 VSS.n6986 VSS.n6985 0.120292
R24930 VSS.n6987 VSS.n6986 0.120292
R24931 VSS.n6987 VSS.n6806 0.120292
R24932 VSS.n6998 VSS.n6997 0.120292
R24933 VSS.n6998 VSS.n6802 0.120292
R24934 VSS.n6802 VSS.n6798 0.120292
R24935 VSS.n7006 VSS.n6798 0.120292
R24936 VSS.n7007 VSS.n7006 0.120292
R24937 VSS.n7018 VSS.n7017 0.120292
R24938 VSS.n7019 VSS.n7018 0.120292
R24939 VSS.n7019 VSS.n6791 0.120292
R24940 VSS.n7027 VSS.n6791 0.120292
R24941 VSS.n7028 VSS.n7027 0.120292
R24942 VSS.n7029 VSS.n7028 0.120292
R24943 VSS.n7029 VSS.n6789 0.120292
R24944 VSS.n7033 VSS.n6789 0.120292
R24945 VSS.n7034 VSS.n7033 0.120292
R24946 VSS.n7034 VSS.n6788 0.120292
R24947 VSS.n7037 VSS.n6788 0.120292
R24948 VSS.n7038 VSS.n7037 0.120292
R24949 VSS.n7038 VSS.n6787 0.120292
R24950 VSS.n6787 VSS.n6779 0.120292
R24951 VSS.n7044 VSS.n6779 0.120292
R24952 VSS.n7045 VSS.n7044 0.120292
R24953 VSS.n7045 VSS.n6778 0.120292
R24954 VSS.n6778 VSS.n6773 0.120292
R24955 VSS.n7050 VSS.n6773 0.120292
R24956 VSS.n7051 VSS.n7050 0.120292
R24957 VSS.n7052 VSS.n7051 0.120292
R24958 VSS.n7052 VSS.n6771 0.120292
R24959 VSS.n7056 VSS.n6771 0.120292
R24960 VSS.n7057 VSS.n7056 0.120292
R24961 VSS.n7057 VSS.n6769 0.120292
R24962 VSS.n7063 VSS.n6769 0.120292
R24963 VSS.n7064 VSS.n7063 0.120292
R24964 VSS.n7064 VSS.n6764 0.120292
R24965 VSS.n7071 VSS.n6764 0.120292
R24966 VSS.n7072 VSS.n7071 0.120292
R24967 VSS.n7072 VSS.n6759 0.120292
R24968 VSS.n7080 VSS.n6759 0.120292
R24969 VSS.n7081 VSS.n7080 0.120292
R24970 VSS.n7082 VSS.n7081 0.120292
R24971 VSS.n7082 VSS.n6757 0.120292
R24972 VSS.n7086 VSS.n6757 0.120292
R24973 VSS.n7087 VSS.n7086 0.120292
R24974 VSS.n7088 VSS.n7087 0.120292
R24975 VSS.n7088 VSS.n6756 0.120292
R24976 VSS.n7099 VSS.n7098 0.120292
R24977 VSS.n7099 VSS.n6752 0.120292
R24978 VSS.n6752 VSS.n6748 0.120292
R24979 VSS.n7107 VSS.n6748 0.120292
R24980 VSS.n7108 VSS.n7107 0.120292
R24981 VSS.n7119 VSS.n7118 0.120292
R24982 VSS.n7120 VSS.n7119 0.120292
R24983 VSS.n7120 VSS.n6741 0.120292
R24984 VSS.n7128 VSS.n6741 0.120292
R24985 VSS.n7129 VSS.n7128 0.120292
R24986 VSS.n7130 VSS.n7129 0.120292
R24987 VSS.n7130 VSS.n6739 0.120292
R24988 VSS.n7134 VSS.n6739 0.120292
R24989 VSS.n7135 VSS.n7134 0.120292
R24990 VSS.n7135 VSS.n6738 0.120292
R24991 VSS.n7138 VSS.n6738 0.120292
R24992 VSS.n7139 VSS.n7138 0.120292
R24993 VSS.n7139 VSS.n6737 0.120292
R24994 VSS.n6737 VSS.n6729 0.120292
R24995 VSS.n7145 VSS.n6729 0.120292
R24996 VSS.n7146 VSS.n7145 0.120292
R24997 VSS.n7146 VSS.n6728 0.120292
R24998 VSS.n6728 VSS.n6723 0.120292
R24999 VSS.n7151 VSS.n6723 0.120292
R25000 VSS.n7152 VSS.n7151 0.120292
R25001 VSS.n7153 VSS.n7152 0.120292
R25002 VSS.n7153 VSS.n6721 0.120292
R25003 VSS.n7157 VSS.n6721 0.120292
R25004 VSS.n7158 VSS.n7157 0.120292
R25005 VSS.n7158 VSS.n6719 0.120292
R25006 VSS.n7164 VSS.n6719 0.120292
R25007 VSS.n7165 VSS.n7164 0.120292
R25008 VSS.n7165 VSS.n6714 0.120292
R25009 VSS.n7172 VSS.n6714 0.120292
R25010 VSS.n7173 VSS.n7172 0.120292
R25011 VSS.n7173 VSS.n6709 0.120292
R25012 VSS.n7181 VSS.n6709 0.120292
R25013 VSS.n7182 VSS.n7181 0.120292
R25014 VSS.n7183 VSS.n7182 0.120292
R25015 VSS.n7183 VSS.n6707 0.120292
R25016 VSS.n7187 VSS.n6707 0.120292
R25017 VSS.n7188 VSS.n7187 0.120292
R25018 VSS.n7189 VSS.n7188 0.120292
R25019 VSS.n7189 VSS.n6706 0.120292
R25020 VSS.n7200 VSS.n7199 0.120292
R25021 VSS.n7200 VSS.n6702 0.120292
R25022 VSS.n6702 VSS.n6698 0.120292
R25023 VSS.n7208 VSS.n6698 0.120292
R25024 VSS.n7209 VSS.n7208 0.120292
R25025 VSS.n7220 VSS.n7219 0.120292
R25026 VSS.n7221 VSS.n7220 0.120292
R25027 VSS.n7221 VSS.n6691 0.120292
R25028 VSS.n7229 VSS.n6691 0.120292
R25029 VSS.n7230 VSS.n7229 0.120292
R25030 VSS.n7231 VSS.n7230 0.120292
R25031 VSS.n7231 VSS.n6689 0.120292
R25032 VSS.n7235 VSS.n6689 0.120292
R25033 VSS.n7236 VSS.n7235 0.120292
R25034 VSS.n7236 VSS.n6688 0.120292
R25035 VSS.n7239 VSS.n6688 0.120292
R25036 VSS.n7240 VSS.n7239 0.120292
R25037 VSS.n7240 VSS.n6687 0.120292
R25038 VSS.n6687 VSS.n6679 0.120292
R25039 VSS.n7246 VSS.n6679 0.120292
R25040 VSS.n7247 VSS.n7246 0.120292
R25041 VSS.n7247 VSS.n6678 0.120292
R25042 VSS.n6678 VSS.n6673 0.120292
R25043 VSS.n7252 VSS.n6673 0.120292
R25044 VSS.n7253 VSS.n7252 0.120292
R25045 VSS.n7254 VSS.n7253 0.120292
R25046 VSS.n7254 VSS.n6671 0.120292
R25047 VSS.n7258 VSS.n6671 0.120292
R25048 VSS.n7259 VSS.n7258 0.120292
R25049 VSS.n7259 VSS.n6669 0.120292
R25050 VSS.n7265 VSS.n6669 0.120292
R25051 VSS.n7266 VSS.n7265 0.120292
R25052 VSS.n7266 VSS.n6664 0.120292
R25053 VSS.n7273 VSS.n6664 0.120292
R25054 VSS.n7274 VSS.n7273 0.120292
R25055 VSS.n7274 VSS.n6659 0.120292
R25056 VSS.n7282 VSS.n6659 0.120292
R25057 VSS.n7283 VSS.n7282 0.120292
R25058 VSS.n7284 VSS.n7283 0.120292
R25059 VSS.n7284 VSS.n6657 0.120292
R25060 VSS.n7288 VSS.n6657 0.120292
R25061 VSS.n7289 VSS.n7288 0.120292
R25062 VSS.n7290 VSS.n7289 0.120292
R25063 VSS.n7290 VSS.n6656 0.120292
R25064 VSS.n7301 VSS.n7300 0.120292
R25065 VSS.n7301 VSS.n6652 0.120292
R25066 VSS.n6652 VSS.n6648 0.120292
R25067 VSS.n7309 VSS.n6648 0.120292
R25068 VSS.n7310 VSS.n7309 0.120292
R25069 VSS.n7321 VSS.n7320 0.120292
R25070 VSS.n7322 VSS.n7321 0.120292
R25071 VSS.n7322 VSS.n6641 0.120292
R25072 VSS.n7330 VSS.n6641 0.120292
R25073 VSS.n7331 VSS.n7330 0.120292
R25074 VSS.n7332 VSS.n7331 0.120292
R25075 VSS.n7332 VSS.n6639 0.120292
R25076 VSS.n7336 VSS.n6639 0.120292
R25077 VSS.n7337 VSS.n7336 0.120292
R25078 VSS.n7337 VSS.n6638 0.120292
R25079 VSS.n7340 VSS.n6638 0.120292
R25080 VSS.n7341 VSS.n7340 0.120292
R25081 VSS.n7341 VSS.n6637 0.120292
R25082 VSS.n6637 VSS.n6629 0.120292
R25083 VSS.n7347 VSS.n6629 0.120292
R25084 VSS.n7348 VSS.n7347 0.120292
R25085 VSS.n7348 VSS.n6628 0.120292
R25086 VSS.n6628 VSS.n6623 0.120292
R25087 VSS.n7353 VSS.n6623 0.120292
R25088 VSS.n7354 VSS.n7353 0.120292
R25089 VSS.n7355 VSS.n7354 0.120292
R25090 VSS.n7355 VSS.n6621 0.120292
R25091 VSS.n7359 VSS.n6621 0.120292
R25092 VSS.n7360 VSS.n7359 0.120292
R25093 VSS.n7360 VSS.n6619 0.120292
R25094 VSS.n7366 VSS.n6619 0.120292
R25095 VSS.n7367 VSS.n7366 0.120292
R25096 VSS.n7367 VSS.n6614 0.120292
R25097 VSS.n7374 VSS.n6614 0.120292
R25098 VSS.n7375 VSS.n7374 0.120292
R25099 VSS.n7375 VSS.n6609 0.120292
R25100 VSS.n7383 VSS.n6609 0.120292
R25101 VSS.n7384 VSS.n7383 0.120292
R25102 VSS.n7385 VSS.n7384 0.120292
R25103 VSS.n7385 VSS.n6607 0.120292
R25104 VSS.n7389 VSS.n6607 0.120292
R25105 VSS.n7390 VSS.n7389 0.120292
R25106 VSS.n7391 VSS.n7390 0.120292
R25107 VSS.n7391 VSS.n6606 0.120292
R25108 VSS.n7402 VSS.n7401 0.120292
R25109 VSS.n7402 VSS.n6602 0.120292
R25110 VSS.n6602 VSS.n6598 0.120292
R25111 VSS.n7410 VSS.n6598 0.120292
R25112 VSS.n7411 VSS.n7410 0.120292
R25113 VSS.n7422 VSS.n7421 0.120292
R25114 VSS.n7423 VSS.n7422 0.120292
R25115 VSS.n7423 VSS.n6591 0.120292
R25116 VSS.n7431 VSS.n6591 0.120292
R25117 VSS.n7432 VSS.n7431 0.120292
R25118 VSS.n7433 VSS.n7432 0.120292
R25119 VSS.n7433 VSS.n6589 0.120292
R25120 VSS.n7437 VSS.n6589 0.120292
R25121 VSS.n7438 VSS.n7437 0.120292
R25122 VSS.n7438 VSS.n6588 0.120292
R25123 VSS.n7441 VSS.n6588 0.120292
R25124 VSS.n7442 VSS.n7441 0.120292
R25125 VSS.n7442 VSS.n6587 0.120292
R25126 VSS.n6587 VSS.n6579 0.120292
R25127 VSS.n7448 VSS.n6579 0.120292
R25128 VSS.n7449 VSS.n7448 0.120292
R25129 VSS.n7449 VSS.n6578 0.120292
R25130 VSS.n6578 VSS.n6573 0.120292
R25131 VSS.n7454 VSS.n6573 0.120292
R25132 VSS.n7455 VSS.n7454 0.120292
R25133 VSS.n7456 VSS.n7455 0.120292
R25134 VSS.n7456 VSS.n6571 0.120292
R25135 VSS.n7460 VSS.n6571 0.120292
R25136 VSS.n7461 VSS.n7460 0.120292
R25137 VSS.n7461 VSS.n6569 0.120292
R25138 VSS.n7467 VSS.n6569 0.120292
R25139 VSS.n7468 VSS.n7467 0.120292
R25140 VSS.n7468 VSS.n6564 0.120292
R25141 VSS.n7475 VSS.n6564 0.120292
R25142 VSS.n7476 VSS.n7475 0.120292
R25143 VSS.n7476 VSS.n6559 0.120292
R25144 VSS.n7484 VSS.n6559 0.120292
R25145 VSS.n7485 VSS.n7484 0.120292
R25146 VSS.n7486 VSS.n7485 0.120292
R25147 VSS.n7486 VSS.n6557 0.120292
R25148 VSS.n7490 VSS.n6557 0.120292
R25149 VSS.n7491 VSS.n7490 0.120292
R25150 VSS.n7491 VSS.n6556 0.120292
R25151 VSS.n7494 VSS.n6556 0.120292
R25152 VSS.n7516 VSS.n7498 0.120292
R25153 VSS.n7508 VSS.n7498 0.120292
R25154 VSS.n7508 VSS.n7507 0.120292
R25155 VSS.n7507 VSS.n7502 0.120292
R25156 VSS.n7503 VSS.n7502 0.120292
R25157 VSS.n7571 VSS.n11 0.120292
R25158 VSS.n7571 VSS.n7570 0.120292
R25159 VSS.n7570 VSS.n7569 0.120292
R25160 VSS.n7569 VSS.n6551 0.120292
R25161 VSS.n7561 VSS.n6551 0.120292
R25162 VSS.n7562 VSS.n7561 0.120292
R25163 VSS.n7562 VSS.n7560 0.120292
R25164 VSS.n7560 VSS.n7559 0.120292
R25165 VSS.n7559 VSS.n7522 0.120292
R25166 VSS.n7547 VSS.n7522 0.120292
R25167 VSS.n7548 VSS.n7547 0.120292
R25168 VSS.n7548 VSS.n7546 0.120292
R25169 VSS.n7546 VSS.n7527 0.120292
R25170 VSS.n7539 VSS.n7527 0.120292
R25171 VSS.n7539 VSS.n7538 0.120292
R25172 VSS.n7538 VSS.n7528 0.120292
R25173 VSS.n7535 VSS.n7528 0.120292
R25174 VSS.n7535 VSS.n7534 0.120292
R25175 VSS.n7534 VSS.n7533 0.120292
R25176 VSS.n7533 VSS.n7530 0.120292
R25177 VSS.n8311 VSS.n8304 0.120292
R25178 VSS.n8312 VSS.n8311 0.120292
R25179 VSS.n8312 VSS.n8303 0.120292
R25180 VSS.n8303 VSS.n8297 0.120292
R25181 VSS.n8320 VSS.n8297 0.120292
R25182 VSS.n8321 VSS.n8320 0.120292
R25183 VSS.n8322 VSS.n8321 0.120292
R25184 VSS.n8322 VSS.n8295 0.120292
R25185 VSS.n8326 VSS.n8295 0.120292
R25186 VSS.n8327 VSS.n8326 0.120292
R25187 VSS.n8328 VSS.n8327 0.120292
R25188 VSS.n8328 VSS.n8291 0.120292
R25189 VSS.n8334 VSS.n8291 0.120292
R25190 VSS.n8335 VSS.n8334 0.120292
R25191 VSS.n8335 VSS.n8290 0.120292
R25192 VSS.n8290 VSS.n8284 0.120292
R25193 VSS.n8343 VSS.n8284 0.120292
R25194 VSS.n8344 VSS.n8343 0.120292
R25195 VSS.n8345 VSS.n8344 0.120292
R25196 VSS.n8345 VSS.n8282 0.120292
R25197 VSS.n8349 VSS.n8282 0.120292
R25198 VSS.n8350 VSS.n8349 0.120292
R25199 VSS.n8357 VSS.n8356 0.120292
R25200 VSS.n8357 VSS.n2274 0.120292
R25201 VSS.n8361 VSS.n2274 0.120292
R25202 VSS.n2289 VSS.n2288 0.120292
R25203 VSS.n2290 VSS.n2289 0.120292
R25204 VSS.n2290 VSS.n2283 0.120292
R25205 VSS.n2295 VSS.n2280 0.120292
R25206 VSS.n8276 VSS.n2280 0.120292
R25207 VSS.n8277 VSS.n8276 0.120292
R25208 VSS.n8277 VSS.n2279 0.120292
R25209 VSS.n8264 VSS.n2279 0.120292
R25210 VSS.n8265 VSS.n8264 0.120292
R25211 VSS.n8265 VSS.n8263 0.120292
R25212 VSS.n8263 VSS.n8262 0.120292
R25213 VSS.n8262 VSS.n2299 0.120292
R25214 VSS.n8257 VSS.n2299 0.120292
R25215 VSS.n8257 VSS.n8256 0.120292
R25216 VSS.n8256 VSS.n2300 0.120292
R25217 VSS.n8252 VSS.n2300 0.120292
R25218 VSS.n8252 VSS.n8251 0.120292
R25219 VSS.n8251 VSS.n8250 0.120292
R25220 VSS.n8250 VSS.n2304 0.120292
R25221 VSS.n8237 VSS.n2304 0.120292
R25222 VSS.n8238 VSS.n8237 0.120292
R25223 VSS.n8238 VSS.n8236 0.120292
R25224 VSS.n8236 VSS.n2309 0.120292
R25225 VSS.n8228 VSS.n2309 0.120292
R25226 VSS.n8228 VSS.n8227 0.120292
R25227 VSS.n8227 VSS.n8226 0.120292
R25228 VSS.n8226 VSS.n2312 0.120292
R25229 VSS.n8223 VSS.n2312 0.120292
R25230 VSS.n8223 VSS.n8222 0.120292
R25231 VSS.n8222 VSS.n8221 0.120292
R25232 VSS.n8216 VSS.n2318 0.120292
R25233 VSS.n8208 VSS.n2318 0.120292
R25234 VSS.n8208 VSS.n8207 0.120292
R25235 VSS.n8207 VSS.n2322 0.120292
R25236 VSS.n8203 VSS.n2322 0.120292
R25237 VSS.n8201 VSS.n2324 0.120292
R25238 VSS.n8192 VSS.n2324 0.120292
R25239 VSS.n8192 VSS.n8191 0.120292
R25240 VSS.n8191 VSS.n8190 0.120292
R25241 VSS.n8190 VSS.n2331 0.120292
R25242 VSS.n8182 VSS.n2331 0.120292
R25243 VSS.n8182 VSS.n8181 0.120292
R25244 VSS.n8181 VSS.n2332 0.120292
R25245 VSS.n8178 VSS.n2332 0.120292
R25246 VSS.n8178 VSS.n8177 0.120292
R25247 VSS.n8177 VSS.n8176 0.120292
R25248 VSS.n8176 VSS.n2334 0.120292
R25249 VSS.n8168 VSS.n2334 0.120292
R25250 VSS.n8169 VSS.n8168 0.120292
R25251 VSS.n8169 VSS.n8167 0.120292
R25252 VSS.n8167 VSS.n8166 0.120292
R25253 VSS.n8166 VSS.n2339 0.120292
R25254 VSS.n8158 VSS.n2339 0.120292
R25255 VSS.n8158 VSS.n8157 0.120292
R25256 VSS.n8157 VSS.n8156 0.120292
R25257 VSS.n8156 VSS.n2341 0.120292
R25258 VSS.n8151 VSS.n2341 0.120292
R25259 VSS.n8151 VSS.n8150 0.120292
R25260 VSS.n8150 VSS.n2342 0.120292
R25261 VSS.n8146 VSS.n2342 0.120292
R25262 VSS.n8146 VSS.n8145 0.120292
R25263 VSS.n8145 VSS.n8144 0.120292
R25264 VSS.n8144 VSS.n2346 0.120292
R25265 VSS.n8131 VSS.n2346 0.120292
R25266 VSS.n8132 VSS.n8131 0.120292
R25267 VSS.n8132 VSS.n8130 0.120292
R25268 VSS.n8130 VSS.n2351 0.120292
R25269 VSS.n8122 VSS.n2351 0.120292
R25270 VSS.n8122 VSS.n8121 0.120292
R25271 VSS.n8121 VSS.n8120 0.120292
R25272 VSS.n8120 VSS.n2354 0.120292
R25273 VSS.n8117 VSS.n2354 0.120292
R25274 VSS.n8117 VSS.n8116 0.120292
R25275 VSS.n8116 VSS.n8115 0.120292
R25276 VSS.n8110 VSS.n2360 0.120292
R25277 VSS.n8102 VSS.n2360 0.120292
R25278 VSS.n8102 VSS.n8101 0.120292
R25279 VSS.n8101 VSS.n2364 0.120292
R25280 VSS.n8097 VSS.n2364 0.120292
R25281 VSS.n8095 VSS.n2366 0.120292
R25282 VSS.n8086 VSS.n2366 0.120292
R25283 VSS.n8086 VSS.n8085 0.120292
R25284 VSS.n8085 VSS.n8084 0.120292
R25285 VSS.n8084 VSS.n2373 0.120292
R25286 VSS.n8076 VSS.n2373 0.120292
R25287 VSS.n8076 VSS.n8075 0.120292
R25288 VSS.n8075 VSS.n2374 0.120292
R25289 VSS.n8072 VSS.n2374 0.120292
R25290 VSS.n8072 VSS.n8071 0.120292
R25291 VSS.n8071 VSS.n8070 0.120292
R25292 VSS.n8070 VSS.n2376 0.120292
R25293 VSS.n8062 VSS.n2376 0.120292
R25294 VSS.n8063 VSS.n8062 0.120292
R25295 VSS.n8063 VSS.n8061 0.120292
R25296 VSS.n8061 VSS.n8060 0.120292
R25297 VSS.n8060 VSS.n2381 0.120292
R25298 VSS.n8052 VSS.n2381 0.120292
R25299 VSS.n8052 VSS.n8051 0.120292
R25300 VSS.n8051 VSS.n8050 0.120292
R25301 VSS.n8050 VSS.n2383 0.120292
R25302 VSS.n8045 VSS.n2383 0.120292
R25303 VSS.n8045 VSS.n8044 0.120292
R25304 VSS.n8044 VSS.n2384 0.120292
R25305 VSS.n8040 VSS.n2384 0.120292
R25306 VSS.n8040 VSS.n8039 0.120292
R25307 VSS.n8039 VSS.n8038 0.120292
R25308 VSS.n8038 VSS.n2388 0.120292
R25309 VSS.n8025 VSS.n2388 0.120292
R25310 VSS.n8026 VSS.n8025 0.120292
R25311 VSS.n8026 VSS.n8024 0.120292
R25312 VSS.n8024 VSS.n2393 0.120292
R25313 VSS.n8016 VSS.n2393 0.120292
R25314 VSS.n8016 VSS.n8015 0.120292
R25315 VSS.n8015 VSS.n8014 0.120292
R25316 VSS.n8014 VSS.n2396 0.120292
R25317 VSS.n8011 VSS.n2396 0.120292
R25318 VSS.n8011 VSS.n8010 0.120292
R25319 VSS.n8010 VSS.n8009 0.120292
R25320 VSS.n8004 VSS.n2402 0.120292
R25321 VSS.n7996 VSS.n2402 0.120292
R25322 VSS.n7996 VSS.n7995 0.120292
R25323 VSS.n7995 VSS.n2406 0.120292
R25324 VSS.n7991 VSS.n2406 0.120292
R25325 VSS.n7989 VSS.n2408 0.120292
R25326 VSS.n7980 VSS.n2408 0.120292
R25327 VSS.n7980 VSS.n7979 0.120292
R25328 VSS.n7979 VSS.n7978 0.120292
R25329 VSS.n7978 VSS.n2415 0.120292
R25330 VSS.n7970 VSS.n2415 0.120292
R25331 VSS.n7970 VSS.n7969 0.120292
R25332 VSS.n7969 VSS.n2416 0.120292
R25333 VSS.n7966 VSS.n2416 0.120292
R25334 VSS.n7966 VSS.n7965 0.120292
R25335 VSS.n7965 VSS.n7964 0.120292
R25336 VSS.n7964 VSS.n2418 0.120292
R25337 VSS.n7956 VSS.n2418 0.120292
R25338 VSS.n7957 VSS.n7956 0.120292
R25339 VSS.n7957 VSS.n7955 0.120292
R25340 VSS.n7955 VSS.n7954 0.120292
R25341 VSS.n7954 VSS.n2423 0.120292
R25342 VSS.n7946 VSS.n2423 0.120292
R25343 VSS.n7946 VSS.n7945 0.120292
R25344 VSS.n7945 VSS.n7944 0.120292
R25345 VSS.n7944 VSS.n2425 0.120292
R25346 VSS.n7939 VSS.n2425 0.120292
R25347 VSS.n7939 VSS.n7938 0.120292
R25348 VSS.n7938 VSS.n2426 0.120292
R25349 VSS.n7934 VSS.n2426 0.120292
R25350 VSS.n7934 VSS.n7933 0.120292
R25351 VSS.n7933 VSS.n7932 0.120292
R25352 VSS.n7932 VSS.n2430 0.120292
R25353 VSS.n7919 VSS.n2430 0.120292
R25354 VSS.n7920 VSS.n7919 0.120292
R25355 VSS.n7920 VSS.n7918 0.120292
R25356 VSS.n7918 VSS.n2435 0.120292
R25357 VSS.n7910 VSS.n2435 0.120292
R25358 VSS.n7910 VSS.n7909 0.120292
R25359 VSS.n7909 VSS.n7908 0.120292
R25360 VSS.n7908 VSS.n2438 0.120292
R25361 VSS.n7905 VSS.n2438 0.120292
R25362 VSS.n7905 VSS.n7904 0.120292
R25363 VSS.n7904 VSS.n7903 0.120292
R25364 VSS.n7898 VSS.n2444 0.120292
R25365 VSS.n7890 VSS.n2444 0.120292
R25366 VSS.n7890 VSS.n7889 0.120292
R25367 VSS.n7889 VSS.n2448 0.120292
R25368 VSS.n7885 VSS.n2448 0.120292
R25369 VSS.n7883 VSS.n2450 0.120292
R25370 VSS.n7874 VSS.n2450 0.120292
R25371 VSS.n7874 VSS.n7873 0.120292
R25372 VSS.n7873 VSS.n7872 0.120292
R25373 VSS.n7872 VSS.n2457 0.120292
R25374 VSS.n7864 VSS.n2457 0.120292
R25375 VSS.n7864 VSS.n7863 0.120292
R25376 VSS.n7863 VSS.n2458 0.120292
R25377 VSS.n7860 VSS.n2458 0.120292
R25378 VSS.n7860 VSS.n7859 0.120292
R25379 VSS.n7859 VSS.n7858 0.120292
R25380 VSS.n7858 VSS.n2460 0.120292
R25381 VSS.n7850 VSS.n2460 0.120292
R25382 VSS.n7851 VSS.n7850 0.120292
R25383 VSS.n7851 VSS.n7849 0.120292
R25384 VSS.n7849 VSS.n7848 0.120292
R25385 VSS.n7848 VSS.n2465 0.120292
R25386 VSS.n7840 VSS.n2465 0.120292
R25387 VSS.n7840 VSS.n7839 0.120292
R25388 VSS.n7839 VSS.n7838 0.120292
R25389 VSS.n7838 VSS.n2467 0.120292
R25390 VSS.n7833 VSS.n2467 0.120292
R25391 VSS.n7833 VSS.n7832 0.120292
R25392 VSS.n7832 VSS.n2468 0.120292
R25393 VSS.n7828 VSS.n2468 0.120292
R25394 VSS.n7828 VSS.n7827 0.120292
R25395 VSS.n7827 VSS.n7826 0.120292
R25396 VSS.n7826 VSS.n2472 0.120292
R25397 VSS.n7813 VSS.n2472 0.120292
R25398 VSS.n7814 VSS.n7813 0.120292
R25399 VSS.n7814 VSS.n7812 0.120292
R25400 VSS.n7812 VSS.n2477 0.120292
R25401 VSS.n7804 VSS.n2477 0.120292
R25402 VSS.n7804 VSS.n7803 0.120292
R25403 VSS.n7803 VSS.n7802 0.120292
R25404 VSS.n7802 VSS.n2480 0.120292
R25405 VSS.n7799 VSS.n2480 0.120292
R25406 VSS.n7799 VSS.n7798 0.120292
R25407 VSS.n7798 VSS.n7797 0.120292
R25408 VSS.n7792 VSS.n2486 0.120292
R25409 VSS.n7784 VSS.n2486 0.120292
R25410 VSS.n7784 VSS.n7783 0.120292
R25411 VSS.n7783 VSS.n2490 0.120292
R25412 VSS.n7779 VSS.n2490 0.120292
R25413 VSS.n7777 VSS.n2492 0.120292
R25414 VSS.n7768 VSS.n2492 0.120292
R25415 VSS.n7768 VSS.n7767 0.120292
R25416 VSS.n7767 VSS.n7766 0.120292
R25417 VSS.n7766 VSS.n2499 0.120292
R25418 VSS.n7758 VSS.n2499 0.120292
R25419 VSS.n7758 VSS.n7757 0.120292
R25420 VSS.n7757 VSS.n2500 0.120292
R25421 VSS.n7754 VSS.n2500 0.120292
R25422 VSS.n7754 VSS.n7753 0.120292
R25423 VSS.n7753 VSS.n7752 0.120292
R25424 VSS.n7752 VSS.n2502 0.120292
R25425 VSS.n7744 VSS.n2502 0.120292
R25426 VSS.n7745 VSS.n7744 0.120292
R25427 VSS.n7745 VSS.n7743 0.120292
R25428 VSS.n7743 VSS.n7742 0.120292
R25429 VSS.n7742 VSS.n2507 0.120292
R25430 VSS.n7734 VSS.n2507 0.120292
R25431 VSS.n7734 VSS.n7733 0.120292
R25432 VSS.n7733 VSS.n7732 0.120292
R25433 VSS.n7732 VSS.n2509 0.120292
R25434 VSS.n7727 VSS.n2509 0.120292
R25435 VSS.n7727 VSS.n7726 0.120292
R25436 VSS.n7726 VSS.n2510 0.120292
R25437 VSS.n7722 VSS.n2510 0.120292
R25438 VSS.n7722 VSS.n7721 0.120292
R25439 VSS.n7721 VSS.n7720 0.120292
R25440 VSS.n7720 VSS.n2514 0.120292
R25441 VSS.n7707 VSS.n2514 0.120292
R25442 VSS.n7708 VSS.n7707 0.120292
R25443 VSS.n7708 VSS.n7706 0.120292
R25444 VSS.n7706 VSS.n2519 0.120292
R25445 VSS.n7698 VSS.n2519 0.120292
R25446 VSS.n7698 VSS.n7697 0.120292
R25447 VSS.n7697 VSS.n7696 0.120292
R25448 VSS.n7696 VSS.n2522 0.120292
R25449 VSS.n7693 VSS.n2522 0.120292
R25450 VSS.n7693 VSS.n7692 0.120292
R25451 VSS.n7692 VSS.n7691 0.120292
R25452 VSS.n7686 VSS.n2528 0.120292
R25453 VSS.n7678 VSS.n2528 0.120292
R25454 VSS.n7678 VSS.n7677 0.120292
R25455 VSS.n7677 VSS.n2532 0.120292
R25456 VSS.n7673 VSS.n2532 0.120292
R25457 VSS.n7657 VSS.n13 0.120292
R25458 VSS.n7657 VSS.n7656 0.120292
R25459 VSS.n7656 VSS.n7655 0.120292
R25460 VSS.n7655 VSS.n7592 0.120292
R25461 VSS.n7647 VSS.n7592 0.120292
R25462 VSS.n7648 VSS.n7647 0.120292
R25463 VSS.n7648 VSS.n7646 0.120292
R25464 VSS.n7646 VSS.n7645 0.120292
R25465 VSS.n7645 VSS.n7608 0.120292
R25466 VSS.n7633 VSS.n7608 0.120292
R25467 VSS.n7634 VSS.n7633 0.120292
R25468 VSS.n7634 VSS.n7632 0.120292
R25469 VSS.n7632 VSS.n7613 0.120292
R25470 VSS.n7625 VSS.n7613 0.120292
R25471 VSS.n7625 VSS.n7624 0.120292
R25472 VSS.n7624 VSS.n7614 0.120292
R25473 VSS.n7621 VSS.n7614 0.120292
R25474 VSS.n7621 VSS.n7620 0.120292
R25475 VSS.n7620 VSS.n7619 0.120292
R25476 VSS.n7619 VSS.n7616 0.120292
R25477 VSS.n9349 VSS.n9342 0.120292
R25478 VSS.n9350 VSS.n9349 0.120292
R25479 VSS.n9350 VSS.n9341 0.120292
R25480 VSS.n9341 VSS.n9335 0.120292
R25481 VSS.n9358 VSS.n9335 0.120292
R25482 VSS.n9359 VSS.n9358 0.120292
R25483 VSS.n9360 VSS.n9359 0.120292
R25484 VSS.n9360 VSS.n9333 0.120292
R25485 VSS.n9364 VSS.n9333 0.120292
R25486 VSS.n9365 VSS.n9364 0.120292
R25487 VSS.n9366 VSS.n9365 0.120292
R25488 VSS.n9366 VSS.n9329 0.120292
R25489 VSS.n9372 VSS.n9329 0.120292
R25490 VSS.n9373 VSS.n9372 0.120292
R25491 VSS.n9373 VSS.n9328 0.120292
R25492 VSS.n9328 VSS.n9322 0.120292
R25493 VSS.n9381 VSS.n9322 0.120292
R25494 VSS.n9382 VSS.n9381 0.120292
R25495 VSS.n9383 VSS.n9382 0.120292
R25496 VSS.n9383 VSS.n9320 0.120292
R25497 VSS.n9387 VSS.n9320 0.120292
R25498 VSS.n9388 VSS.n9387 0.120292
R25499 VSS.n9395 VSS.n9394 0.120292
R25500 VSS.n9395 VSS.n8366 0.120292
R25501 VSS.n9399 VSS.n8366 0.120292
R25502 VSS.n8381 VSS.n8380 0.120292
R25503 VSS.n8382 VSS.n8381 0.120292
R25504 VSS.n8382 VSS.n8375 0.120292
R25505 VSS.n8387 VSS.n8372 0.120292
R25506 VSS.n9314 VSS.n8372 0.120292
R25507 VSS.n9315 VSS.n9314 0.120292
R25508 VSS.n9315 VSS.n8371 0.120292
R25509 VSS.n9302 VSS.n8371 0.120292
R25510 VSS.n9303 VSS.n9302 0.120292
R25511 VSS.n9303 VSS.n9301 0.120292
R25512 VSS.n9301 VSS.n9300 0.120292
R25513 VSS.n9300 VSS.n8391 0.120292
R25514 VSS.n9295 VSS.n8391 0.120292
R25515 VSS.n9295 VSS.n9294 0.120292
R25516 VSS.n9294 VSS.n8392 0.120292
R25517 VSS.n9290 VSS.n8392 0.120292
R25518 VSS.n9290 VSS.n9289 0.120292
R25519 VSS.n9289 VSS.n9288 0.120292
R25520 VSS.n9288 VSS.n8396 0.120292
R25521 VSS.n9275 VSS.n8396 0.120292
R25522 VSS.n9276 VSS.n9275 0.120292
R25523 VSS.n9276 VSS.n9274 0.120292
R25524 VSS.n9274 VSS.n8401 0.120292
R25525 VSS.n9266 VSS.n8401 0.120292
R25526 VSS.n9266 VSS.n9265 0.120292
R25527 VSS.n9265 VSS.n9264 0.120292
R25528 VSS.n9264 VSS.n8404 0.120292
R25529 VSS.n9261 VSS.n8404 0.120292
R25530 VSS.n9261 VSS.n9260 0.120292
R25531 VSS.n9260 VSS.n9259 0.120292
R25532 VSS.n9254 VSS.n8410 0.120292
R25533 VSS.n9246 VSS.n8410 0.120292
R25534 VSS.n9246 VSS.n9245 0.120292
R25535 VSS.n9245 VSS.n8414 0.120292
R25536 VSS.n9241 VSS.n8414 0.120292
R25537 VSS.n9239 VSS.n8416 0.120292
R25538 VSS.n9230 VSS.n8416 0.120292
R25539 VSS.n9230 VSS.n9229 0.120292
R25540 VSS.n9229 VSS.n9228 0.120292
R25541 VSS.n9228 VSS.n8423 0.120292
R25542 VSS.n9220 VSS.n8423 0.120292
R25543 VSS.n9220 VSS.n9219 0.120292
R25544 VSS.n9219 VSS.n8424 0.120292
R25545 VSS.n9216 VSS.n8424 0.120292
R25546 VSS.n9216 VSS.n9215 0.120292
R25547 VSS.n9215 VSS.n9214 0.120292
R25548 VSS.n9214 VSS.n8426 0.120292
R25549 VSS.n9206 VSS.n8426 0.120292
R25550 VSS.n9207 VSS.n9206 0.120292
R25551 VSS.n9207 VSS.n9205 0.120292
R25552 VSS.n9205 VSS.n9204 0.120292
R25553 VSS.n9204 VSS.n8431 0.120292
R25554 VSS.n9196 VSS.n8431 0.120292
R25555 VSS.n9196 VSS.n9195 0.120292
R25556 VSS.n9195 VSS.n9194 0.120292
R25557 VSS.n9194 VSS.n8433 0.120292
R25558 VSS.n9189 VSS.n8433 0.120292
R25559 VSS.n9189 VSS.n9188 0.120292
R25560 VSS.n9188 VSS.n8434 0.120292
R25561 VSS.n9184 VSS.n8434 0.120292
R25562 VSS.n9184 VSS.n9183 0.120292
R25563 VSS.n9183 VSS.n9182 0.120292
R25564 VSS.n9182 VSS.n8438 0.120292
R25565 VSS.n9169 VSS.n8438 0.120292
R25566 VSS.n9170 VSS.n9169 0.120292
R25567 VSS.n9170 VSS.n9168 0.120292
R25568 VSS.n9168 VSS.n8443 0.120292
R25569 VSS.n9160 VSS.n8443 0.120292
R25570 VSS.n9160 VSS.n9159 0.120292
R25571 VSS.n9159 VSS.n9158 0.120292
R25572 VSS.n9158 VSS.n8446 0.120292
R25573 VSS.n9155 VSS.n8446 0.120292
R25574 VSS.n9155 VSS.n9154 0.120292
R25575 VSS.n9154 VSS.n9153 0.120292
R25576 VSS.n9148 VSS.n8452 0.120292
R25577 VSS.n9140 VSS.n8452 0.120292
R25578 VSS.n9140 VSS.n9139 0.120292
R25579 VSS.n9139 VSS.n8456 0.120292
R25580 VSS.n9135 VSS.n8456 0.120292
R25581 VSS.n9133 VSS.n8458 0.120292
R25582 VSS.n9124 VSS.n8458 0.120292
R25583 VSS.n9124 VSS.n9123 0.120292
R25584 VSS.n9123 VSS.n9122 0.120292
R25585 VSS.n9122 VSS.n8465 0.120292
R25586 VSS.n9114 VSS.n8465 0.120292
R25587 VSS.n9114 VSS.n9113 0.120292
R25588 VSS.n9113 VSS.n8466 0.120292
R25589 VSS.n9110 VSS.n8466 0.120292
R25590 VSS.n9110 VSS.n9109 0.120292
R25591 VSS.n9109 VSS.n9108 0.120292
R25592 VSS.n9108 VSS.n8468 0.120292
R25593 VSS.n9100 VSS.n8468 0.120292
R25594 VSS.n9101 VSS.n9100 0.120292
R25595 VSS.n9101 VSS.n9099 0.120292
R25596 VSS.n9099 VSS.n9098 0.120292
R25597 VSS.n9098 VSS.n8473 0.120292
R25598 VSS.n9090 VSS.n8473 0.120292
R25599 VSS.n9090 VSS.n9089 0.120292
R25600 VSS.n9089 VSS.n9088 0.120292
R25601 VSS.n9088 VSS.n8475 0.120292
R25602 VSS.n9083 VSS.n8475 0.120292
R25603 VSS.n9083 VSS.n9082 0.120292
R25604 VSS.n9082 VSS.n8476 0.120292
R25605 VSS.n9078 VSS.n8476 0.120292
R25606 VSS.n9078 VSS.n9077 0.120292
R25607 VSS.n9077 VSS.n9076 0.120292
R25608 VSS.n9076 VSS.n8480 0.120292
R25609 VSS.n9063 VSS.n8480 0.120292
R25610 VSS.n9064 VSS.n9063 0.120292
R25611 VSS.n9064 VSS.n9062 0.120292
R25612 VSS.n9062 VSS.n8485 0.120292
R25613 VSS.n9054 VSS.n8485 0.120292
R25614 VSS.n9054 VSS.n9053 0.120292
R25615 VSS.n9053 VSS.n9052 0.120292
R25616 VSS.n9052 VSS.n8488 0.120292
R25617 VSS.n9049 VSS.n8488 0.120292
R25618 VSS.n9049 VSS.n9048 0.120292
R25619 VSS.n9048 VSS.n9047 0.120292
R25620 VSS.n9042 VSS.n8494 0.120292
R25621 VSS.n9034 VSS.n8494 0.120292
R25622 VSS.n9034 VSS.n9033 0.120292
R25623 VSS.n9033 VSS.n8498 0.120292
R25624 VSS.n9029 VSS.n8498 0.120292
R25625 VSS.n9027 VSS.n8500 0.120292
R25626 VSS.n9018 VSS.n8500 0.120292
R25627 VSS.n9018 VSS.n9017 0.120292
R25628 VSS.n9017 VSS.n9016 0.120292
R25629 VSS.n9016 VSS.n8507 0.120292
R25630 VSS.n9008 VSS.n8507 0.120292
R25631 VSS.n9008 VSS.n9007 0.120292
R25632 VSS.n9007 VSS.n8508 0.120292
R25633 VSS.n9004 VSS.n8508 0.120292
R25634 VSS.n9004 VSS.n9003 0.120292
R25635 VSS.n9003 VSS.n9002 0.120292
R25636 VSS.n9002 VSS.n8510 0.120292
R25637 VSS.n8994 VSS.n8510 0.120292
R25638 VSS.n8995 VSS.n8994 0.120292
R25639 VSS.n8995 VSS.n8993 0.120292
R25640 VSS.n8993 VSS.n8992 0.120292
R25641 VSS.n8992 VSS.n8515 0.120292
R25642 VSS.n8984 VSS.n8515 0.120292
R25643 VSS.n8984 VSS.n8983 0.120292
R25644 VSS.n8983 VSS.n8982 0.120292
R25645 VSS.n8982 VSS.n8517 0.120292
R25646 VSS.n8977 VSS.n8517 0.120292
R25647 VSS.n8977 VSS.n8976 0.120292
R25648 VSS.n8976 VSS.n8518 0.120292
R25649 VSS.n8972 VSS.n8518 0.120292
R25650 VSS.n8972 VSS.n8971 0.120292
R25651 VSS.n8971 VSS.n8970 0.120292
R25652 VSS.n8970 VSS.n8522 0.120292
R25653 VSS.n8957 VSS.n8522 0.120292
R25654 VSS.n8958 VSS.n8957 0.120292
R25655 VSS.n8958 VSS.n8956 0.120292
R25656 VSS.n8956 VSS.n8527 0.120292
R25657 VSS.n8948 VSS.n8527 0.120292
R25658 VSS.n8948 VSS.n8947 0.120292
R25659 VSS.n8947 VSS.n8946 0.120292
R25660 VSS.n8946 VSS.n8530 0.120292
R25661 VSS.n8943 VSS.n8530 0.120292
R25662 VSS.n8943 VSS.n8942 0.120292
R25663 VSS.n8942 VSS.n8941 0.120292
R25664 VSS.n8936 VSS.n8536 0.120292
R25665 VSS.n8928 VSS.n8536 0.120292
R25666 VSS.n8928 VSS.n8927 0.120292
R25667 VSS.n8927 VSS.n8540 0.120292
R25668 VSS.n8923 VSS.n8540 0.120292
R25669 VSS.n8921 VSS.n8542 0.120292
R25670 VSS.n8912 VSS.n8542 0.120292
R25671 VSS.n8912 VSS.n8911 0.120292
R25672 VSS.n8911 VSS.n8910 0.120292
R25673 VSS.n8910 VSS.n8549 0.120292
R25674 VSS.n8902 VSS.n8549 0.120292
R25675 VSS.n8902 VSS.n8901 0.120292
R25676 VSS.n8901 VSS.n8550 0.120292
R25677 VSS.n8898 VSS.n8550 0.120292
R25678 VSS.n8898 VSS.n8897 0.120292
R25679 VSS.n8897 VSS.n8896 0.120292
R25680 VSS.n8896 VSS.n8552 0.120292
R25681 VSS.n8888 VSS.n8552 0.120292
R25682 VSS.n8889 VSS.n8888 0.120292
R25683 VSS.n8889 VSS.n8887 0.120292
R25684 VSS.n8887 VSS.n8886 0.120292
R25685 VSS.n8886 VSS.n8557 0.120292
R25686 VSS.n8878 VSS.n8557 0.120292
R25687 VSS.n8878 VSS.n8877 0.120292
R25688 VSS.n8877 VSS.n8876 0.120292
R25689 VSS.n8876 VSS.n8559 0.120292
R25690 VSS.n8871 VSS.n8559 0.120292
R25691 VSS.n8871 VSS.n8870 0.120292
R25692 VSS.n8870 VSS.n8560 0.120292
R25693 VSS.n8866 VSS.n8560 0.120292
R25694 VSS.n8866 VSS.n8865 0.120292
R25695 VSS.n8865 VSS.n8864 0.120292
R25696 VSS.n8864 VSS.n8564 0.120292
R25697 VSS.n8851 VSS.n8564 0.120292
R25698 VSS.n8852 VSS.n8851 0.120292
R25699 VSS.n8852 VSS.n8850 0.120292
R25700 VSS.n8850 VSS.n8569 0.120292
R25701 VSS.n8842 VSS.n8569 0.120292
R25702 VSS.n8842 VSS.n8841 0.120292
R25703 VSS.n8841 VSS.n8840 0.120292
R25704 VSS.n8840 VSS.n8572 0.120292
R25705 VSS.n8837 VSS.n8572 0.120292
R25706 VSS.n8837 VSS.n8836 0.120292
R25707 VSS.n8836 VSS.n8835 0.120292
R25708 VSS.n8830 VSS.n8578 0.120292
R25709 VSS.n8822 VSS.n8578 0.120292
R25710 VSS.n8822 VSS.n8821 0.120292
R25711 VSS.n8821 VSS.n8582 0.120292
R25712 VSS.n8817 VSS.n8582 0.120292
R25713 VSS.n8815 VSS.n8584 0.120292
R25714 VSS.n8806 VSS.n8584 0.120292
R25715 VSS.n8806 VSS.n8805 0.120292
R25716 VSS.n8805 VSS.n8804 0.120292
R25717 VSS.n8804 VSS.n8591 0.120292
R25718 VSS.n8796 VSS.n8591 0.120292
R25719 VSS.n8796 VSS.n8795 0.120292
R25720 VSS.n8795 VSS.n8592 0.120292
R25721 VSS.n8792 VSS.n8592 0.120292
R25722 VSS.n8792 VSS.n8791 0.120292
R25723 VSS.n8791 VSS.n8790 0.120292
R25724 VSS.n8790 VSS.n8594 0.120292
R25725 VSS.n8782 VSS.n8594 0.120292
R25726 VSS.n8783 VSS.n8782 0.120292
R25727 VSS.n8783 VSS.n8781 0.120292
R25728 VSS.n8781 VSS.n8780 0.120292
R25729 VSS.n8780 VSS.n8599 0.120292
R25730 VSS.n8772 VSS.n8599 0.120292
R25731 VSS.n8772 VSS.n8771 0.120292
R25732 VSS.n8771 VSS.n8770 0.120292
R25733 VSS.n8770 VSS.n8601 0.120292
R25734 VSS.n8765 VSS.n8601 0.120292
R25735 VSS.n8765 VSS.n8764 0.120292
R25736 VSS.n8764 VSS.n8602 0.120292
R25737 VSS.n8760 VSS.n8602 0.120292
R25738 VSS.n8760 VSS.n8759 0.120292
R25739 VSS.n8759 VSS.n8758 0.120292
R25740 VSS.n8758 VSS.n8606 0.120292
R25741 VSS.n8745 VSS.n8606 0.120292
R25742 VSS.n8746 VSS.n8745 0.120292
R25743 VSS.n8746 VSS.n8744 0.120292
R25744 VSS.n8744 VSS.n8611 0.120292
R25745 VSS.n8736 VSS.n8611 0.120292
R25746 VSS.n8736 VSS.n8735 0.120292
R25747 VSS.n8735 VSS.n8734 0.120292
R25748 VSS.n8734 VSS.n8614 0.120292
R25749 VSS.n8731 VSS.n8614 0.120292
R25750 VSS.n8731 VSS.n8730 0.120292
R25751 VSS.n8730 VSS.n8729 0.120292
R25752 VSS.n8724 VSS.n8620 0.120292
R25753 VSS.n8716 VSS.n8620 0.120292
R25754 VSS.n8716 VSS.n8715 0.120292
R25755 VSS.n8715 VSS.n8624 0.120292
R25756 VSS.n8711 VSS.n8624 0.120292
R25757 VSS.n8700 VSS.n15 0.120292
R25758 VSS.n8700 VSS.n8699 0.120292
R25759 VSS.n8699 VSS.n8698 0.120292
R25760 VSS.n8698 VSS.n8635 0.120292
R25761 VSS.n8690 VSS.n8635 0.120292
R25762 VSS.n8691 VSS.n8690 0.120292
R25763 VSS.n8691 VSS.n8689 0.120292
R25764 VSS.n8689 VSS.n8688 0.120292
R25765 VSS.n8688 VSS.n8651 0.120292
R25766 VSS.n8676 VSS.n8651 0.120292
R25767 VSS.n8677 VSS.n8676 0.120292
R25768 VSS.n8677 VSS.n8675 0.120292
R25769 VSS.n8675 VSS.n8656 0.120292
R25770 VSS.n8668 VSS.n8656 0.120292
R25771 VSS.n8668 VSS.n8667 0.120292
R25772 VSS.n8667 VSS.n8657 0.120292
R25773 VSS.n8664 VSS.n8657 0.120292
R25774 VSS.n8664 VSS.n8663 0.120292
R25775 VSS.n8663 VSS.n8662 0.120292
R25776 VSS.n8662 VSS.n8659 0.120292
R25777 VSS.n2227 VSS.n2226 0.120292
R25778 VSS.n2227 VSS.n128 0.120292
R25779 VSS.n2237 VSS.n2219 0.120292
R25780 VSS.n2245 VSS.n2219 0.120292
R25781 VSS.n2246 VSS.n2245 0.120292
R25782 VSS.n2246 VSS.n2217 0.120292
R25783 VSS.n2250 VSS.n2217 0.120292
R25784 VSS.n2215 VSS.n2213 0.120292
R25785 VSS.n2257 VSS.n2213 0.120292
R25786 VSS.n2258 VSS.n2257 0.120292
R25787 VSS.n2259 VSS.n2258 0.120292
R25788 VSS.n2259 VSS.n2210 0.120292
R25789 VSS.n2269 VSS.n2268 0.120292
R25790 VSS.n2270 VSS.n2269 0.120292
R25791 VSS.n2270 VSS.n2207 0.120292
R25792 VSS.n9409 VSS.n9408 0.120292
R25793 VSS.n9410 VSS.n9409 0.120292
R25794 VSS.n9410 VSS.n2205 0.120292
R25795 VSS.n9415 VSS.n2204 0.120292
R25796 VSS.n2204 VSS.n2195 0.120292
R25797 VSS.n9421 VSS.n2195 0.120292
R25798 VSS.n9422 VSS.n9421 0.120292
R25799 VSS.n9422 VSS.n2194 0.120292
R25800 VSS.n2194 VSS.n2189 0.120292
R25801 VSS.n9427 VSS.n2189 0.120292
R25802 VSS.n9428 VSS.n9427 0.120292
R25803 VSS.n9429 VSS.n9428 0.120292
R25804 VSS.n9429 VSS.n2187 0.120292
R25805 VSS.n9433 VSS.n2187 0.120292
R25806 VSS.n9434 VSS.n9433 0.120292
R25807 VSS.n9434 VSS.n2185 0.120292
R25808 VSS.n9440 VSS.n2185 0.120292
R25809 VSS.n9441 VSS.n9440 0.120292
R25810 VSS.n9441 VSS.n2180 0.120292
R25811 VSS.n9448 VSS.n2180 0.120292
R25812 VSS.n9449 VSS.n9448 0.120292
R25813 VSS.n9449 VSS.n2175 0.120292
R25814 VSS.n9457 VSS.n2175 0.120292
R25815 VSS.n9458 VSS.n9457 0.120292
R25816 VSS.n9459 VSS.n9458 0.120292
R25817 VSS.n9459 VSS.n2173 0.120292
R25818 VSS.n9463 VSS.n2173 0.120292
R25819 VSS.n9464 VSS.n9463 0.120292
R25820 VSS.n9465 VSS.n9464 0.120292
R25821 VSS.n9465 VSS.n2172 0.120292
R25822 VSS.n9476 VSS.n9475 0.120292
R25823 VSS.n9476 VSS.n2168 0.120292
R25824 VSS.n2168 VSS.n2164 0.120292
R25825 VSS.n9484 VSS.n2164 0.120292
R25826 VSS.n9485 VSS.n9484 0.120292
R25827 VSS.n9496 VSS.n9495 0.120292
R25828 VSS.n9497 VSS.n9496 0.120292
R25829 VSS.n9497 VSS.n2157 0.120292
R25830 VSS.n9505 VSS.n2157 0.120292
R25831 VSS.n9506 VSS.n9505 0.120292
R25832 VSS.n9507 VSS.n9506 0.120292
R25833 VSS.n9507 VSS.n2155 0.120292
R25834 VSS.n9511 VSS.n2155 0.120292
R25835 VSS.n9512 VSS.n9511 0.120292
R25836 VSS.n9512 VSS.n2154 0.120292
R25837 VSS.n9515 VSS.n2154 0.120292
R25838 VSS.n9516 VSS.n9515 0.120292
R25839 VSS.n9516 VSS.n2153 0.120292
R25840 VSS.n2153 VSS.n2145 0.120292
R25841 VSS.n9522 VSS.n2145 0.120292
R25842 VSS.n9523 VSS.n9522 0.120292
R25843 VSS.n9523 VSS.n2144 0.120292
R25844 VSS.n2144 VSS.n2139 0.120292
R25845 VSS.n9528 VSS.n2139 0.120292
R25846 VSS.n9529 VSS.n9528 0.120292
R25847 VSS.n9530 VSS.n9529 0.120292
R25848 VSS.n9530 VSS.n2137 0.120292
R25849 VSS.n9534 VSS.n2137 0.120292
R25850 VSS.n9535 VSS.n9534 0.120292
R25851 VSS.n9535 VSS.n2135 0.120292
R25852 VSS.n9541 VSS.n2135 0.120292
R25853 VSS.n9542 VSS.n9541 0.120292
R25854 VSS.n9542 VSS.n2130 0.120292
R25855 VSS.n9549 VSS.n2130 0.120292
R25856 VSS.n9550 VSS.n9549 0.120292
R25857 VSS.n9550 VSS.n2125 0.120292
R25858 VSS.n9558 VSS.n2125 0.120292
R25859 VSS.n9559 VSS.n9558 0.120292
R25860 VSS.n9560 VSS.n9559 0.120292
R25861 VSS.n9560 VSS.n2123 0.120292
R25862 VSS.n9564 VSS.n2123 0.120292
R25863 VSS.n9565 VSS.n9564 0.120292
R25864 VSS.n9566 VSS.n9565 0.120292
R25865 VSS.n9566 VSS.n2122 0.120292
R25866 VSS.n9577 VSS.n9576 0.120292
R25867 VSS.n9577 VSS.n2118 0.120292
R25868 VSS.n2118 VSS.n2114 0.120292
R25869 VSS.n9585 VSS.n2114 0.120292
R25870 VSS.n9586 VSS.n9585 0.120292
R25871 VSS.n9597 VSS.n9596 0.120292
R25872 VSS.n9598 VSS.n9597 0.120292
R25873 VSS.n9598 VSS.n2107 0.120292
R25874 VSS.n9606 VSS.n2107 0.120292
R25875 VSS.n9607 VSS.n9606 0.120292
R25876 VSS.n9608 VSS.n9607 0.120292
R25877 VSS.n9608 VSS.n2105 0.120292
R25878 VSS.n9612 VSS.n2105 0.120292
R25879 VSS.n9613 VSS.n9612 0.120292
R25880 VSS.n9613 VSS.n2104 0.120292
R25881 VSS.n9616 VSS.n2104 0.120292
R25882 VSS.n9617 VSS.n9616 0.120292
R25883 VSS.n9617 VSS.n2103 0.120292
R25884 VSS.n2103 VSS.n2095 0.120292
R25885 VSS.n9623 VSS.n2095 0.120292
R25886 VSS.n9624 VSS.n9623 0.120292
R25887 VSS.n9624 VSS.n2094 0.120292
R25888 VSS.n2094 VSS.n2089 0.120292
R25889 VSS.n9629 VSS.n2089 0.120292
R25890 VSS.n9630 VSS.n9629 0.120292
R25891 VSS.n9631 VSS.n9630 0.120292
R25892 VSS.n9631 VSS.n2087 0.120292
R25893 VSS.n9635 VSS.n2087 0.120292
R25894 VSS.n9636 VSS.n9635 0.120292
R25895 VSS.n9636 VSS.n2085 0.120292
R25896 VSS.n9642 VSS.n2085 0.120292
R25897 VSS.n9643 VSS.n9642 0.120292
R25898 VSS.n9643 VSS.n2080 0.120292
R25899 VSS.n9650 VSS.n2080 0.120292
R25900 VSS.n9651 VSS.n9650 0.120292
R25901 VSS.n9651 VSS.n2075 0.120292
R25902 VSS.n9659 VSS.n2075 0.120292
R25903 VSS.n9660 VSS.n9659 0.120292
R25904 VSS.n9661 VSS.n9660 0.120292
R25905 VSS.n9661 VSS.n2073 0.120292
R25906 VSS.n9665 VSS.n2073 0.120292
R25907 VSS.n9666 VSS.n9665 0.120292
R25908 VSS.n9667 VSS.n9666 0.120292
R25909 VSS.n9667 VSS.n2072 0.120292
R25910 VSS.n9678 VSS.n9677 0.120292
R25911 VSS.n9678 VSS.n2068 0.120292
R25912 VSS.n2068 VSS.n2064 0.120292
R25913 VSS.n9686 VSS.n2064 0.120292
R25914 VSS.n9687 VSS.n9686 0.120292
R25915 VSS.n9698 VSS.n9697 0.120292
R25916 VSS.n9699 VSS.n9698 0.120292
R25917 VSS.n9699 VSS.n2057 0.120292
R25918 VSS.n9707 VSS.n2057 0.120292
R25919 VSS.n9708 VSS.n9707 0.120292
R25920 VSS.n9709 VSS.n9708 0.120292
R25921 VSS.n9709 VSS.n2055 0.120292
R25922 VSS.n9713 VSS.n2055 0.120292
R25923 VSS.n9714 VSS.n9713 0.120292
R25924 VSS.n9714 VSS.n2054 0.120292
R25925 VSS.n9717 VSS.n2054 0.120292
R25926 VSS.n9718 VSS.n9717 0.120292
R25927 VSS.n9718 VSS.n2053 0.120292
R25928 VSS.n2053 VSS.n2045 0.120292
R25929 VSS.n9724 VSS.n2045 0.120292
R25930 VSS.n9725 VSS.n9724 0.120292
R25931 VSS.n9725 VSS.n2044 0.120292
R25932 VSS.n2044 VSS.n2039 0.120292
R25933 VSS.n9730 VSS.n2039 0.120292
R25934 VSS.n9731 VSS.n9730 0.120292
R25935 VSS.n9732 VSS.n9731 0.120292
R25936 VSS.n9732 VSS.n2037 0.120292
R25937 VSS.n9736 VSS.n2037 0.120292
R25938 VSS.n9737 VSS.n9736 0.120292
R25939 VSS.n9737 VSS.n2035 0.120292
R25940 VSS.n9743 VSS.n2035 0.120292
R25941 VSS.n9744 VSS.n9743 0.120292
R25942 VSS.n9744 VSS.n2030 0.120292
R25943 VSS.n9751 VSS.n2030 0.120292
R25944 VSS.n9752 VSS.n9751 0.120292
R25945 VSS.n9752 VSS.n2025 0.120292
R25946 VSS.n9760 VSS.n2025 0.120292
R25947 VSS.n9761 VSS.n9760 0.120292
R25948 VSS.n9762 VSS.n9761 0.120292
R25949 VSS.n9762 VSS.n2023 0.120292
R25950 VSS.n9766 VSS.n2023 0.120292
R25951 VSS.n9767 VSS.n9766 0.120292
R25952 VSS.n9768 VSS.n9767 0.120292
R25953 VSS.n9768 VSS.n2022 0.120292
R25954 VSS.n9779 VSS.n9778 0.120292
R25955 VSS.n9779 VSS.n2018 0.120292
R25956 VSS.n2018 VSS.n2014 0.120292
R25957 VSS.n9787 VSS.n2014 0.120292
R25958 VSS.n9788 VSS.n9787 0.120292
R25959 VSS.n9799 VSS.n9798 0.120292
R25960 VSS.n9800 VSS.n9799 0.120292
R25961 VSS.n9800 VSS.n2007 0.120292
R25962 VSS.n9808 VSS.n2007 0.120292
R25963 VSS.n9809 VSS.n9808 0.120292
R25964 VSS.n9810 VSS.n9809 0.120292
R25965 VSS.n9810 VSS.n2005 0.120292
R25966 VSS.n9814 VSS.n2005 0.120292
R25967 VSS.n9815 VSS.n9814 0.120292
R25968 VSS.n9815 VSS.n2004 0.120292
R25969 VSS.n9818 VSS.n2004 0.120292
R25970 VSS.n9819 VSS.n9818 0.120292
R25971 VSS.n9819 VSS.n2003 0.120292
R25972 VSS.n2003 VSS.n1995 0.120292
R25973 VSS.n9825 VSS.n1995 0.120292
R25974 VSS.n9826 VSS.n9825 0.120292
R25975 VSS.n9826 VSS.n1994 0.120292
R25976 VSS.n1994 VSS.n1989 0.120292
R25977 VSS.n9831 VSS.n1989 0.120292
R25978 VSS.n9832 VSS.n9831 0.120292
R25979 VSS.n9833 VSS.n9832 0.120292
R25980 VSS.n9833 VSS.n1987 0.120292
R25981 VSS.n9837 VSS.n1987 0.120292
R25982 VSS.n9838 VSS.n9837 0.120292
R25983 VSS.n9838 VSS.n1985 0.120292
R25984 VSS.n9844 VSS.n1985 0.120292
R25985 VSS.n9845 VSS.n9844 0.120292
R25986 VSS.n9845 VSS.n1980 0.120292
R25987 VSS.n9852 VSS.n1980 0.120292
R25988 VSS.n9853 VSS.n9852 0.120292
R25989 VSS.n9853 VSS.n1975 0.120292
R25990 VSS.n9861 VSS.n1975 0.120292
R25991 VSS.n9862 VSS.n9861 0.120292
R25992 VSS.n9863 VSS.n9862 0.120292
R25993 VSS.n9863 VSS.n1973 0.120292
R25994 VSS.n9867 VSS.n1973 0.120292
R25995 VSS.n9868 VSS.n9867 0.120292
R25996 VSS.n9869 VSS.n9868 0.120292
R25997 VSS.n9869 VSS.n1972 0.120292
R25998 VSS.n9880 VSS.n9879 0.120292
R25999 VSS.n9880 VSS.n1968 0.120292
R26000 VSS.n1968 VSS.n1964 0.120292
R26001 VSS.n9888 VSS.n1964 0.120292
R26002 VSS.n9889 VSS.n9888 0.120292
R26003 VSS.n9900 VSS.n9899 0.120292
R26004 VSS.n9901 VSS.n9900 0.120292
R26005 VSS.n9901 VSS.n1957 0.120292
R26006 VSS.n9909 VSS.n1957 0.120292
R26007 VSS.n9910 VSS.n9909 0.120292
R26008 VSS.n9911 VSS.n9910 0.120292
R26009 VSS.n9911 VSS.n1955 0.120292
R26010 VSS.n9915 VSS.n1955 0.120292
R26011 VSS.n9916 VSS.n9915 0.120292
R26012 VSS.n9916 VSS.n1954 0.120292
R26013 VSS.n9919 VSS.n1954 0.120292
R26014 VSS.n9920 VSS.n9919 0.120292
R26015 VSS.n9920 VSS.n1953 0.120292
R26016 VSS.n1953 VSS.n1945 0.120292
R26017 VSS.n9926 VSS.n1945 0.120292
R26018 VSS.n9927 VSS.n9926 0.120292
R26019 VSS.n9927 VSS.n1944 0.120292
R26020 VSS.n1944 VSS.n1939 0.120292
R26021 VSS.n9932 VSS.n1939 0.120292
R26022 VSS.n9933 VSS.n9932 0.120292
R26023 VSS.n9934 VSS.n9933 0.120292
R26024 VSS.n9934 VSS.n1937 0.120292
R26025 VSS.n9938 VSS.n1937 0.120292
R26026 VSS.n9939 VSS.n9938 0.120292
R26027 VSS.n9939 VSS.n1935 0.120292
R26028 VSS.n9945 VSS.n1935 0.120292
R26029 VSS.n9946 VSS.n9945 0.120292
R26030 VSS.n9946 VSS.n1930 0.120292
R26031 VSS.n9953 VSS.n1930 0.120292
R26032 VSS.n9954 VSS.n9953 0.120292
R26033 VSS.n9954 VSS.n1925 0.120292
R26034 VSS.n9962 VSS.n1925 0.120292
R26035 VSS.n9963 VSS.n9962 0.120292
R26036 VSS.n9964 VSS.n9963 0.120292
R26037 VSS.n9964 VSS.n1923 0.120292
R26038 VSS.n9968 VSS.n1923 0.120292
R26039 VSS.n9969 VSS.n9968 0.120292
R26040 VSS.n9969 VSS.n1922 0.120292
R26041 VSS.n9972 VSS.n1922 0.120292
R26042 VSS.n9994 VSS.n9976 0.120292
R26043 VSS.n9986 VSS.n9976 0.120292
R26044 VSS.n9986 VSS.n9985 0.120292
R26045 VSS.n9985 VSS.n9980 0.120292
R26046 VSS.n9981 VSS.n9980 0.120292
R26047 VSS.n10049 VSS.n17 0.120292
R26048 VSS.n10049 VSS.n10048 0.120292
R26049 VSS.n10048 VSS.n10047 0.120292
R26050 VSS.n10047 VSS.n1917 0.120292
R26051 VSS.n10039 VSS.n1917 0.120292
R26052 VSS.n10040 VSS.n10039 0.120292
R26053 VSS.n10040 VSS.n10038 0.120292
R26054 VSS.n10038 VSS.n10037 0.120292
R26055 VSS.n10037 VSS.n10000 0.120292
R26056 VSS.n10025 VSS.n10000 0.120292
R26057 VSS.n10026 VSS.n10025 0.120292
R26058 VSS.n10026 VSS.n10024 0.120292
R26059 VSS.n10024 VSS.n10005 0.120292
R26060 VSS.n10017 VSS.n10005 0.120292
R26061 VSS.n10017 VSS.n10016 0.120292
R26062 VSS.n10016 VSS.n10006 0.120292
R26063 VSS.n10013 VSS.n10006 0.120292
R26064 VSS.n10013 VSS.n10012 0.120292
R26065 VSS.n10012 VSS.n10011 0.120292
R26066 VSS.n10011 VSS.n10008 0.120292
R26067 VSS.n10394 VSS.n10393 0.120292
R26068 VSS.n10394 VSS.n10383 0.120292
R26069 VSS.n10402 VSS.n10383 0.120292
R26070 VSS.n10403 VSS.n10402 0.120292
R26071 VSS.n10404 VSS.n10403 0.120292
R26072 VSS.n10404 VSS.n10381 0.120292
R26073 VSS.n10408 VSS.n10381 0.120292
R26074 VSS.n10409 VSS.n10408 0.120292
R26075 VSS.n10410 VSS.n10409 0.120292
R26076 VSS.n10410 VSS.n10379 0.120292
R26077 VSS.n10414 VSS.n10379 0.120292
R26078 VSS.n10415 VSS.n10414 0.120292
R26079 VSS.n10416 VSS.n10415 0.120292
R26080 VSS.n10416 VSS.n10369 0.120292
R26081 VSS.n10424 VSS.n10369 0.120292
R26082 VSS.n10425 VSS.n10424 0.120292
R26083 VSS.n10426 VSS.n10425 0.120292
R26084 VSS.n10426 VSS.n10367 0.120292
R26085 VSS.n10430 VSS.n10367 0.120292
R26086 VSS.n10431 VSS.n10430 0.120292
R26087 VSS.n10432 VSS.n10431 0.120292
R26088 VSS.n10432 VSS.n10364 0.120292
R26089 VSS.n10442 VSS.n10441 0.120292
R26090 VSS.n10443 VSS.n10442 0.120292
R26091 VSS.n10443 VSS.n10361 0.120292
R26092 VSS.n10451 VSS.n10450 0.120292
R26093 VSS.n10452 VSS.n10451 0.120292
R26094 VSS.n10452 VSS.n10359 0.120292
R26095 VSS.n10457 VSS.n10358 0.120292
R26096 VSS.n10358 VSS.n10349 0.120292
R26097 VSS.n10463 VSS.n10349 0.120292
R26098 VSS.n10464 VSS.n10463 0.120292
R26099 VSS.n10464 VSS.n10348 0.120292
R26100 VSS.n10348 VSS.n10343 0.120292
R26101 VSS.n10469 VSS.n10343 0.120292
R26102 VSS.n10470 VSS.n10469 0.120292
R26103 VSS.n10471 VSS.n10470 0.120292
R26104 VSS.n10471 VSS.n10341 0.120292
R26105 VSS.n10475 VSS.n10341 0.120292
R26106 VSS.n10476 VSS.n10475 0.120292
R26107 VSS.n10476 VSS.n10339 0.120292
R26108 VSS.n10482 VSS.n10339 0.120292
R26109 VSS.n10483 VSS.n10482 0.120292
R26110 VSS.n10483 VSS.n10334 0.120292
R26111 VSS.n10490 VSS.n10334 0.120292
R26112 VSS.n10491 VSS.n10490 0.120292
R26113 VSS.n10491 VSS.n10329 0.120292
R26114 VSS.n10499 VSS.n10329 0.120292
R26115 VSS.n10500 VSS.n10499 0.120292
R26116 VSS.n10501 VSS.n10500 0.120292
R26117 VSS.n10501 VSS.n10327 0.120292
R26118 VSS.n10505 VSS.n10327 0.120292
R26119 VSS.n10506 VSS.n10505 0.120292
R26120 VSS.n10507 VSS.n10506 0.120292
R26121 VSS.n10507 VSS.n10326 0.120292
R26122 VSS.n10518 VSS.n10517 0.120292
R26123 VSS.n10518 VSS.n10322 0.120292
R26124 VSS.n10322 VSS.n10318 0.120292
R26125 VSS.n10526 VSS.n10318 0.120292
R26126 VSS.n10527 VSS.n10526 0.120292
R26127 VSS.n10538 VSS.n10537 0.120292
R26128 VSS.n10539 VSS.n10538 0.120292
R26129 VSS.n10539 VSS.n10311 0.120292
R26130 VSS.n10547 VSS.n10311 0.120292
R26131 VSS.n10548 VSS.n10547 0.120292
R26132 VSS.n10549 VSS.n10548 0.120292
R26133 VSS.n10549 VSS.n10309 0.120292
R26134 VSS.n10553 VSS.n10309 0.120292
R26135 VSS.n10554 VSS.n10553 0.120292
R26136 VSS.n10554 VSS.n10308 0.120292
R26137 VSS.n10557 VSS.n10308 0.120292
R26138 VSS.n10558 VSS.n10557 0.120292
R26139 VSS.n10558 VSS.n10307 0.120292
R26140 VSS.n10307 VSS.n10299 0.120292
R26141 VSS.n10564 VSS.n10299 0.120292
R26142 VSS.n10565 VSS.n10564 0.120292
R26143 VSS.n10565 VSS.n10298 0.120292
R26144 VSS.n10298 VSS.n10293 0.120292
R26145 VSS.n10570 VSS.n10293 0.120292
R26146 VSS.n10571 VSS.n10570 0.120292
R26147 VSS.n10572 VSS.n10571 0.120292
R26148 VSS.n10572 VSS.n10291 0.120292
R26149 VSS.n10576 VSS.n10291 0.120292
R26150 VSS.n10577 VSS.n10576 0.120292
R26151 VSS.n10577 VSS.n10289 0.120292
R26152 VSS.n10583 VSS.n10289 0.120292
R26153 VSS.n10584 VSS.n10583 0.120292
R26154 VSS.n10584 VSS.n10284 0.120292
R26155 VSS.n10591 VSS.n10284 0.120292
R26156 VSS.n10592 VSS.n10591 0.120292
R26157 VSS.n10592 VSS.n10279 0.120292
R26158 VSS.n10600 VSS.n10279 0.120292
R26159 VSS.n10601 VSS.n10600 0.120292
R26160 VSS.n10602 VSS.n10601 0.120292
R26161 VSS.n10602 VSS.n10277 0.120292
R26162 VSS.n10606 VSS.n10277 0.120292
R26163 VSS.n10607 VSS.n10606 0.120292
R26164 VSS.n10608 VSS.n10607 0.120292
R26165 VSS.n10608 VSS.n10276 0.120292
R26166 VSS.n10619 VSS.n10618 0.120292
R26167 VSS.n10619 VSS.n10272 0.120292
R26168 VSS.n10272 VSS.n10268 0.120292
R26169 VSS.n10627 VSS.n10268 0.120292
R26170 VSS.n10628 VSS.n10627 0.120292
R26171 VSS.n10639 VSS.n10638 0.120292
R26172 VSS.n10640 VSS.n10639 0.120292
R26173 VSS.n10640 VSS.n10261 0.120292
R26174 VSS.n10648 VSS.n10261 0.120292
R26175 VSS.n10649 VSS.n10648 0.120292
R26176 VSS.n10650 VSS.n10649 0.120292
R26177 VSS.n10650 VSS.n10259 0.120292
R26178 VSS.n10654 VSS.n10259 0.120292
R26179 VSS.n10655 VSS.n10654 0.120292
R26180 VSS.n10655 VSS.n10258 0.120292
R26181 VSS.n10658 VSS.n10258 0.120292
R26182 VSS.n10659 VSS.n10658 0.120292
R26183 VSS.n10659 VSS.n10257 0.120292
R26184 VSS.n10257 VSS.n10249 0.120292
R26185 VSS.n10665 VSS.n10249 0.120292
R26186 VSS.n10666 VSS.n10665 0.120292
R26187 VSS.n10666 VSS.n10248 0.120292
R26188 VSS.n10248 VSS.n10243 0.120292
R26189 VSS.n10671 VSS.n10243 0.120292
R26190 VSS.n10672 VSS.n10671 0.120292
R26191 VSS.n10673 VSS.n10672 0.120292
R26192 VSS.n10673 VSS.n10241 0.120292
R26193 VSS.n10677 VSS.n10241 0.120292
R26194 VSS.n10678 VSS.n10677 0.120292
R26195 VSS.n10678 VSS.n10239 0.120292
R26196 VSS.n10684 VSS.n10239 0.120292
R26197 VSS.n10685 VSS.n10684 0.120292
R26198 VSS.n10685 VSS.n10234 0.120292
R26199 VSS.n10692 VSS.n10234 0.120292
R26200 VSS.n10693 VSS.n10692 0.120292
R26201 VSS.n10693 VSS.n10229 0.120292
R26202 VSS.n10701 VSS.n10229 0.120292
R26203 VSS.n10702 VSS.n10701 0.120292
R26204 VSS.n10703 VSS.n10702 0.120292
R26205 VSS.n10703 VSS.n10227 0.120292
R26206 VSS.n10707 VSS.n10227 0.120292
R26207 VSS.n10708 VSS.n10707 0.120292
R26208 VSS.n10709 VSS.n10708 0.120292
R26209 VSS.n10709 VSS.n10226 0.120292
R26210 VSS.n10720 VSS.n10719 0.120292
R26211 VSS.n10720 VSS.n10222 0.120292
R26212 VSS.n10222 VSS.n10218 0.120292
R26213 VSS.n10728 VSS.n10218 0.120292
R26214 VSS.n10729 VSS.n10728 0.120292
R26215 VSS.n10740 VSS.n10739 0.120292
R26216 VSS.n10741 VSS.n10740 0.120292
R26217 VSS.n10741 VSS.n10211 0.120292
R26218 VSS.n10749 VSS.n10211 0.120292
R26219 VSS.n10750 VSS.n10749 0.120292
R26220 VSS.n10751 VSS.n10750 0.120292
R26221 VSS.n10751 VSS.n10209 0.120292
R26222 VSS.n10755 VSS.n10209 0.120292
R26223 VSS.n10756 VSS.n10755 0.120292
R26224 VSS.n10756 VSS.n10208 0.120292
R26225 VSS.n10759 VSS.n10208 0.120292
R26226 VSS.n10760 VSS.n10759 0.120292
R26227 VSS.n10760 VSS.n10207 0.120292
R26228 VSS.n10207 VSS.n10199 0.120292
R26229 VSS.n10766 VSS.n10199 0.120292
R26230 VSS.n10767 VSS.n10766 0.120292
R26231 VSS.n10767 VSS.n10198 0.120292
R26232 VSS.n10198 VSS.n10193 0.120292
R26233 VSS.n10772 VSS.n10193 0.120292
R26234 VSS.n10773 VSS.n10772 0.120292
R26235 VSS.n10774 VSS.n10773 0.120292
R26236 VSS.n10774 VSS.n10191 0.120292
R26237 VSS.n10778 VSS.n10191 0.120292
R26238 VSS.n10779 VSS.n10778 0.120292
R26239 VSS.n10779 VSS.n10189 0.120292
R26240 VSS.n10785 VSS.n10189 0.120292
R26241 VSS.n10786 VSS.n10785 0.120292
R26242 VSS.n10786 VSS.n10184 0.120292
R26243 VSS.n10793 VSS.n10184 0.120292
R26244 VSS.n10794 VSS.n10793 0.120292
R26245 VSS.n10794 VSS.n10179 0.120292
R26246 VSS.n10802 VSS.n10179 0.120292
R26247 VSS.n10803 VSS.n10802 0.120292
R26248 VSS.n10804 VSS.n10803 0.120292
R26249 VSS.n10804 VSS.n10177 0.120292
R26250 VSS.n10808 VSS.n10177 0.120292
R26251 VSS.n10809 VSS.n10808 0.120292
R26252 VSS.n10810 VSS.n10809 0.120292
R26253 VSS.n10810 VSS.n10176 0.120292
R26254 VSS.n10821 VSS.n10820 0.120292
R26255 VSS.n10821 VSS.n10172 0.120292
R26256 VSS.n10172 VSS.n10168 0.120292
R26257 VSS.n10829 VSS.n10168 0.120292
R26258 VSS.n10830 VSS.n10829 0.120292
R26259 VSS.n10841 VSS.n10840 0.120292
R26260 VSS.n10842 VSS.n10841 0.120292
R26261 VSS.n10842 VSS.n10161 0.120292
R26262 VSS.n10850 VSS.n10161 0.120292
R26263 VSS.n10851 VSS.n10850 0.120292
R26264 VSS.n10852 VSS.n10851 0.120292
R26265 VSS.n10852 VSS.n10159 0.120292
R26266 VSS.n10856 VSS.n10159 0.120292
R26267 VSS.n10857 VSS.n10856 0.120292
R26268 VSS.n10857 VSS.n10158 0.120292
R26269 VSS.n10860 VSS.n10158 0.120292
R26270 VSS.n10861 VSS.n10860 0.120292
R26271 VSS.n10861 VSS.n10157 0.120292
R26272 VSS.n10157 VSS.n10149 0.120292
R26273 VSS.n10867 VSS.n10149 0.120292
R26274 VSS.n10868 VSS.n10867 0.120292
R26275 VSS.n10868 VSS.n10148 0.120292
R26276 VSS.n10148 VSS.n10143 0.120292
R26277 VSS.n10873 VSS.n10143 0.120292
R26278 VSS.n10874 VSS.n10873 0.120292
R26279 VSS.n10875 VSS.n10874 0.120292
R26280 VSS.n10875 VSS.n10141 0.120292
R26281 VSS.n10879 VSS.n10141 0.120292
R26282 VSS.n10880 VSS.n10879 0.120292
R26283 VSS.n10880 VSS.n10139 0.120292
R26284 VSS.n10886 VSS.n10139 0.120292
R26285 VSS.n10887 VSS.n10886 0.120292
R26286 VSS.n10887 VSS.n10134 0.120292
R26287 VSS.n10894 VSS.n10134 0.120292
R26288 VSS.n10895 VSS.n10894 0.120292
R26289 VSS.n10895 VSS.n10129 0.120292
R26290 VSS.n10903 VSS.n10129 0.120292
R26291 VSS.n10904 VSS.n10903 0.120292
R26292 VSS.n10905 VSS.n10904 0.120292
R26293 VSS.n10905 VSS.n10127 0.120292
R26294 VSS.n10909 VSS.n10127 0.120292
R26295 VSS.n10910 VSS.n10909 0.120292
R26296 VSS.n10911 VSS.n10910 0.120292
R26297 VSS.n10911 VSS.n10126 0.120292
R26298 VSS.n10922 VSS.n10921 0.120292
R26299 VSS.n10922 VSS.n10122 0.120292
R26300 VSS.n10122 VSS.n10118 0.120292
R26301 VSS.n10930 VSS.n10118 0.120292
R26302 VSS.n10931 VSS.n10930 0.120292
R26303 VSS.n10942 VSS.n10941 0.120292
R26304 VSS.n10943 VSS.n10942 0.120292
R26305 VSS.n10943 VSS.n10111 0.120292
R26306 VSS.n10951 VSS.n10111 0.120292
R26307 VSS.n10952 VSS.n10951 0.120292
R26308 VSS.n10953 VSS.n10952 0.120292
R26309 VSS.n10953 VSS.n10109 0.120292
R26310 VSS.n10957 VSS.n10109 0.120292
R26311 VSS.n10958 VSS.n10957 0.120292
R26312 VSS.n10958 VSS.n10108 0.120292
R26313 VSS.n10961 VSS.n10108 0.120292
R26314 VSS.n10962 VSS.n10961 0.120292
R26315 VSS.n10962 VSS.n10107 0.120292
R26316 VSS.n10107 VSS.n10099 0.120292
R26317 VSS.n10968 VSS.n10099 0.120292
R26318 VSS.n10969 VSS.n10968 0.120292
R26319 VSS.n10969 VSS.n10098 0.120292
R26320 VSS.n10098 VSS.n10093 0.120292
R26321 VSS.n10974 VSS.n10093 0.120292
R26322 VSS.n10975 VSS.n10974 0.120292
R26323 VSS.n10976 VSS.n10975 0.120292
R26324 VSS.n10976 VSS.n10091 0.120292
R26325 VSS.n10980 VSS.n10091 0.120292
R26326 VSS.n10981 VSS.n10980 0.120292
R26327 VSS.n10981 VSS.n10089 0.120292
R26328 VSS.n10987 VSS.n10089 0.120292
R26329 VSS.n10988 VSS.n10987 0.120292
R26330 VSS.n10988 VSS.n10084 0.120292
R26331 VSS.n10995 VSS.n10084 0.120292
R26332 VSS.n10996 VSS.n10995 0.120292
R26333 VSS.n10996 VSS.n10079 0.120292
R26334 VSS.n11004 VSS.n10079 0.120292
R26335 VSS.n11005 VSS.n11004 0.120292
R26336 VSS.n11006 VSS.n11005 0.120292
R26337 VSS.n11006 VSS.n10077 0.120292
R26338 VSS.n11010 VSS.n10077 0.120292
R26339 VSS.n11011 VSS.n11010 0.120292
R26340 VSS.n11011 VSS.n10076 0.120292
R26341 VSS.n11014 VSS.n10076 0.120292
R26342 VSS.n11036 VSS.n11018 0.120292
R26343 VSS.n11028 VSS.n11018 0.120292
R26344 VSS.n11028 VSS.n11027 0.120292
R26345 VSS.n11027 VSS.n11022 0.120292
R26346 VSS.n11023 VSS.n11022 0.120292
R26347 VSS.n11091 VSS.n19 0.120292
R26348 VSS.n11091 VSS.n11090 0.120292
R26349 VSS.n11090 VSS.n11089 0.120292
R26350 VSS.n11089 VSS.n10071 0.120292
R26351 VSS.n11081 VSS.n10071 0.120292
R26352 VSS.n11082 VSS.n11081 0.120292
R26353 VSS.n11082 VSS.n11080 0.120292
R26354 VSS.n11080 VSS.n11079 0.120292
R26355 VSS.n11079 VSS.n11042 0.120292
R26356 VSS.n11067 VSS.n11042 0.120292
R26357 VSS.n11068 VSS.n11067 0.120292
R26358 VSS.n11068 VSS.n11066 0.120292
R26359 VSS.n11066 VSS.n11047 0.120292
R26360 VSS.n11059 VSS.n11047 0.120292
R26361 VSS.n11059 VSS.n11058 0.120292
R26362 VSS.n11058 VSS.n11048 0.120292
R26363 VSS.n11055 VSS.n11048 0.120292
R26364 VSS.n11055 VSS.n11054 0.120292
R26365 VSS.n11054 VSS.n11053 0.120292
R26366 VSS.n11053 VSS.n11050 0.120292
R26367 VSS.n11831 VSS.n11824 0.120292
R26368 VSS.n11832 VSS.n11831 0.120292
R26369 VSS.n11832 VSS.n11823 0.120292
R26370 VSS.n11823 VSS.n11817 0.120292
R26371 VSS.n11840 VSS.n11817 0.120292
R26372 VSS.n11841 VSS.n11840 0.120292
R26373 VSS.n11842 VSS.n11841 0.120292
R26374 VSS.n11842 VSS.n11815 0.120292
R26375 VSS.n11846 VSS.n11815 0.120292
R26376 VSS.n11847 VSS.n11846 0.120292
R26377 VSS.n11848 VSS.n11847 0.120292
R26378 VSS.n11848 VSS.n11811 0.120292
R26379 VSS.n11854 VSS.n11811 0.120292
R26380 VSS.n11855 VSS.n11854 0.120292
R26381 VSS.n11855 VSS.n11810 0.120292
R26382 VSS.n11810 VSS.n11804 0.120292
R26383 VSS.n11863 VSS.n11804 0.120292
R26384 VSS.n11864 VSS.n11863 0.120292
R26385 VSS.n11865 VSS.n11864 0.120292
R26386 VSS.n11865 VSS.n11802 0.120292
R26387 VSS.n11869 VSS.n11802 0.120292
R26388 VSS.n11870 VSS.n11869 0.120292
R26389 VSS.n11877 VSS.n11876 0.120292
R26390 VSS.n11877 VSS.n1652 0.120292
R26391 VSS.n11881 VSS.n1652 0.120292
R26392 VSS.n1667 VSS.n1666 0.120292
R26393 VSS.n1668 VSS.n1667 0.120292
R26394 VSS.n1668 VSS.n1661 0.120292
R26395 VSS.n1673 VSS.n1658 0.120292
R26396 VSS.n11796 VSS.n1658 0.120292
R26397 VSS.n11797 VSS.n11796 0.120292
R26398 VSS.n11797 VSS.n1657 0.120292
R26399 VSS.n11784 VSS.n1657 0.120292
R26400 VSS.n11785 VSS.n11784 0.120292
R26401 VSS.n11785 VSS.n11783 0.120292
R26402 VSS.n11783 VSS.n11782 0.120292
R26403 VSS.n11782 VSS.n1677 0.120292
R26404 VSS.n11777 VSS.n1677 0.120292
R26405 VSS.n11777 VSS.n11776 0.120292
R26406 VSS.n11776 VSS.n1678 0.120292
R26407 VSS.n11772 VSS.n1678 0.120292
R26408 VSS.n11772 VSS.n11771 0.120292
R26409 VSS.n11771 VSS.n11770 0.120292
R26410 VSS.n11770 VSS.n1682 0.120292
R26411 VSS.n11757 VSS.n1682 0.120292
R26412 VSS.n11758 VSS.n11757 0.120292
R26413 VSS.n11758 VSS.n11756 0.120292
R26414 VSS.n11756 VSS.n1687 0.120292
R26415 VSS.n11748 VSS.n1687 0.120292
R26416 VSS.n11748 VSS.n11747 0.120292
R26417 VSS.n11747 VSS.n11746 0.120292
R26418 VSS.n11746 VSS.n1690 0.120292
R26419 VSS.n11743 VSS.n1690 0.120292
R26420 VSS.n11743 VSS.n11742 0.120292
R26421 VSS.n11742 VSS.n11741 0.120292
R26422 VSS.n11736 VSS.n1696 0.120292
R26423 VSS.n11728 VSS.n1696 0.120292
R26424 VSS.n11728 VSS.n11727 0.120292
R26425 VSS.n11727 VSS.n1700 0.120292
R26426 VSS.n11723 VSS.n1700 0.120292
R26427 VSS.n11721 VSS.n1702 0.120292
R26428 VSS.n11712 VSS.n1702 0.120292
R26429 VSS.n11712 VSS.n11711 0.120292
R26430 VSS.n11711 VSS.n11710 0.120292
R26431 VSS.n11710 VSS.n1709 0.120292
R26432 VSS.n11702 VSS.n1709 0.120292
R26433 VSS.n11702 VSS.n11701 0.120292
R26434 VSS.n11701 VSS.n1710 0.120292
R26435 VSS.n11698 VSS.n1710 0.120292
R26436 VSS.n11698 VSS.n11697 0.120292
R26437 VSS.n11697 VSS.n11696 0.120292
R26438 VSS.n11696 VSS.n1712 0.120292
R26439 VSS.n11688 VSS.n1712 0.120292
R26440 VSS.n11689 VSS.n11688 0.120292
R26441 VSS.n11689 VSS.n11687 0.120292
R26442 VSS.n11687 VSS.n11686 0.120292
R26443 VSS.n11686 VSS.n1717 0.120292
R26444 VSS.n11678 VSS.n1717 0.120292
R26445 VSS.n11678 VSS.n11677 0.120292
R26446 VSS.n11677 VSS.n11676 0.120292
R26447 VSS.n11676 VSS.n1719 0.120292
R26448 VSS.n11671 VSS.n1719 0.120292
R26449 VSS.n11671 VSS.n11670 0.120292
R26450 VSS.n11670 VSS.n1720 0.120292
R26451 VSS.n11666 VSS.n1720 0.120292
R26452 VSS.n11666 VSS.n11665 0.120292
R26453 VSS.n11665 VSS.n11664 0.120292
R26454 VSS.n11664 VSS.n1724 0.120292
R26455 VSS.n11651 VSS.n1724 0.120292
R26456 VSS.n11652 VSS.n11651 0.120292
R26457 VSS.n11652 VSS.n11650 0.120292
R26458 VSS.n11650 VSS.n1729 0.120292
R26459 VSS.n11642 VSS.n1729 0.120292
R26460 VSS.n11642 VSS.n11641 0.120292
R26461 VSS.n11641 VSS.n11640 0.120292
R26462 VSS.n11640 VSS.n1732 0.120292
R26463 VSS.n11637 VSS.n1732 0.120292
R26464 VSS.n11637 VSS.n11636 0.120292
R26465 VSS.n11636 VSS.n11635 0.120292
R26466 VSS.n11630 VSS.n1738 0.120292
R26467 VSS.n11622 VSS.n1738 0.120292
R26468 VSS.n11622 VSS.n11621 0.120292
R26469 VSS.n11621 VSS.n1742 0.120292
R26470 VSS.n11617 VSS.n1742 0.120292
R26471 VSS.n11615 VSS.n1744 0.120292
R26472 VSS.n11606 VSS.n1744 0.120292
R26473 VSS.n11606 VSS.n11605 0.120292
R26474 VSS.n11605 VSS.n11604 0.120292
R26475 VSS.n11604 VSS.n1751 0.120292
R26476 VSS.n11596 VSS.n1751 0.120292
R26477 VSS.n11596 VSS.n11595 0.120292
R26478 VSS.n11595 VSS.n1752 0.120292
R26479 VSS.n11592 VSS.n1752 0.120292
R26480 VSS.n11592 VSS.n11591 0.120292
R26481 VSS.n11591 VSS.n11590 0.120292
R26482 VSS.n11590 VSS.n1754 0.120292
R26483 VSS.n11582 VSS.n1754 0.120292
R26484 VSS.n11583 VSS.n11582 0.120292
R26485 VSS.n11583 VSS.n11581 0.120292
R26486 VSS.n11581 VSS.n11580 0.120292
R26487 VSS.n11580 VSS.n1759 0.120292
R26488 VSS.n11572 VSS.n1759 0.120292
R26489 VSS.n11572 VSS.n11571 0.120292
R26490 VSS.n11571 VSS.n11570 0.120292
R26491 VSS.n11570 VSS.n1761 0.120292
R26492 VSS.n11565 VSS.n1761 0.120292
R26493 VSS.n11565 VSS.n11564 0.120292
R26494 VSS.n11564 VSS.n1762 0.120292
R26495 VSS.n11560 VSS.n1762 0.120292
R26496 VSS.n11560 VSS.n11559 0.120292
R26497 VSS.n11559 VSS.n11558 0.120292
R26498 VSS.n11558 VSS.n1766 0.120292
R26499 VSS.n11545 VSS.n1766 0.120292
R26500 VSS.n11546 VSS.n11545 0.120292
R26501 VSS.n11546 VSS.n11544 0.120292
R26502 VSS.n11544 VSS.n1771 0.120292
R26503 VSS.n11536 VSS.n1771 0.120292
R26504 VSS.n11536 VSS.n11535 0.120292
R26505 VSS.n11535 VSS.n11534 0.120292
R26506 VSS.n11534 VSS.n1774 0.120292
R26507 VSS.n11531 VSS.n1774 0.120292
R26508 VSS.n11531 VSS.n11530 0.120292
R26509 VSS.n11530 VSS.n11529 0.120292
R26510 VSS.n11524 VSS.n1780 0.120292
R26511 VSS.n11516 VSS.n1780 0.120292
R26512 VSS.n11516 VSS.n11515 0.120292
R26513 VSS.n11515 VSS.n1784 0.120292
R26514 VSS.n11511 VSS.n1784 0.120292
R26515 VSS.n11509 VSS.n1786 0.120292
R26516 VSS.n11500 VSS.n1786 0.120292
R26517 VSS.n11500 VSS.n11499 0.120292
R26518 VSS.n11499 VSS.n11498 0.120292
R26519 VSS.n11498 VSS.n1793 0.120292
R26520 VSS.n11490 VSS.n1793 0.120292
R26521 VSS.n11490 VSS.n11489 0.120292
R26522 VSS.n11489 VSS.n1794 0.120292
R26523 VSS.n11486 VSS.n1794 0.120292
R26524 VSS.n11486 VSS.n11485 0.120292
R26525 VSS.n11485 VSS.n11484 0.120292
R26526 VSS.n11484 VSS.n1796 0.120292
R26527 VSS.n11476 VSS.n1796 0.120292
R26528 VSS.n11477 VSS.n11476 0.120292
R26529 VSS.n11477 VSS.n11475 0.120292
R26530 VSS.n11475 VSS.n11474 0.120292
R26531 VSS.n11474 VSS.n1801 0.120292
R26532 VSS.n11466 VSS.n1801 0.120292
R26533 VSS.n11466 VSS.n11465 0.120292
R26534 VSS.n11465 VSS.n11464 0.120292
R26535 VSS.n11464 VSS.n1803 0.120292
R26536 VSS.n11459 VSS.n1803 0.120292
R26537 VSS.n11459 VSS.n11458 0.120292
R26538 VSS.n11458 VSS.n1804 0.120292
R26539 VSS.n11454 VSS.n1804 0.120292
R26540 VSS.n11454 VSS.n11453 0.120292
R26541 VSS.n11453 VSS.n11452 0.120292
R26542 VSS.n11452 VSS.n1808 0.120292
R26543 VSS.n11439 VSS.n1808 0.120292
R26544 VSS.n11440 VSS.n11439 0.120292
R26545 VSS.n11440 VSS.n11438 0.120292
R26546 VSS.n11438 VSS.n1813 0.120292
R26547 VSS.n11430 VSS.n1813 0.120292
R26548 VSS.n11430 VSS.n11429 0.120292
R26549 VSS.n11429 VSS.n11428 0.120292
R26550 VSS.n11428 VSS.n1816 0.120292
R26551 VSS.n11425 VSS.n1816 0.120292
R26552 VSS.n11425 VSS.n11424 0.120292
R26553 VSS.n11424 VSS.n11423 0.120292
R26554 VSS.n11418 VSS.n1822 0.120292
R26555 VSS.n11410 VSS.n1822 0.120292
R26556 VSS.n11410 VSS.n11409 0.120292
R26557 VSS.n11409 VSS.n1826 0.120292
R26558 VSS.n11405 VSS.n1826 0.120292
R26559 VSS.n11403 VSS.n1828 0.120292
R26560 VSS.n11394 VSS.n1828 0.120292
R26561 VSS.n11394 VSS.n11393 0.120292
R26562 VSS.n11393 VSS.n11392 0.120292
R26563 VSS.n11392 VSS.n1835 0.120292
R26564 VSS.n11384 VSS.n1835 0.120292
R26565 VSS.n11384 VSS.n11383 0.120292
R26566 VSS.n11383 VSS.n1836 0.120292
R26567 VSS.n11380 VSS.n1836 0.120292
R26568 VSS.n11380 VSS.n11379 0.120292
R26569 VSS.n11379 VSS.n11378 0.120292
R26570 VSS.n11378 VSS.n1838 0.120292
R26571 VSS.n11370 VSS.n1838 0.120292
R26572 VSS.n11371 VSS.n11370 0.120292
R26573 VSS.n11371 VSS.n11369 0.120292
R26574 VSS.n11369 VSS.n11368 0.120292
R26575 VSS.n11368 VSS.n1843 0.120292
R26576 VSS.n11360 VSS.n1843 0.120292
R26577 VSS.n11360 VSS.n11359 0.120292
R26578 VSS.n11359 VSS.n11358 0.120292
R26579 VSS.n11358 VSS.n1845 0.120292
R26580 VSS.n11353 VSS.n1845 0.120292
R26581 VSS.n11353 VSS.n11352 0.120292
R26582 VSS.n11352 VSS.n1846 0.120292
R26583 VSS.n11348 VSS.n1846 0.120292
R26584 VSS.n11348 VSS.n11347 0.120292
R26585 VSS.n11347 VSS.n11346 0.120292
R26586 VSS.n11346 VSS.n1850 0.120292
R26587 VSS.n11333 VSS.n1850 0.120292
R26588 VSS.n11334 VSS.n11333 0.120292
R26589 VSS.n11334 VSS.n11332 0.120292
R26590 VSS.n11332 VSS.n1855 0.120292
R26591 VSS.n11324 VSS.n1855 0.120292
R26592 VSS.n11324 VSS.n11323 0.120292
R26593 VSS.n11323 VSS.n11322 0.120292
R26594 VSS.n11322 VSS.n1858 0.120292
R26595 VSS.n11319 VSS.n1858 0.120292
R26596 VSS.n11319 VSS.n11318 0.120292
R26597 VSS.n11318 VSS.n11317 0.120292
R26598 VSS.n11312 VSS.n1864 0.120292
R26599 VSS.n11304 VSS.n1864 0.120292
R26600 VSS.n11304 VSS.n11303 0.120292
R26601 VSS.n11303 VSS.n1868 0.120292
R26602 VSS.n11299 VSS.n1868 0.120292
R26603 VSS.n11297 VSS.n1870 0.120292
R26604 VSS.n11288 VSS.n1870 0.120292
R26605 VSS.n11288 VSS.n11287 0.120292
R26606 VSS.n11287 VSS.n11286 0.120292
R26607 VSS.n11286 VSS.n1877 0.120292
R26608 VSS.n11278 VSS.n1877 0.120292
R26609 VSS.n11278 VSS.n11277 0.120292
R26610 VSS.n11277 VSS.n1878 0.120292
R26611 VSS.n11274 VSS.n1878 0.120292
R26612 VSS.n11274 VSS.n11273 0.120292
R26613 VSS.n11273 VSS.n11272 0.120292
R26614 VSS.n11272 VSS.n1880 0.120292
R26615 VSS.n11264 VSS.n1880 0.120292
R26616 VSS.n11265 VSS.n11264 0.120292
R26617 VSS.n11265 VSS.n11263 0.120292
R26618 VSS.n11263 VSS.n11262 0.120292
R26619 VSS.n11262 VSS.n1885 0.120292
R26620 VSS.n11254 VSS.n1885 0.120292
R26621 VSS.n11254 VSS.n11253 0.120292
R26622 VSS.n11253 VSS.n11252 0.120292
R26623 VSS.n11252 VSS.n1887 0.120292
R26624 VSS.n11247 VSS.n1887 0.120292
R26625 VSS.n11247 VSS.n11246 0.120292
R26626 VSS.n11246 VSS.n1888 0.120292
R26627 VSS.n11242 VSS.n1888 0.120292
R26628 VSS.n11242 VSS.n11241 0.120292
R26629 VSS.n11241 VSS.n11240 0.120292
R26630 VSS.n11240 VSS.n1892 0.120292
R26631 VSS.n11227 VSS.n1892 0.120292
R26632 VSS.n11228 VSS.n11227 0.120292
R26633 VSS.n11228 VSS.n11226 0.120292
R26634 VSS.n11226 VSS.n1897 0.120292
R26635 VSS.n11218 VSS.n1897 0.120292
R26636 VSS.n11218 VSS.n11217 0.120292
R26637 VSS.n11217 VSS.n11216 0.120292
R26638 VSS.n11216 VSS.n1900 0.120292
R26639 VSS.n11213 VSS.n1900 0.120292
R26640 VSS.n11213 VSS.n11212 0.120292
R26641 VSS.n11212 VSS.n11211 0.120292
R26642 VSS.n11206 VSS.n1906 0.120292
R26643 VSS.n11198 VSS.n1906 0.120292
R26644 VSS.n11198 VSS.n11197 0.120292
R26645 VSS.n11197 VSS.n1910 0.120292
R26646 VSS.n11193 VSS.n1910 0.120292
R26647 VSS.n11177 VSS.n21 0.120292
R26648 VSS.n11177 VSS.n11176 0.120292
R26649 VSS.n11176 VSS.n11175 0.120292
R26650 VSS.n11175 VSS.n11112 0.120292
R26651 VSS.n11167 VSS.n11112 0.120292
R26652 VSS.n11168 VSS.n11167 0.120292
R26653 VSS.n11168 VSS.n11166 0.120292
R26654 VSS.n11166 VSS.n11165 0.120292
R26655 VSS.n11165 VSS.n11128 0.120292
R26656 VSS.n11153 VSS.n11128 0.120292
R26657 VSS.n11154 VSS.n11153 0.120292
R26658 VSS.n11154 VSS.n11152 0.120292
R26659 VSS.n11152 VSS.n11133 0.120292
R26660 VSS.n11145 VSS.n11133 0.120292
R26661 VSS.n11145 VSS.n11144 0.120292
R26662 VSS.n11144 VSS.n11134 0.120292
R26663 VSS.n11141 VSS.n11134 0.120292
R26664 VSS.n11141 VSS.n11140 0.120292
R26665 VSS.n11140 VSS.n11139 0.120292
R26666 VSS.n11139 VSS.n11136 0.120292
R26667 VSS.n12869 VSS.n12862 0.120292
R26668 VSS.n12870 VSS.n12869 0.120292
R26669 VSS.n12870 VSS.n12861 0.120292
R26670 VSS.n12861 VSS.n12855 0.120292
R26671 VSS.n12878 VSS.n12855 0.120292
R26672 VSS.n12879 VSS.n12878 0.120292
R26673 VSS.n12880 VSS.n12879 0.120292
R26674 VSS.n12880 VSS.n12853 0.120292
R26675 VSS.n12884 VSS.n12853 0.120292
R26676 VSS.n12885 VSS.n12884 0.120292
R26677 VSS.n12886 VSS.n12885 0.120292
R26678 VSS.n12886 VSS.n12849 0.120292
R26679 VSS.n12892 VSS.n12849 0.120292
R26680 VSS.n12893 VSS.n12892 0.120292
R26681 VSS.n12893 VSS.n12848 0.120292
R26682 VSS.n12848 VSS.n12842 0.120292
R26683 VSS.n12901 VSS.n12842 0.120292
R26684 VSS.n12902 VSS.n12901 0.120292
R26685 VSS.n12903 VSS.n12902 0.120292
R26686 VSS.n12903 VSS.n12840 0.120292
R26687 VSS.n12907 VSS.n12840 0.120292
R26688 VSS.n12908 VSS.n12907 0.120292
R26689 VSS.n12915 VSS.n12914 0.120292
R26690 VSS.n12915 VSS.n11886 0.120292
R26691 VSS.n12919 VSS.n11886 0.120292
R26692 VSS.n11901 VSS.n11900 0.120292
R26693 VSS.n11902 VSS.n11901 0.120292
R26694 VSS.n11902 VSS.n11895 0.120292
R26695 VSS.n11907 VSS.n11892 0.120292
R26696 VSS.n12834 VSS.n11892 0.120292
R26697 VSS.n12835 VSS.n12834 0.120292
R26698 VSS.n12835 VSS.n11891 0.120292
R26699 VSS.n12822 VSS.n11891 0.120292
R26700 VSS.n12823 VSS.n12822 0.120292
R26701 VSS.n12823 VSS.n12821 0.120292
R26702 VSS.n12821 VSS.n12820 0.120292
R26703 VSS.n12820 VSS.n11911 0.120292
R26704 VSS.n12815 VSS.n11911 0.120292
R26705 VSS.n12815 VSS.n12814 0.120292
R26706 VSS.n12814 VSS.n11912 0.120292
R26707 VSS.n12810 VSS.n11912 0.120292
R26708 VSS.n12810 VSS.n12809 0.120292
R26709 VSS.n12809 VSS.n12808 0.120292
R26710 VSS.n12808 VSS.n11916 0.120292
R26711 VSS.n12795 VSS.n11916 0.120292
R26712 VSS.n12796 VSS.n12795 0.120292
R26713 VSS.n12796 VSS.n12794 0.120292
R26714 VSS.n12794 VSS.n11921 0.120292
R26715 VSS.n12786 VSS.n11921 0.120292
R26716 VSS.n12786 VSS.n12785 0.120292
R26717 VSS.n12785 VSS.n12784 0.120292
R26718 VSS.n12784 VSS.n11924 0.120292
R26719 VSS.n12781 VSS.n11924 0.120292
R26720 VSS.n12781 VSS.n12780 0.120292
R26721 VSS.n12780 VSS.n12779 0.120292
R26722 VSS.n12774 VSS.n11930 0.120292
R26723 VSS.n12766 VSS.n11930 0.120292
R26724 VSS.n12766 VSS.n12765 0.120292
R26725 VSS.n12765 VSS.n11934 0.120292
R26726 VSS.n12761 VSS.n11934 0.120292
R26727 VSS.n12759 VSS.n11936 0.120292
R26728 VSS.n12750 VSS.n11936 0.120292
R26729 VSS.n12750 VSS.n12749 0.120292
R26730 VSS.n12749 VSS.n12748 0.120292
R26731 VSS.n12748 VSS.n11943 0.120292
R26732 VSS.n12740 VSS.n11943 0.120292
R26733 VSS.n12740 VSS.n12739 0.120292
R26734 VSS.n12739 VSS.n11944 0.120292
R26735 VSS.n12736 VSS.n11944 0.120292
R26736 VSS.n12736 VSS.n12735 0.120292
R26737 VSS.n12735 VSS.n12734 0.120292
R26738 VSS.n12734 VSS.n11946 0.120292
R26739 VSS.n12726 VSS.n11946 0.120292
R26740 VSS.n12727 VSS.n12726 0.120292
R26741 VSS.n12727 VSS.n12725 0.120292
R26742 VSS.n12725 VSS.n12724 0.120292
R26743 VSS.n12724 VSS.n11951 0.120292
R26744 VSS.n12716 VSS.n11951 0.120292
R26745 VSS.n12716 VSS.n12715 0.120292
R26746 VSS.n12715 VSS.n12714 0.120292
R26747 VSS.n12714 VSS.n11953 0.120292
R26748 VSS.n12709 VSS.n11953 0.120292
R26749 VSS.n12709 VSS.n12708 0.120292
R26750 VSS.n12708 VSS.n11954 0.120292
R26751 VSS.n12704 VSS.n11954 0.120292
R26752 VSS.n12704 VSS.n12703 0.120292
R26753 VSS.n12703 VSS.n12702 0.120292
R26754 VSS.n12702 VSS.n11958 0.120292
R26755 VSS.n12689 VSS.n11958 0.120292
R26756 VSS.n12690 VSS.n12689 0.120292
R26757 VSS.n12690 VSS.n12688 0.120292
R26758 VSS.n12688 VSS.n11963 0.120292
R26759 VSS.n12680 VSS.n11963 0.120292
R26760 VSS.n12680 VSS.n12679 0.120292
R26761 VSS.n12679 VSS.n12678 0.120292
R26762 VSS.n12678 VSS.n11966 0.120292
R26763 VSS.n12675 VSS.n11966 0.120292
R26764 VSS.n12675 VSS.n12674 0.120292
R26765 VSS.n12674 VSS.n12673 0.120292
R26766 VSS.n12668 VSS.n11972 0.120292
R26767 VSS.n12660 VSS.n11972 0.120292
R26768 VSS.n12660 VSS.n12659 0.120292
R26769 VSS.n12659 VSS.n11976 0.120292
R26770 VSS.n12655 VSS.n11976 0.120292
R26771 VSS.n12653 VSS.n11978 0.120292
R26772 VSS.n12644 VSS.n11978 0.120292
R26773 VSS.n12644 VSS.n12643 0.120292
R26774 VSS.n12643 VSS.n12642 0.120292
R26775 VSS.n12642 VSS.n11985 0.120292
R26776 VSS.n12634 VSS.n11985 0.120292
R26777 VSS.n12634 VSS.n12633 0.120292
R26778 VSS.n12633 VSS.n11986 0.120292
R26779 VSS.n12630 VSS.n11986 0.120292
R26780 VSS.n12630 VSS.n12629 0.120292
R26781 VSS.n12629 VSS.n12628 0.120292
R26782 VSS.n12628 VSS.n11988 0.120292
R26783 VSS.n12620 VSS.n11988 0.120292
R26784 VSS.n12621 VSS.n12620 0.120292
R26785 VSS.n12621 VSS.n12619 0.120292
R26786 VSS.n12619 VSS.n12618 0.120292
R26787 VSS.n12618 VSS.n11993 0.120292
R26788 VSS.n12610 VSS.n11993 0.120292
R26789 VSS.n12610 VSS.n12609 0.120292
R26790 VSS.n12609 VSS.n12608 0.120292
R26791 VSS.n12608 VSS.n11995 0.120292
R26792 VSS.n12603 VSS.n11995 0.120292
R26793 VSS.n12603 VSS.n12602 0.120292
R26794 VSS.n12602 VSS.n11996 0.120292
R26795 VSS.n12598 VSS.n11996 0.120292
R26796 VSS.n12598 VSS.n12597 0.120292
R26797 VSS.n12597 VSS.n12596 0.120292
R26798 VSS.n12596 VSS.n12000 0.120292
R26799 VSS.n12583 VSS.n12000 0.120292
R26800 VSS.n12584 VSS.n12583 0.120292
R26801 VSS.n12584 VSS.n12582 0.120292
R26802 VSS.n12582 VSS.n12005 0.120292
R26803 VSS.n12574 VSS.n12005 0.120292
R26804 VSS.n12574 VSS.n12573 0.120292
R26805 VSS.n12573 VSS.n12572 0.120292
R26806 VSS.n12572 VSS.n12008 0.120292
R26807 VSS.n12569 VSS.n12008 0.120292
R26808 VSS.n12569 VSS.n12568 0.120292
R26809 VSS.n12568 VSS.n12567 0.120292
R26810 VSS.n12562 VSS.n12014 0.120292
R26811 VSS.n12554 VSS.n12014 0.120292
R26812 VSS.n12554 VSS.n12553 0.120292
R26813 VSS.n12553 VSS.n12018 0.120292
R26814 VSS.n12549 VSS.n12018 0.120292
R26815 VSS.n12547 VSS.n12020 0.120292
R26816 VSS.n12538 VSS.n12020 0.120292
R26817 VSS.n12538 VSS.n12537 0.120292
R26818 VSS.n12537 VSS.n12536 0.120292
R26819 VSS.n12536 VSS.n12027 0.120292
R26820 VSS.n12528 VSS.n12027 0.120292
R26821 VSS.n12528 VSS.n12527 0.120292
R26822 VSS.n12527 VSS.n12028 0.120292
R26823 VSS.n12524 VSS.n12028 0.120292
R26824 VSS.n12524 VSS.n12523 0.120292
R26825 VSS.n12523 VSS.n12522 0.120292
R26826 VSS.n12522 VSS.n12030 0.120292
R26827 VSS.n12514 VSS.n12030 0.120292
R26828 VSS.n12515 VSS.n12514 0.120292
R26829 VSS.n12515 VSS.n12513 0.120292
R26830 VSS.n12513 VSS.n12512 0.120292
R26831 VSS.n12512 VSS.n12035 0.120292
R26832 VSS.n12504 VSS.n12035 0.120292
R26833 VSS.n12504 VSS.n12503 0.120292
R26834 VSS.n12503 VSS.n12502 0.120292
R26835 VSS.n12502 VSS.n12037 0.120292
R26836 VSS.n12497 VSS.n12037 0.120292
R26837 VSS.n12497 VSS.n12496 0.120292
R26838 VSS.n12496 VSS.n12038 0.120292
R26839 VSS.n12492 VSS.n12038 0.120292
R26840 VSS.n12492 VSS.n12491 0.120292
R26841 VSS.n12491 VSS.n12490 0.120292
R26842 VSS.n12490 VSS.n12042 0.120292
R26843 VSS.n12477 VSS.n12042 0.120292
R26844 VSS.n12478 VSS.n12477 0.120292
R26845 VSS.n12478 VSS.n12476 0.120292
R26846 VSS.n12476 VSS.n12047 0.120292
R26847 VSS.n12468 VSS.n12047 0.120292
R26848 VSS.n12468 VSS.n12467 0.120292
R26849 VSS.n12467 VSS.n12466 0.120292
R26850 VSS.n12466 VSS.n12050 0.120292
R26851 VSS.n12463 VSS.n12050 0.120292
R26852 VSS.n12463 VSS.n12462 0.120292
R26853 VSS.n12462 VSS.n12461 0.120292
R26854 VSS.n12456 VSS.n12056 0.120292
R26855 VSS.n12448 VSS.n12056 0.120292
R26856 VSS.n12448 VSS.n12447 0.120292
R26857 VSS.n12447 VSS.n12060 0.120292
R26858 VSS.n12443 VSS.n12060 0.120292
R26859 VSS.n12441 VSS.n12062 0.120292
R26860 VSS.n12432 VSS.n12062 0.120292
R26861 VSS.n12432 VSS.n12431 0.120292
R26862 VSS.n12431 VSS.n12430 0.120292
R26863 VSS.n12430 VSS.n12069 0.120292
R26864 VSS.n12422 VSS.n12069 0.120292
R26865 VSS.n12422 VSS.n12421 0.120292
R26866 VSS.n12421 VSS.n12070 0.120292
R26867 VSS.n12418 VSS.n12070 0.120292
R26868 VSS.n12418 VSS.n12417 0.120292
R26869 VSS.n12417 VSS.n12416 0.120292
R26870 VSS.n12416 VSS.n12072 0.120292
R26871 VSS.n12408 VSS.n12072 0.120292
R26872 VSS.n12409 VSS.n12408 0.120292
R26873 VSS.n12409 VSS.n12407 0.120292
R26874 VSS.n12407 VSS.n12406 0.120292
R26875 VSS.n12406 VSS.n12077 0.120292
R26876 VSS.n12398 VSS.n12077 0.120292
R26877 VSS.n12398 VSS.n12397 0.120292
R26878 VSS.n12397 VSS.n12396 0.120292
R26879 VSS.n12396 VSS.n12079 0.120292
R26880 VSS.n12391 VSS.n12079 0.120292
R26881 VSS.n12391 VSS.n12390 0.120292
R26882 VSS.n12390 VSS.n12080 0.120292
R26883 VSS.n12386 VSS.n12080 0.120292
R26884 VSS.n12386 VSS.n12385 0.120292
R26885 VSS.n12385 VSS.n12384 0.120292
R26886 VSS.n12384 VSS.n12084 0.120292
R26887 VSS.n12371 VSS.n12084 0.120292
R26888 VSS.n12372 VSS.n12371 0.120292
R26889 VSS.n12372 VSS.n12370 0.120292
R26890 VSS.n12370 VSS.n12089 0.120292
R26891 VSS.n12362 VSS.n12089 0.120292
R26892 VSS.n12362 VSS.n12361 0.120292
R26893 VSS.n12361 VSS.n12360 0.120292
R26894 VSS.n12360 VSS.n12092 0.120292
R26895 VSS.n12357 VSS.n12092 0.120292
R26896 VSS.n12357 VSS.n12356 0.120292
R26897 VSS.n12356 VSS.n12355 0.120292
R26898 VSS.n12350 VSS.n12098 0.120292
R26899 VSS.n12342 VSS.n12098 0.120292
R26900 VSS.n12342 VSS.n12341 0.120292
R26901 VSS.n12341 VSS.n12102 0.120292
R26902 VSS.n12337 VSS.n12102 0.120292
R26903 VSS.n12335 VSS.n12104 0.120292
R26904 VSS.n12326 VSS.n12104 0.120292
R26905 VSS.n12326 VSS.n12325 0.120292
R26906 VSS.n12325 VSS.n12324 0.120292
R26907 VSS.n12324 VSS.n12111 0.120292
R26908 VSS.n12316 VSS.n12111 0.120292
R26909 VSS.n12316 VSS.n12315 0.120292
R26910 VSS.n12315 VSS.n12112 0.120292
R26911 VSS.n12312 VSS.n12112 0.120292
R26912 VSS.n12312 VSS.n12311 0.120292
R26913 VSS.n12311 VSS.n12310 0.120292
R26914 VSS.n12310 VSS.n12114 0.120292
R26915 VSS.n12302 VSS.n12114 0.120292
R26916 VSS.n12303 VSS.n12302 0.120292
R26917 VSS.n12303 VSS.n12301 0.120292
R26918 VSS.n12301 VSS.n12300 0.120292
R26919 VSS.n12300 VSS.n12119 0.120292
R26920 VSS.n12292 VSS.n12119 0.120292
R26921 VSS.n12292 VSS.n12291 0.120292
R26922 VSS.n12291 VSS.n12290 0.120292
R26923 VSS.n12290 VSS.n12121 0.120292
R26924 VSS.n12285 VSS.n12121 0.120292
R26925 VSS.n12285 VSS.n12284 0.120292
R26926 VSS.n12284 VSS.n12122 0.120292
R26927 VSS.n12280 VSS.n12122 0.120292
R26928 VSS.n12280 VSS.n12279 0.120292
R26929 VSS.n12279 VSS.n12278 0.120292
R26930 VSS.n12278 VSS.n12126 0.120292
R26931 VSS.n12265 VSS.n12126 0.120292
R26932 VSS.n12266 VSS.n12265 0.120292
R26933 VSS.n12266 VSS.n12264 0.120292
R26934 VSS.n12264 VSS.n12131 0.120292
R26935 VSS.n12256 VSS.n12131 0.120292
R26936 VSS.n12256 VSS.n12255 0.120292
R26937 VSS.n12255 VSS.n12254 0.120292
R26938 VSS.n12254 VSS.n12134 0.120292
R26939 VSS.n12251 VSS.n12134 0.120292
R26940 VSS.n12251 VSS.n12250 0.120292
R26941 VSS.n12250 VSS.n12249 0.120292
R26942 VSS.n12244 VSS.n12140 0.120292
R26943 VSS.n12236 VSS.n12140 0.120292
R26944 VSS.n12236 VSS.n12235 0.120292
R26945 VSS.n12235 VSS.n12144 0.120292
R26946 VSS.n12231 VSS.n12144 0.120292
R26947 VSS.n12220 VSS.n23 0.120292
R26948 VSS.n12220 VSS.n12219 0.120292
R26949 VSS.n12219 VSS.n12218 0.120292
R26950 VSS.n12218 VSS.n12155 0.120292
R26951 VSS.n12210 VSS.n12155 0.120292
R26952 VSS.n12211 VSS.n12210 0.120292
R26953 VSS.n12211 VSS.n12209 0.120292
R26954 VSS.n12209 VSS.n12208 0.120292
R26955 VSS.n12208 VSS.n12171 0.120292
R26956 VSS.n12196 VSS.n12171 0.120292
R26957 VSS.n12197 VSS.n12196 0.120292
R26958 VSS.n12197 VSS.n12195 0.120292
R26959 VSS.n12195 VSS.n12176 0.120292
R26960 VSS.n12188 VSS.n12176 0.120292
R26961 VSS.n12188 VSS.n12187 0.120292
R26962 VSS.n12187 VSS.n12177 0.120292
R26963 VSS.n12184 VSS.n12177 0.120292
R26964 VSS.n12184 VSS.n12183 0.120292
R26965 VSS.n12183 VSS.n12182 0.120292
R26966 VSS.n12182 VSS.n12179 0.120292
R26967 VSS.n1599 VSS.n1598 0.120292
R26968 VSS.n1599 VSS.n1588 0.120292
R26969 VSS.n1607 VSS.n1588 0.120292
R26970 VSS.n1608 VSS.n1607 0.120292
R26971 VSS.n1609 VSS.n1608 0.120292
R26972 VSS.n1609 VSS.n1586 0.120292
R26973 VSS.n1613 VSS.n1586 0.120292
R26974 VSS.n1614 VSS.n1613 0.120292
R26975 VSS.n1615 VSS.n1614 0.120292
R26976 VSS.n1615 VSS.n1584 0.120292
R26977 VSS.n1619 VSS.n1584 0.120292
R26978 VSS.n1620 VSS.n1619 0.120292
R26979 VSS.n1621 VSS.n1620 0.120292
R26980 VSS.n1621 VSS.n1574 0.120292
R26981 VSS.n1629 VSS.n1574 0.120292
R26982 VSS.n1630 VSS.n1629 0.120292
R26983 VSS.n1631 VSS.n1630 0.120292
R26984 VSS.n1631 VSS.n1572 0.120292
R26985 VSS.n1635 VSS.n1572 0.120292
R26986 VSS.n1636 VSS.n1635 0.120292
R26987 VSS.n1637 VSS.n1636 0.120292
R26988 VSS.n1637 VSS.n1569 0.120292
R26989 VSS.n1647 VSS.n1646 0.120292
R26990 VSS.n1648 VSS.n1647 0.120292
R26991 VSS.n1648 VSS.n1566 0.120292
R26992 VSS.n12929 VSS.n12928 0.120292
R26993 VSS.n12930 VSS.n12929 0.120292
R26994 VSS.n12930 VSS.n1564 0.120292
R26995 VSS.n12935 VSS.n1563 0.120292
R26996 VSS.n1563 VSS.n1554 0.120292
R26997 VSS.n12941 VSS.n1554 0.120292
R26998 VSS.n12942 VSS.n12941 0.120292
R26999 VSS.n12942 VSS.n1553 0.120292
R27000 VSS.n1553 VSS.n1548 0.120292
R27001 VSS.n12947 VSS.n1548 0.120292
R27002 VSS.n12948 VSS.n12947 0.120292
R27003 VSS.n12949 VSS.n12948 0.120292
R27004 VSS.n12949 VSS.n1546 0.120292
R27005 VSS.n12953 VSS.n1546 0.120292
R27006 VSS.n12954 VSS.n12953 0.120292
R27007 VSS.n12954 VSS.n1544 0.120292
R27008 VSS.n12960 VSS.n1544 0.120292
R27009 VSS.n12961 VSS.n12960 0.120292
R27010 VSS.n12961 VSS.n1539 0.120292
R27011 VSS.n12968 VSS.n1539 0.120292
R27012 VSS.n12969 VSS.n12968 0.120292
R27013 VSS.n12969 VSS.n1534 0.120292
R27014 VSS.n12977 VSS.n1534 0.120292
R27015 VSS.n12978 VSS.n12977 0.120292
R27016 VSS.n12979 VSS.n12978 0.120292
R27017 VSS.n12979 VSS.n1532 0.120292
R27018 VSS.n12983 VSS.n1532 0.120292
R27019 VSS.n12984 VSS.n12983 0.120292
R27020 VSS.n12985 VSS.n12984 0.120292
R27021 VSS.n12985 VSS.n1531 0.120292
R27022 VSS.n12996 VSS.n12995 0.120292
R27023 VSS.n12996 VSS.n1527 0.120292
R27024 VSS.n1527 VSS.n1523 0.120292
R27025 VSS.n13004 VSS.n1523 0.120292
R27026 VSS.n13005 VSS.n13004 0.120292
R27027 VSS.n13016 VSS.n13015 0.120292
R27028 VSS.n13017 VSS.n13016 0.120292
R27029 VSS.n13017 VSS.n1516 0.120292
R27030 VSS.n13025 VSS.n1516 0.120292
R27031 VSS.n13026 VSS.n13025 0.120292
R27032 VSS.n13027 VSS.n13026 0.120292
R27033 VSS.n13027 VSS.n1514 0.120292
R27034 VSS.n13031 VSS.n1514 0.120292
R27035 VSS.n13032 VSS.n13031 0.120292
R27036 VSS.n13032 VSS.n1513 0.120292
R27037 VSS.n13035 VSS.n1513 0.120292
R27038 VSS.n13036 VSS.n13035 0.120292
R27039 VSS.n13036 VSS.n1512 0.120292
R27040 VSS.n1512 VSS.n1504 0.120292
R27041 VSS.n13042 VSS.n1504 0.120292
R27042 VSS.n13043 VSS.n13042 0.120292
R27043 VSS.n13043 VSS.n1503 0.120292
R27044 VSS.n1503 VSS.n1498 0.120292
R27045 VSS.n13048 VSS.n1498 0.120292
R27046 VSS.n13049 VSS.n13048 0.120292
R27047 VSS.n13050 VSS.n13049 0.120292
R27048 VSS.n13050 VSS.n1496 0.120292
R27049 VSS.n13054 VSS.n1496 0.120292
R27050 VSS.n13055 VSS.n13054 0.120292
R27051 VSS.n13055 VSS.n1494 0.120292
R27052 VSS.n13061 VSS.n1494 0.120292
R27053 VSS.n13062 VSS.n13061 0.120292
R27054 VSS.n13062 VSS.n1489 0.120292
R27055 VSS.n13069 VSS.n1489 0.120292
R27056 VSS.n13070 VSS.n13069 0.120292
R27057 VSS.n13070 VSS.n1484 0.120292
R27058 VSS.n13078 VSS.n1484 0.120292
R27059 VSS.n13079 VSS.n13078 0.120292
R27060 VSS.n13080 VSS.n13079 0.120292
R27061 VSS.n13080 VSS.n1482 0.120292
R27062 VSS.n13084 VSS.n1482 0.120292
R27063 VSS.n13085 VSS.n13084 0.120292
R27064 VSS.n13086 VSS.n13085 0.120292
R27065 VSS.n13086 VSS.n1481 0.120292
R27066 VSS.n13097 VSS.n13096 0.120292
R27067 VSS.n13097 VSS.n1477 0.120292
R27068 VSS.n1477 VSS.n1473 0.120292
R27069 VSS.n13105 VSS.n1473 0.120292
R27070 VSS.n13106 VSS.n13105 0.120292
R27071 VSS.n13117 VSS.n13116 0.120292
R27072 VSS.n13118 VSS.n13117 0.120292
R27073 VSS.n13118 VSS.n1466 0.120292
R27074 VSS.n13126 VSS.n1466 0.120292
R27075 VSS.n13127 VSS.n13126 0.120292
R27076 VSS.n13128 VSS.n13127 0.120292
R27077 VSS.n13128 VSS.n1464 0.120292
R27078 VSS.n13132 VSS.n1464 0.120292
R27079 VSS.n13133 VSS.n13132 0.120292
R27080 VSS.n13133 VSS.n1463 0.120292
R27081 VSS.n13136 VSS.n1463 0.120292
R27082 VSS.n13137 VSS.n13136 0.120292
R27083 VSS.n13137 VSS.n1462 0.120292
R27084 VSS.n1462 VSS.n1454 0.120292
R27085 VSS.n13143 VSS.n1454 0.120292
R27086 VSS.n13144 VSS.n13143 0.120292
R27087 VSS.n13144 VSS.n1453 0.120292
R27088 VSS.n1453 VSS.n1448 0.120292
R27089 VSS.n13149 VSS.n1448 0.120292
R27090 VSS.n13150 VSS.n13149 0.120292
R27091 VSS.n13151 VSS.n13150 0.120292
R27092 VSS.n13151 VSS.n1446 0.120292
R27093 VSS.n13155 VSS.n1446 0.120292
R27094 VSS.n13156 VSS.n13155 0.120292
R27095 VSS.n13156 VSS.n1444 0.120292
R27096 VSS.n13162 VSS.n1444 0.120292
R27097 VSS.n13163 VSS.n13162 0.120292
R27098 VSS.n13163 VSS.n1439 0.120292
R27099 VSS.n13170 VSS.n1439 0.120292
R27100 VSS.n13171 VSS.n13170 0.120292
R27101 VSS.n13171 VSS.n1434 0.120292
R27102 VSS.n13179 VSS.n1434 0.120292
R27103 VSS.n13180 VSS.n13179 0.120292
R27104 VSS.n13181 VSS.n13180 0.120292
R27105 VSS.n13181 VSS.n1432 0.120292
R27106 VSS.n13185 VSS.n1432 0.120292
R27107 VSS.n13186 VSS.n13185 0.120292
R27108 VSS.n13187 VSS.n13186 0.120292
R27109 VSS.n13187 VSS.n1431 0.120292
R27110 VSS.n13198 VSS.n13197 0.120292
R27111 VSS.n13198 VSS.n1427 0.120292
R27112 VSS.n1427 VSS.n1423 0.120292
R27113 VSS.n13206 VSS.n1423 0.120292
R27114 VSS.n13207 VSS.n13206 0.120292
R27115 VSS.n13218 VSS.n13217 0.120292
R27116 VSS.n13219 VSS.n13218 0.120292
R27117 VSS.n13219 VSS.n1416 0.120292
R27118 VSS.n13227 VSS.n1416 0.120292
R27119 VSS.n13228 VSS.n13227 0.120292
R27120 VSS.n13229 VSS.n13228 0.120292
R27121 VSS.n13229 VSS.n1414 0.120292
R27122 VSS.n13233 VSS.n1414 0.120292
R27123 VSS.n13234 VSS.n13233 0.120292
R27124 VSS.n13234 VSS.n1413 0.120292
R27125 VSS.n13237 VSS.n1413 0.120292
R27126 VSS.n13238 VSS.n13237 0.120292
R27127 VSS.n13238 VSS.n1412 0.120292
R27128 VSS.n1412 VSS.n1404 0.120292
R27129 VSS.n13244 VSS.n1404 0.120292
R27130 VSS.n13245 VSS.n13244 0.120292
R27131 VSS.n13245 VSS.n1403 0.120292
R27132 VSS.n1403 VSS.n1398 0.120292
R27133 VSS.n13250 VSS.n1398 0.120292
R27134 VSS.n13251 VSS.n13250 0.120292
R27135 VSS.n13252 VSS.n13251 0.120292
R27136 VSS.n13252 VSS.n1396 0.120292
R27137 VSS.n13256 VSS.n1396 0.120292
R27138 VSS.n13257 VSS.n13256 0.120292
R27139 VSS.n13257 VSS.n1394 0.120292
R27140 VSS.n13263 VSS.n1394 0.120292
R27141 VSS.n13264 VSS.n13263 0.120292
R27142 VSS.n13264 VSS.n1389 0.120292
R27143 VSS.n13271 VSS.n1389 0.120292
R27144 VSS.n13272 VSS.n13271 0.120292
R27145 VSS.n13272 VSS.n1384 0.120292
R27146 VSS.n13280 VSS.n1384 0.120292
R27147 VSS.n13281 VSS.n13280 0.120292
R27148 VSS.n13282 VSS.n13281 0.120292
R27149 VSS.n13282 VSS.n1382 0.120292
R27150 VSS.n13286 VSS.n1382 0.120292
R27151 VSS.n13287 VSS.n13286 0.120292
R27152 VSS.n13288 VSS.n13287 0.120292
R27153 VSS.n13288 VSS.n1381 0.120292
R27154 VSS.n13299 VSS.n13298 0.120292
R27155 VSS.n13299 VSS.n1377 0.120292
R27156 VSS.n1377 VSS.n1373 0.120292
R27157 VSS.n13307 VSS.n1373 0.120292
R27158 VSS.n13308 VSS.n13307 0.120292
R27159 VSS.n13319 VSS.n13318 0.120292
R27160 VSS.n13320 VSS.n13319 0.120292
R27161 VSS.n13320 VSS.n1366 0.120292
R27162 VSS.n13328 VSS.n1366 0.120292
R27163 VSS.n13329 VSS.n13328 0.120292
R27164 VSS.n13330 VSS.n13329 0.120292
R27165 VSS.n13330 VSS.n1364 0.120292
R27166 VSS.n13334 VSS.n1364 0.120292
R27167 VSS.n13335 VSS.n13334 0.120292
R27168 VSS.n13335 VSS.n1363 0.120292
R27169 VSS.n13338 VSS.n1363 0.120292
R27170 VSS.n13339 VSS.n13338 0.120292
R27171 VSS.n13339 VSS.n1362 0.120292
R27172 VSS.n1362 VSS.n1354 0.120292
R27173 VSS.n13345 VSS.n1354 0.120292
R27174 VSS.n13346 VSS.n13345 0.120292
R27175 VSS.n13346 VSS.n1353 0.120292
R27176 VSS.n1353 VSS.n1348 0.120292
R27177 VSS.n13351 VSS.n1348 0.120292
R27178 VSS.n13352 VSS.n13351 0.120292
R27179 VSS.n13353 VSS.n13352 0.120292
R27180 VSS.n13353 VSS.n1346 0.120292
R27181 VSS.n13357 VSS.n1346 0.120292
R27182 VSS.n13358 VSS.n13357 0.120292
R27183 VSS.n13358 VSS.n1344 0.120292
R27184 VSS.n13364 VSS.n1344 0.120292
R27185 VSS.n13365 VSS.n13364 0.120292
R27186 VSS.n13365 VSS.n1339 0.120292
R27187 VSS.n13372 VSS.n1339 0.120292
R27188 VSS.n13373 VSS.n13372 0.120292
R27189 VSS.n13373 VSS.n1334 0.120292
R27190 VSS.n13381 VSS.n1334 0.120292
R27191 VSS.n13382 VSS.n13381 0.120292
R27192 VSS.n13383 VSS.n13382 0.120292
R27193 VSS.n13383 VSS.n1332 0.120292
R27194 VSS.n13387 VSS.n1332 0.120292
R27195 VSS.n13388 VSS.n13387 0.120292
R27196 VSS.n13389 VSS.n13388 0.120292
R27197 VSS.n13389 VSS.n1331 0.120292
R27198 VSS.n13400 VSS.n13399 0.120292
R27199 VSS.n13400 VSS.n1327 0.120292
R27200 VSS.n1327 VSS.n1323 0.120292
R27201 VSS.n13408 VSS.n1323 0.120292
R27202 VSS.n13409 VSS.n13408 0.120292
R27203 VSS.n13420 VSS.n13419 0.120292
R27204 VSS.n13421 VSS.n13420 0.120292
R27205 VSS.n13421 VSS.n1316 0.120292
R27206 VSS.n13429 VSS.n1316 0.120292
R27207 VSS.n13430 VSS.n13429 0.120292
R27208 VSS.n13431 VSS.n13430 0.120292
R27209 VSS.n13431 VSS.n1314 0.120292
R27210 VSS.n13435 VSS.n1314 0.120292
R27211 VSS.n13436 VSS.n13435 0.120292
R27212 VSS.n13436 VSS.n1313 0.120292
R27213 VSS.n13439 VSS.n1313 0.120292
R27214 VSS.n13440 VSS.n13439 0.120292
R27215 VSS.n13440 VSS.n1312 0.120292
R27216 VSS.n1312 VSS.n1304 0.120292
R27217 VSS.n13446 VSS.n1304 0.120292
R27218 VSS.n13447 VSS.n13446 0.120292
R27219 VSS.n13447 VSS.n1303 0.120292
R27220 VSS.n1303 VSS.n1298 0.120292
R27221 VSS.n13452 VSS.n1298 0.120292
R27222 VSS.n13453 VSS.n13452 0.120292
R27223 VSS.n13454 VSS.n13453 0.120292
R27224 VSS.n13454 VSS.n1296 0.120292
R27225 VSS.n13458 VSS.n1296 0.120292
R27226 VSS.n13459 VSS.n13458 0.120292
R27227 VSS.n13459 VSS.n1294 0.120292
R27228 VSS.n13465 VSS.n1294 0.120292
R27229 VSS.n13466 VSS.n13465 0.120292
R27230 VSS.n13466 VSS.n1289 0.120292
R27231 VSS.n13473 VSS.n1289 0.120292
R27232 VSS.n13474 VSS.n13473 0.120292
R27233 VSS.n13474 VSS.n1284 0.120292
R27234 VSS.n13482 VSS.n1284 0.120292
R27235 VSS.n13483 VSS.n13482 0.120292
R27236 VSS.n13484 VSS.n13483 0.120292
R27237 VSS.n13484 VSS.n1282 0.120292
R27238 VSS.n13488 VSS.n1282 0.120292
R27239 VSS.n13489 VSS.n13488 0.120292
R27240 VSS.n13489 VSS.n1281 0.120292
R27241 VSS.n13492 VSS.n1281 0.120292
R27242 VSS.n13514 VSS.n13496 0.120292
R27243 VSS.n13506 VSS.n13496 0.120292
R27244 VSS.n13506 VSS.n13505 0.120292
R27245 VSS.n13505 VSS.n13500 0.120292
R27246 VSS.n13501 VSS.n13500 0.120292
R27247 VSS.n13569 VSS.n25 0.120292
R27248 VSS.n13569 VSS.n13568 0.120292
R27249 VSS.n13568 VSS.n13567 0.120292
R27250 VSS.n13567 VSS.n1276 0.120292
R27251 VSS.n13559 VSS.n1276 0.120292
R27252 VSS.n13560 VSS.n13559 0.120292
R27253 VSS.n13560 VSS.n13558 0.120292
R27254 VSS.n13558 VSS.n13557 0.120292
R27255 VSS.n13557 VSS.n13520 0.120292
R27256 VSS.n13545 VSS.n13520 0.120292
R27257 VSS.n13546 VSS.n13545 0.120292
R27258 VSS.n13546 VSS.n13544 0.120292
R27259 VSS.n13544 VSS.n13525 0.120292
R27260 VSS.n13537 VSS.n13525 0.120292
R27261 VSS.n13537 VSS.n13536 0.120292
R27262 VSS.n13536 VSS.n13526 0.120292
R27263 VSS.n13533 VSS.n13526 0.120292
R27264 VSS.n13533 VSS.n13532 0.120292
R27265 VSS.n13532 VSS.n13531 0.120292
R27266 VSS.n13531 VSS.n13528 0.120292
R27267 VSS.n13881 VSS.n13880 0.120292
R27268 VSS.n13881 VSS.n13870 0.120292
R27269 VSS.n13889 VSS.n13870 0.120292
R27270 VSS.n13890 VSS.n13889 0.120292
R27271 VSS.n13891 VSS.n13890 0.120292
R27272 VSS.n13891 VSS.n13868 0.120292
R27273 VSS.n13895 VSS.n13868 0.120292
R27274 VSS.n13896 VSS.n13895 0.120292
R27275 VSS.n13897 VSS.n13896 0.120292
R27276 VSS.n13897 VSS.n13866 0.120292
R27277 VSS.n13901 VSS.n13866 0.120292
R27278 VSS.n13902 VSS.n13901 0.120292
R27279 VSS.n13903 VSS.n13902 0.120292
R27280 VSS.n13903 VSS.n13856 0.120292
R27281 VSS.n13911 VSS.n13856 0.120292
R27282 VSS.n13912 VSS.n13911 0.120292
R27283 VSS.n13913 VSS.n13912 0.120292
R27284 VSS.n13913 VSS.n13854 0.120292
R27285 VSS.n13917 VSS.n13854 0.120292
R27286 VSS.n13918 VSS.n13917 0.120292
R27287 VSS.n13919 VSS.n13918 0.120292
R27288 VSS.n13919 VSS.n13851 0.120292
R27289 VSS.n13929 VSS.n13928 0.120292
R27290 VSS.n13930 VSS.n13929 0.120292
R27291 VSS.n13930 VSS.n13848 0.120292
R27292 VSS.n13938 VSS.n13937 0.120292
R27293 VSS.n13939 VSS.n13938 0.120292
R27294 VSS.n13939 VSS.n13846 0.120292
R27295 VSS.n13944 VSS.n13845 0.120292
R27296 VSS.n13845 VSS.n13836 0.120292
R27297 VSS.n13950 VSS.n13836 0.120292
R27298 VSS.n13951 VSS.n13950 0.120292
R27299 VSS.n13951 VSS.n13835 0.120292
R27300 VSS.n13835 VSS.n13830 0.120292
R27301 VSS.n13956 VSS.n13830 0.120292
R27302 VSS.n13957 VSS.n13956 0.120292
R27303 VSS.n13958 VSS.n13957 0.120292
R27304 VSS.n13958 VSS.n13828 0.120292
R27305 VSS.n13962 VSS.n13828 0.120292
R27306 VSS.n13963 VSS.n13962 0.120292
R27307 VSS.n13963 VSS.n13826 0.120292
R27308 VSS.n13969 VSS.n13826 0.120292
R27309 VSS.n13970 VSS.n13969 0.120292
R27310 VSS.n13970 VSS.n13821 0.120292
R27311 VSS.n13977 VSS.n13821 0.120292
R27312 VSS.n13978 VSS.n13977 0.120292
R27313 VSS.n13978 VSS.n13816 0.120292
R27314 VSS.n13986 VSS.n13816 0.120292
R27315 VSS.n13987 VSS.n13986 0.120292
R27316 VSS.n13988 VSS.n13987 0.120292
R27317 VSS.n13988 VSS.n13814 0.120292
R27318 VSS.n13992 VSS.n13814 0.120292
R27319 VSS.n13993 VSS.n13992 0.120292
R27320 VSS.n13994 VSS.n13993 0.120292
R27321 VSS.n13994 VSS.n13813 0.120292
R27322 VSS.n14005 VSS.n14004 0.120292
R27323 VSS.n14005 VSS.n13809 0.120292
R27324 VSS.n13809 VSS.n13805 0.120292
R27325 VSS.n14013 VSS.n13805 0.120292
R27326 VSS.n14014 VSS.n14013 0.120292
R27327 VSS.n14025 VSS.n14024 0.120292
R27328 VSS.n14026 VSS.n14025 0.120292
R27329 VSS.n14026 VSS.n13798 0.120292
R27330 VSS.n14034 VSS.n13798 0.120292
R27331 VSS.n14035 VSS.n14034 0.120292
R27332 VSS.n14036 VSS.n14035 0.120292
R27333 VSS.n14036 VSS.n13796 0.120292
R27334 VSS.n14040 VSS.n13796 0.120292
R27335 VSS.n14041 VSS.n14040 0.120292
R27336 VSS.n14041 VSS.n13795 0.120292
R27337 VSS.n14044 VSS.n13795 0.120292
R27338 VSS.n14045 VSS.n14044 0.120292
R27339 VSS.n14045 VSS.n13794 0.120292
R27340 VSS.n13794 VSS.n13786 0.120292
R27341 VSS.n14051 VSS.n13786 0.120292
R27342 VSS.n14052 VSS.n14051 0.120292
R27343 VSS.n14052 VSS.n13785 0.120292
R27344 VSS.n13785 VSS.n13780 0.120292
R27345 VSS.n14057 VSS.n13780 0.120292
R27346 VSS.n14058 VSS.n14057 0.120292
R27347 VSS.n14059 VSS.n14058 0.120292
R27348 VSS.n14059 VSS.n13778 0.120292
R27349 VSS.n14063 VSS.n13778 0.120292
R27350 VSS.n14064 VSS.n14063 0.120292
R27351 VSS.n14064 VSS.n13776 0.120292
R27352 VSS.n14070 VSS.n13776 0.120292
R27353 VSS.n14071 VSS.n14070 0.120292
R27354 VSS.n14071 VSS.n13771 0.120292
R27355 VSS.n14078 VSS.n13771 0.120292
R27356 VSS.n14079 VSS.n14078 0.120292
R27357 VSS.n14079 VSS.n13766 0.120292
R27358 VSS.n14087 VSS.n13766 0.120292
R27359 VSS.n14088 VSS.n14087 0.120292
R27360 VSS.n14089 VSS.n14088 0.120292
R27361 VSS.n14089 VSS.n13764 0.120292
R27362 VSS.n14093 VSS.n13764 0.120292
R27363 VSS.n14094 VSS.n14093 0.120292
R27364 VSS.n14095 VSS.n14094 0.120292
R27365 VSS.n14095 VSS.n13763 0.120292
R27366 VSS.n14106 VSS.n14105 0.120292
R27367 VSS.n14106 VSS.n13759 0.120292
R27368 VSS.n13759 VSS.n13755 0.120292
R27369 VSS.n14114 VSS.n13755 0.120292
R27370 VSS.n14115 VSS.n14114 0.120292
R27371 VSS.n14126 VSS.n14125 0.120292
R27372 VSS.n14127 VSS.n14126 0.120292
R27373 VSS.n14127 VSS.n13748 0.120292
R27374 VSS.n14135 VSS.n13748 0.120292
R27375 VSS.n14136 VSS.n14135 0.120292
R27376 VSS.n14137 VSS.n14136 0.120292
R27377 VSS.n14137 VSS.n13746 0.120292
R27378 VSS.n14141 VSS.n13746 0.120292
R27379 VSS.n14142 VSS.n14141 0.120292
R27380 VSS.n14142 VSS.n13745 0.120292
R27381 VSS.n14145 VSS.n13745 0.120292
R27382 VSS.n14146 VSS.n14145 0.120292
R27383 VSS.n14146 VSS.n13743 0.120292
R27384 VSS.n14212 VSS.n13743 0.120292
R27385 VSS.n14213 VSS.n14212 0.120292
R27386 VSS.n14213 VSS.n13742 0.120292
R27387 VSS.n14198 VSS.n13742 0.120292
R27388 VSS.n14199 VSS.n14198 0.120292
R27389 VSS.n14199 VSS.n14197 0.120292
R27390 VSS.n14197 VSS.n14151 0.120292
R27391 VSS.n14189 VSS.n14151 0.120292
R27392 VSS.n14189 VSS.n14188 0.120292
R27393 VSS.n14188 VSS.n14187 0.120292
R27394 VSS.n14187 VSS.n14154 0.120292
R27395 VSS.n14184 VSS.n14154 0.120292
R27396 VSS.n14184 VSS.n14183 0.120292
R27397 VSS.n14183 VSS.n14182 0.120292
R27398 VSS.n14177 VSS.n14176 0.120292
R27399 VSS.n14176 VSS.n129 0.120292
R27400 VSS.n14168 VSS.n129 0.120292
R27401 VSS.n14168 VSS.n14167 0.120292
R27402 VSS.n14167 VSS.n14166 0.120292
R27403 VSS.n14166 VSS.n14159 0.120292
R27404 VSS.n14220 VSS.n13733 0.120292
R27405 VSS.n14228 VSS.n13733 0.120292
R27406 VSS.n14229 VSS.n14228 0.120292
R27407 VSS.n14230 VSS.n14229 0.120292
R27408 VSS.n14230 VSS.n13731 0.120292
R27409 VSS.n14234 VSS.n13731 0.120292
R27410 VSS.n14235 VSS.n14234 0.120292
R27411 VSS.n14236 VSS.n14235 0.120292
R27412 VSS.n14236 VSS.n13729 0.120292
R27413 VSS.n14240 VSS.n13729 0.120292
R27414 VSS.n14241 VSS.n14240 0.120292
R27415 VSS.n14241 VSS.n13728 0.120292
R27416 VSS.n14245 VSS.n13728 0.120292
R27417 VSS.n14246 VSS.n14245 0.120292
R27418 VSS.n14246 VSS.n13727 0.120292
R27419 VSS.n14250 VSS.n13727 0.120292
R27420 VSS.n14251 VSS.n14250 0.120292
R27421 VSS.n14251 VSS.n13726 0.120292
R27422 VSS.n13726 VSS.n13723 0.120292
R27423 VSS.n14258 VSS.n13723 0.120292
R27424 VSS.n14259 VSS.n14258 0.120292
R27425 VSS.n14260 VSS.n14259 0.120292
R27426 VSS.n14260 VSS.n13721 0.120292
R27427 VSS.n14263 VSS.n13721 0.120292
R27428 VSS.n14264 VSS.n14263 0.120292
R27429 VSS.n14265 VSS.n14264 0.120292
R27430 VSS.n14265 VSS.n13719 0.120292
R27431 VSS.n14270 VSS.n13719 0.120292
R27432 VSS.n14271 VSS.n14270 0.120292
R27433 VSS.n14271 VSS.n13718 0.120292
R27434 VSS.n13718 VSS.n13713 0.120292
R27435 VSS.n14277 VSS.n13713 0.120292
R27436 VSS.n14278 VSS.n14277 0.120292
R27437 VSS.n14279 VSS.n14278 0.120292
R27438 VSS.n14279 VSS.n13711 0.120292
R27439 VSS.n14283 VSS.n13711 0.120292
R27440 VSS.n14284 VSS.n14283 0.120292
R27441 VSS.n14285 VSS.n14284 0.120292
R27442 VSS.n14285 VSS.n13709 0.120292
R27443 VSS.n14288 VSS.n13709 0.120292
R27444 VSS.n14289 VSS.n14288 0.120292
R27445 VSS.n14290 VSS.n14289 0.120292
R27446 VSS.n14290 VSS.n13707 0.120292
R27447 VSS.n14293 VSS.n13707 0.120292
R27448 VSS.n14294 VSS.n14293 0.120292
R27449 VSS.n14294 VSS.n13706 0.120292
R27450 VSS.n14300 VSS.n13706 0.120292
R27451 VSS.n14301 VSS.n14300 0.120292
R27452 VSS.n14301 VSS.n13705 0.120292
R27453 VSS.n13705 VSS.n13701 0.120292
R27454 VSS.n14309 VSS.n13701 0.120292
R27455 VSS.n14310 VSS.n14309 0.120292
R27456 VSS.n14311 VSS.n14310 0.120292
R27457 VSS.n13693 VSS.n13670 0.120292
R27458 VSS.n13693 VSS.n13692 0.120292
R27459 VSS.n13692 VSS.n13671 0.120292
R27460 VSS.n13686 VSS.n13675 0.120292
R27461 VSS.n13682 VSS.n13675 0.120292
R27462 VSS.n13682 VSS.n13681 0.120292
R27463 VSS.n13681 VSS.n13680 0.120292
R27464 VSS.n13680 VSS.n13677 0.120292
R27465 VSS.n13677 VSS.n13666 0.120292
R27466 VSS.n14316 VSS.n13666 0.120292
R27467 VSS.n14317 VSS.n14316 0.120292
R27468 VSS.n14317 VSS.n13665 0.120292
R27469 VSS.n14322 VSS.n13665 0.120292
R27470 VSS.n14323 VSS.n14322 0.120292
R27471 VSS.n14323 VSS.n13664 0.120292
R27472 VSS.n13664 VSS.n13660 0.120292
R27473 VSS.n14331 VSS.n13660 0.120292
R27474 VSS.n14332 VSS.n14331 0.120292
R27475 VSS.n14333 VSS.n14332 0.120292
R27476 VSS.n14333 VSS.n13658 0.120292
R27477 VSS.n14337 VSS.n13658 0.120292
R27478 VSS.n14338 VSS.n14337 0.120292
R27479 VSS.n14339 VSS.n14338 0.120292
R27480 VSS.n14339 VSS.n13654 0.120292
R27481 VSS.n14343 VSS.n13654 0.120292
R27482 VSS.n14351 VSS.n13649 0.120292
R27483 VSS.n14352 VSS.n14351 0.120292
R27484 VSS.n14353 VSS.n14352 0.120292
R27485 VSS.n14353 VSS.n13647 0.120292
R27486 VSS.n14357 VSS.n13647 0.120292
R27487 VSS.n14365 VSS.n14364 0.120292
R27488 VSS.n14365 VSS.n13642 0.120292
R27489 VSS.n13642 VSS.n13638 0.120292
R27490 VSS.n14373 VSS.n13638 0.120292
R27491 VSS.n14374 VSS.n14373 0.120292
R27492 VSS.n14385 VSS.n14384 0.120292
R27493 VSS.n14386 VSS.n14385 0.120292
R27494 VSS.n14386 VSS.n13631 0.120292
R27495 VSS.n14394 VSS.n13631 0.120292
R27496 VSS.n14395 VSS.n14394 0.120292
R27497 VSS.n14396 VSS.n14395 0.120292
R27498 VSS.n14396 VSS.n13629 0.120292
R27499 VSS.n14400 VSS.n13629 0.120292
R27500 VSS.n14401 VSS.n14400 0.120292
R27501 VSS.n14401 VSS.n13628 0.120292
R27502 VSS.n14404 VSS.n13628 0.120292
R27503 VSS.n14405 VSS.n14404 0.120292
R27504 VSS.n14405 VSS.n13627 0.120292
R27505 VSS.n13627 VSS.n13619 0.120292
R27506 VSS.n14411 VSS.n13619 0.120292
R27507 VSS.n14412 VSS.n14411 0.120292
R27508 VSS.n14412 VSS.n13618 0.120292
R27509 VSS.n13618 VSS.n13613 0.120292
R27510 VSS.n14417 VSS.n13613 0.120292
R27511 VSS.n14418 VSS.n14417 0.120292
R27512 VSS.n14419 VSS.n14418 0.120292
R27513 VSS.n14419 VSS.n13611 0.120292
R27514 VSS.n14423 VSS.n13611 0.120292
R27515 VSS.n14424 VSS.n14423 0.120292
R27516 VSS.n14424 VSS.n13609 0.120292
R27517 VSS.n14430 VSS.n13609 0.120292
R27518 VSS.n14431 VSS.n14430 0.120292
R27519 VSS.n14431 VSS.n13604 0.120292
R27520 VSS.n14438 VSS.n13604 0.120292
R27521 VSS.n14439 VSS.n14438 0.120292
R27522 VSS.n14439 VSS.n13599 0.120292
R27523 VSS.n14447 VSS.n13599 0.120292
R27524 VSS.n14448 VSS.n14447 0.120292
R27525 VSS.n14449 VSS.n14448 0.120292
R27526 VSS.n14449 VSS.n13597 0.120292
R27527 VSS.n14453 VSS.n13597 0.120292
R27528 VSS.n14454 VSS.n14453 0.120292
R27529 VSS.n14454 VSS.n13596 0.120292
R27530 VSS.n14457 VSS.n13596 0.120292
R27531 VSS.n14479 VSS.n14461 0.120292
R27532 VSS.n14471 VSS.n14461 0.120292
R27533 VSS.n14471 VSS.n14470 0.120292
R27534 VSS.n14470 VSS.n14465 0.120292
R27535 VSS.n14466 VSS.n14465 0.120292
R27536 VSS.n14534 VSS.n27 0.120292
R27537 VSS.n14534 VSS.n14533 0.120292
R27538 VSS.n14533 VSS.n14532 0.120292
R27539 VSS.n14532 VSS.n13591 0.120292
R27540 VSS.n14524 VSS.n13591 0.120292
R27541 VSS.n14525 VSS.n14524 0.120292
R27542 VSS.n14525 VSS.n14523 0.120292
R27543 VSS.n14523 VSS.n14522 0.120292
R27544 VSS.n14522 VSS.n14485 0.120292
R27545 VSS.n14510 VSS.n14485 0.120292
R27546 VSS.n14511 VSS.n14510 0.120292
R27547 VSS.n14511 VSS.n14509 0.120292
R27548 VSS.n14509 VSS.n14490 0.120292
R27549 VSS.n14502 VSS.n14490 0.120292
R27550 VSS.n14502 VSS.n14501 0.120292
R27551 VSS.n14501 VSS.n14491 0.120292
R27552 VSS.n14498 VSS.n14491 0.120292
R27553 VSS.n14498 VSS.n14497 0.120292
R27554 VSS.n14497 VSS.n14496 0.120292
R27555 VSS.n14496 VSS.n14493 0.120292
R27556 VSS.n15177 VSS.n15176 0.120292
R27557 VSS.n15177 VSS.n15166 0.120292
R27558 VSS.n15185 VSS.n15166 0.120292
R27559 VSS.n15186 VSS.n15185 0.120292
R27560 VSS.n15187 VSS.n15186 0.120292
R27561 VSS.n15187 VSS.n15164 0.120292
R27562 VSS.n15191 VSS.n15164 0.120292
R27563 VSS.n15192 VSS.n15191 0.120292
R27564 VSS.n15193 VSS.n15192 0.120292
R27565 VSS.n15193 VSS.n15162 0.120292
R27566 VSS.n15197 VSS.n15162 0.120292
R27567 VSS.n15198 VSS.n15197 0.120292
R27568 VSS.n15199 VSS.n15198 0.120292
R27569 VSS.n15199 VSS.n15152 0.120292
R27570 VSS.n15207 VSS.n15152 0.120292
R27571 VSS.n15208 VSS.n15207 0.120292
R27572 VSS.n15209 VSS.n15208 0.120292
R27573 VSS.n15209 VSS.n15150 0.120292
R27574 VSS.n15213 VSS.n15150 0.120292
R27575 VSS.n15214 VSS.n15213 0.120292
R27576 VSS.n15215 VSS.n15214 0.120292
R27577 VSS.n15215 VSS.n15148 0.120292
R27578 VSS.n15219 VSS.n15148 0.120292
R27579 VSS.n15220 VSS.n15219 0.120292
R27580 VSS.n15220 VSS.n15147 0.120292
R27581 VSS.n15147 VSS.n15146 0.120292
R27582 VSS.n15146 VSS.n15138 0.120292
R27583 VSS.n15143 VSS.n15138 0.120292
R27584 VSS.n15143 VSS.n15142 0.120292
R27585 VSS.n15225 VSS.n303 0.120292
R27586 VSS.n15094 VSS.n303 0.120292
R27587 VSS.n15097 VSS.n15094 0.120292
R27588 VSS.n15098 VSS.n15097 0.120292
R27589 VSS.n15099 VSS.n15098 0.120292
R27590 VSS.n15099 VSS.n15092 0.120292
R27591 VSS.n15102 VSS.n15092 0.120292
R27592 VSS.n15103 VSS.n15102 0.120292
R27593 VSS.n15104 VSS.n15103 0.120292
R27594 VSS.n15104 VSS.n15091 0.120292
R27595 VSS.n15107 VSS.n15091 0.120292
R27596 VSS.n15108 VSS.n15107 0.120292
R27597 VSS.n15109 VSS.n15108 0.120292
R27598 VSS.n15109 VSS.n15089 0.120292
R27599 VSS.n15114 VSS.n15089 0.120292
R27600 VSS.n15115 VSS.n15114 0.120292
R27601 VSS.n15115 VSS.n15088 0.120292
R27602 VSS.n15088 VSS.n15084 0.120292
R27603 VSS.n15122 VSS.n15084 0.120292
R27604 VSS.n15123 VSS.n15122 0.120292
R27605 VSS.n15124 VSS.n15123 0.120292
R27606 VSS.n15124 VSS.n15082 0.120292
R27607 VSS.n15128 VSS.n15082 0.120292
R27608 VSS.n15129 VSS.n15128 0.120292
R27609 VSS.n15129 VSS.n15080 0.120292
R27610 VSS.n15132 VSS.n15080 0.120292
R27611 VSS.n15133 VSS.n15132 0.120292
R27612 VSS.n15133 VSS.n15079 0.120292
R27613 VSS.n15079 VSS.n15078 0.120292
R27614 VSS.n15078 VSS.n15077 0.120292
R27615 VSS.n15077 VSS.n306 0.120292
R27616 VSS.n15074 VSS.n306 0.120292
R27617 VSS.n15074 VSS.n15073 0.120292
R27618 VSS.n15073 VSS.n15072 0.120292
R27619 VSS.n15072 VSS.n308 0.120292
R27620 VSS.n15068 VSS.n308 0.120292
R27621 VSS.n15068 VSS.n15067 0.120292
R27622 VSS.n15067 VSS.n309 0.120292
R27623 VSS.n15064 VSS.n309 0.120292
R27624 VSS.n15064 VSS.n15063 0.120292
R27625 VSS.n15063 VSS.n15062 0.120292
R27626 VSS.n15062 VSS.n311 0.120292
R27627 VSS.n15054 VSS.n311 0.120292
R27628 VSS.n15055 VSS.n15054 0.120292
R27629 VSS.n15055 VSS.n15053 0.120292
R27630 VSS.n15053 VSS.n314 0.120292
R27631 VSS.n15049 VSS.n314 0.120292
R27632 VSS.n15049 VSS.n15048 0.120292
R27633 VSS.n15048 VSS.n15047 0.120292
R27634 VSS.n15047 VSS.n316 0.120292
R27635 VSS.n15042 VSS.n318 0.120292
R27636 VSS.n15009 VSS.n318 0.120292
R27637 VSS.n15010 VSS.n15009 0.120292
R27638 VSS.n15010 VSS.n15008 0.120292
R27639 VSS.n15011 VSS.n15008 0.120292
R27640 VSS.n15012 VSS.n15011 0.120292
R27641 VSS.n15013 VSS.n15012 0.120292
R27642 VSS.n15013 VSS.n15007 0.120292
R27643 VSS.n15016 VSS.n15007 0.120292
R27644 VSS.n15017 VSS.n15016 0.120292
R27645 VSS.n15018 VSS.n15017 0.120292
R27646 VSS.n15018 VSS.n15005 0.120292
R27647 VSS.n15022 VSS.n15005 0.120292
R27648 VSS.n15023 VSS.n15022 0.120292
R27649 VSS.n15023 VSS.n15004 0.120292
R27650 VSS.n15025 VSS.n15004 0.120292
R27651 VSS.n15026 VSS.n15025 0.120292
R27652 VSS.n15030 VSS.n15029 0.120292
R27653 VSS.n15031 VSS.n15030 0.120292
R27654 VSS.n15031 VSS.n15001 0.120292
R27655 VSS.n15035 VSS.n15001 0.120292
R27656 VSS.n15036 VSS.n15035 0.120292
R27657 VSS.n15037 VSS.n15036 0.120292
R27658 VSS.n15037 VSS.n15000 0.120292
R27659 VSS.n15000 VSS.n319 0.120292
R27660 VSS.n14994 VSS.n319 0.120292
R27661 VSS.n14994 VSS.n14993 0.120292
R27662 VSS.n14993 VSS.n324 0.120292
R27663 VSS.n14983 VSS.n324 0.120292
R27664 VSS.n14983 VSS.n14982 0.120292
R27665 VSS.n14982 VSS.n14981 0.120292
R27666 VSS.n14981 VSS.n326 0.120292
R27667 VSS.n14977 VSS.n326 0.120292
R27668 VSS.n14977 VSS.n14976 0.120292
R27669 VSS.n14976 VSS.n327 0.120292
R27670 VSS.n14968 VSS.n327 0.120292
R27671 VSS.n14969 VSS.n14968 0.120292
R27672 VSS.n14969 VSS.n14967 0.120292
R27673 VSS.n14967 VSS.n14966 0.120292
R27674 VSS.n14966 VSS.n332 0.120292
R27675 VSS.n14955 VSS.n332 0.120292
R27676 VSS.n14955 VSS.n14954 0.120292
R27677 VSS.n14954 VSS.n14953 0.120292
R27678 VSS.n14953 VSS.n334 0.120292
R27679 VSS.n14949 VSS.n334 0.120292
R27680 VSS.n14949 VSS.n14948 0.120292
R27681 VSS.n14948 VSS.n335 0.120292
R27682 VSS.n14940 VSS.n335 0.120292
R27683 VSS.n14941 VSS.n14940 0.120292
R27684 VSS.n14941 VSS.n14939 0.120292
R27685 VSS.n14939 VSS.n14938 0.120292
R27686 VSS.n14938 VSS.n338 0.120292
R27687 VSS.n14931 VSS.n338 0.120292
R27688 VSS.n14931 VSS.n14930 0.120292
R27689 VSS.n14930 VSS.n14929 0.120292
R27690 VSS.n14929 VSS.n340 0.120292
R27691 VSS.n14925 VSS.n340 0.120292
R27692 VSS.n14925 VSS.n14924 0.120292
R27693 VSS.n14924 VSS.n341 0.120292
R27694 VSS.n14920 VSS.n341 0.120292
R27695 VSS.n14920 VSS.n14919 0.120292
R27696 VSS.n14919 VSS.n342 0.120292
R27697 VSS.n343 VSS.n342 0.120292
R27698 VSS.n344 VSS.n343 0.120292
R27699 VSS.n345 VSS.n344 0.120292
R27700 VSS.n346 VSS.n345 0.120292
R27701 VSS.n14916 VSS.n346 0.120292
R27702 VSS.n14916 VSS.n14915 0.120292
R27703 VSS.n14915 VSS.n14914 0.120292
R27704 VSS.n14914 VSS.n347 0.120292
R27705 VSS.n14910 VSS.n347 0.120292
R27706 VSS.n14910 VSS.n14909 0.120292
R27707 VSS.n14909 VSS.n14908 0.120292
R27708 VSS.n14908 VSS.n349 0.120292
R27709 VSS.n350 VSS.n349 0.120292
R27710 VSS.n14906 VSS.n350 0.120292
R27711 VSS.n14906 VSS.n14905 0.120292
R27712 VSS.n14905 VSS.n351 0.120292
R27713 VSS.n14897 VSS.n354 0.120292
R27714 VSS.n14893 VSS.n354 0.120292
R27715 VSS.n14893 VSS.n14892 0.120292
R27716 VSS.n14892 VSS.n14891 0.120292
R27717 VSS.n14891 VSS.n356 0.120292
R27718 VSS.n14888 VSS.n356 0.120292
R27719 VSS.n14888 VSS.n14887 0.120292
R27720 VSS.n14887 VSS.n357 0.120292
R27721 VSS.n14883 VSS.n357 0.120292
R27722 VSS.n14883 VSS.n14882 0.120292
R27723 VSS.n14882 VSS.n14881 0.120292
R27724 VSS.n14881 VSS.n358 0.120292
R27725 VSS.n14877 VSS.n358 0.120292
R27726 VSS.n14877 VSS.n14876 0.120292
R27727 VSS.n14876 VSS.n14875 0.120292
R27728 VSS.n14875 VSS.n360 0.120292
R27729 VSS.n14870 VSS.n360 0.120292
R27730 VSS.n14870 VSS.n14869 0.120292
R27731 VSS.n14869 VSS.n363 0.120292
R27732 VSS.n14865 VSS.n363 0.120292
R27733 VSS.n14865 VSS.n14864 0.120292
R27734 VSS.n14864 VSS.n364 0.120292
R27735 VSS.n14860 VSS.n364 0.120292
R27736 VSS.n14860 VSS.n14859 0.120292
R27737 VSS.n14859 VSS.n14858 0.120292
R27738 VSS.n14858 VSS.n365 0.120292
R27739 VSS.n14856 VSS.n365 0.120292
R27740 VSS.n14856 VSS.n14855 0.120292
R27741 VSS.n14855 VSS.n14854 0.120292
R27742 VSS.n14854 VSS.n366 0.120292
R27743 VSS.n14851 VSS.n366 0.120292
R27744 VSS.n14851 VSS.n14850 0.120292
R27745 VSS.n14850 VSS.n14849 0.120292
R27746 VSS.n14849 VSS.n368 0.120292
R27747 VSS.n14845 VSS.n368 0.120292
R27748 VSS.n14845 VSS.n14844 0.120292
R27749 VSS.n14844 VSS.n14843 0.120292
R27750 VSS.n14843 VSS.n370 0.120292
R27751 VSS.n14840 VSS.n370 0.120292
R27752 VSS.n14840 VSS.n14839 0.120292
R27753 VSS.n14839 VSS.n14838 0.120292
R27754 VSS.n14838 VSS.n371 0.120292
R27755 VSS.n14834 VSS.n371 0.120292
R27756 VSS.n14834 VSS.n14833 0.120292
R27757 VSS.n14833 VSS.n372 0.120292
R27758 VSS.n14830 VSS.n14829 0.120292
R27759 VSS.n14829 VSS.n374 0.120292
R27760 VSS.n14825 VSS.n374 0.120292
R27761 VSS.n14825 VSS.n14824 0.120292
R27762 VSS.n14824 VSS.n375 0.120292
R27763 VSS.n14821 VSS.n375 0.120292
R27764 VSS.n14821 VSS.n14820 0.120292
R27765 VSS.n14820 VSS.n14819 0.120292
R27766 VSS.n14819 VSS.n377 0.120292
R27767 VSS.n14815 VSS.n377 0.120292
R27768 VSS.n14815 VSS.n14814 0.120292
R27769 VSS.n14814 VSS.n378 0.120292
R27770 VSS.n379 VSS.n378 0.120292
R27771 VSS.n14811 VSS.n379 0.120292
R27772 VSS.n14811 VSS.n14810 0.120292
R27773 VSS.n14810 VSS.n380 0.120292
R27774 VSS.n14806 VSS.n380 0.120292
R27775 VSS.n14806 VSS.n14805 0.120292
R27776 VSS.n14805 VSS.n381 0.120292
R27777 VSS.n14801 VSS.n381 0.120292
R27778 VSS.n14801 VSS.n14800 0.120292
R27779 VSS.n14800 VSS.n14799 0.120292
R27780 VSS.n14799 VSS.n383 0.120292
R27781 VSS.n14793 VSS.n14791 0.120292
R27782 VSS.n14791 VSS.n14790 0.120292
R27783 VSS.n14790 VSS.n384 0.120292
R27784 VSS.n14787 VSS.n384 0.120292
R27785 VSS.n14787 VSS.n14786 0.120292
R27786 VSS.n14786 VSS.n385 0.120292
R27787 VSS.n14782 VSS.n385 0.120292
R27788 VSS.n14782 VSS.n14781 0.120292
R27789 VSS.n14781 VSS.n386 0.120292
R27790 VSS.n14777 VSS.n386 0.120292
R27791 VSS.n14777 VSS.n14776 0.120292
R27792 VSS.n14776 VSS.n14775 0.120292
R27793 VSS.n14775 VSS.n387 0.120292
R27794 VSS.n14771 VSS.n387 0.120292
R27795 VSS.n14771 VSS.n14770 0.120292
R27796 VSS.n14770 VSS.n388 0.120292
R27797 VSS.n14767 VSS.n388 0.120292
R27798 VSS.n14767 VSS.n14766 0.120292
R27799 VSS.n14766 VSS.n14765 0.120292
R27800 VSS.n14765 VSS.n390 0.120292
R27801 VSS.n14761 VSS.n390 0.120292
R27802 VSS.n14761 VSS.n14760 0.120292
R27803 VSS.n14760 VSS.n14759 0.120292
R27804 VSS.n14759 VSS.n392 0.120292
R27805 VSS.n14755 VSS.n392 0.120292
R27806 VSS.n14755 VSS.n14754 0.120292
R27807 VSS.n14754 VSS.n393 0.120292
R27808 VSS.n14750 VSS.n393 0.120292
R27809 VSS.n14750 VSS.n14749 0.120292
R27810 VSS.n14749 VSS.n14748 0.120292
R27811 VSS.n14748 VSS.n220 0.120292
R27812 VSS.n14742 VSS.n220 0.120292
R27813 VSS.n14742 VSS.n14741 0.120292
R27814 VSS.n14741 VSS.n14740 0.120292
R27815 VSS.n14740 VSS.n397 0.120292
R27816 VSS.n14738 VSS.n397 0.120292
R27817 VSS.n14738 VSS.n14737 0.120292
R27818 VSS.n14737 VSS.n409 0.120292
R27819 VSS.n14733 VSS.n409 0.120292
R27820 VSS.n14733 VSS.n14732 0.120292
R27821 VSS.n14732 VSS.n14731 0.120292
R27822 VSS.n14731 VSS.n411 0.120292
R27823 VSS.n14723 VSS.n411 0.120292
R27824 VSS.n14724 VSS.n14723 0.120292
R27825 VSS.n14724 VSS.n14722 0.120292
R27826 VSS.n14722 VSS.n14721 0.120292
R27827 VSS.n14721 VSS.n415 0.120292
R27828 VSS.n14719 VSS.n415 0.120292
R27829 VSS.n14719 VSS.n14718 0.120292
R27830 VSS.n14718 VSS.n427 0.120292
R27831 VSS.n14714 VSS.n427 0.120292
R27832 VSS.n14714 VSS.n14713 0.120292
R27833 VSS.n14713 VSS.n14712 0.120292
R27834 VSS.n14712 VSS.n429 0.120292
R27835 VSS.n14704 VSS.n429 0.120292
R27836 VSS.n14705 VSS.n14704 0.120292
R27837 VSS.n14705 VSS.n14703 0.120292
R27838 VSS.n14703 VSS.n14702 0.120292
R27839 VSS.n14702 VSS.n433 0.120292
R27840 VSS.n14694 VSS.n433 0.120292
R27841 VSS.n14694 VSS.n14693 0.120292
R27842 VSS.n14693 VSS.n14692 0.120292
R27843 VSS.n14692 VSS.n435 0.120292
R27844 VSS.n14687 VSS.n435 0.120292
R27845 VSS.n14687 VSS.n14686 0.120292
R27846 VSS.n14686 VSS.n436 0.120292
R27847 VSS.n14682 VSS.n436 0.120292
R27848 VSS.n14682 VSS.n14681 0.120292
R27849 VSS.n14681 VSS.n14680 0.120292
R27850 VSS.n14680 VSS.n440 0.120292
R27851 VSS.n14667 VSS.n440 0.120292
R27852 VSS.n14668 VSS.n14667 0.120292
R27853 VSS.n14668 VSS.n14666 0.120292
R27854 VSS.n14666 VSS.n445 0.120292
R27855 VSS.n14658 VSS.n445 0.120292
R27856 VSS.n14658 VSS.n14657 0.120292
R27857 VSS.n14657 VSS.n14656 0.120292
R27858 VSS.n14656 VSS.n448 0.120292
R27859 VSS.n14653 VSS.n448 0.120292
R27860 VSS.n14653 VSS.n14652 0.120292
R27861 VSS.n14652 VSS.n14651 0.120292
R27862 VSS.n14646 VSS.n454 0.120292
R27863 VSS.n14638 VSS.n454 0.120292
R27864 VSS.n14638 VSS.n14637 0.120292
R27865 VSS.n14637 VSS.n458 0.120292
R27866 VSS.n14633 VSS.n458 0.120292
R27867 VSS.n14617 VSS.n29 0.120292
R27868 VSS.n14617 VSS.n14616 0.120292
R27869 VSS.n14616 VSS.n14615 0.120292
R27870 VSS.n14615 VSS.n14555 0.120292
R27871 VSS.n14607 VSS.n14555 0.120292
R27872 VSS.n14608 VSS.n14607 0.120292
R27873 VSS.n14608 VSS.n14606 0.120292
R27874 VSS.n14606 VSS.n14605 0.120292
R27875 VSS.n14605 VSS.n14568 0.120292
R27876 VSS.n14593 VSS.n14568 0.120292
R27877 VSS.n14594 VSS.n14593 0.120292
R27878 VSS.n14594 VSS.n14592 0.120292
R27879 VSS.n14592 VSS.n14573 0.120292
R27880 VSS.n14585 VSS.n14573 0.120292
R27881 VSS.n14585 VSS.n14584 0.120292
R27882 VSS.n14584 VSS.n14574 0.120292
R27883 VSS.n14581 VSS.n14574 0.120292
R27884 VSS.n14581 VSS.n14580 0.120292
R27885 VSS.n14580 VSS.n14579 0.120292
R27886 VSS.n14579 VSS.n14576 0.120292
R27887 VSS.n14174 VSS.t109 2.01694
R27888 VSS.n2233 VSS.t3401 2.01694
R27889 VSS.n3763 VSS.t3433 2.01694
R27890 VSS.n14696 VSS.t527 1.27055
R27891 VSS.t652 VSS.n13832 1.27055
R27892 VSS.t667 VSS.n13782 1.27055
R27893 VSS.t722 VSS.n13615 1.27055
R27894 VSS.t862 VSS.n1550 1.27055
R27895 VSS.t877 VSS.n1500 1.27055
R27896 VSS.t892 VSS.n1450 1.27055
R27897 VSS.t907 VSS.n1400 1.27055
R27898 VSS.t922 VSS.n1350 1.27055
R27899 VSS.t937 VSS.n1300 1.27055
R27900 VSS.t1077 VSS.n159 1.27055
R27901 VSS.n12718 VSS.t1092 1.27055
R27902 VSS.n12612 VSS.t1107 1.27055
R27903 VSS.n12506 VSS.t1122 1.27055
R27904 VSS.n12400 VSS.t1137 1.27055
R27905 VSS.n12294 VSS.t1152 1.27055
R27906 VSS.t1292 VSS.n153 1.27055
R27907 VSS.n11680 VSS.t1307 1.27055
R27908 VSS.n11574 VSS.t1322 1.27055
R27909 VSS.n11468 VSS.t1337 1.27055
R27910 VSS.n11362 VSS.t1352 1.27055
R27911 VSS.n11256 VSS.t1367 1.27055
R27912 VSS.t1507 VSS.n10345 1.27055
R27913 VSS.t1522 VSS.n10295 1.27055
R27914 VSS.t1537 VSS.n10245 1.27055
R27915 VSS.t1552 VSS.n10195 1.27055
R27916 VSS.t1567 VSS.n10145 1.27055
R27917 VSS.t1582 VSS.n10095 1.27055
R27918 VSS.t1725 VSS.n2191 1.27055
R27919 VSS.t1740 VSS.n2141 1.27055
R27920 VSS.t1755 VSS.n2091 1.27055
R27921 VSS.t1770 VSS.n2041 1.27055
R27922 VSS.t1785 VSS.n1991 1.27055
R27923 VSS.t1800 VSS.n1941 1.27055
R27924 VSS.t1940 VSS.n147 1.27055
R27925 VSS.n9198 VSS.t1955 1.27055
R27926 VSS.n9092 VSS.t1970 1.27055
R27927 VSS.n8986 VSS.t1985 1.27055
R27928 VSS.n8880 VSS.t2000 1.27055
R27929 VSS.n8774 VSS.t2015 1.27055
R27930 VSS.t2155 VSS.n141 1.27055
R27931 VSS.n8160 VSS.t2170 1.27055
R27932 VSS.n8054 VSS.t2185 1.27055
R27933 VSS.n7948 VSS.t2200 1.27055
R27934 VSS.n7842 VSS.t2215 1.27055
R27935 VSS.n7736 VSS.t2230 1.27055
R27936 VSS.t2370 VSS.n6825 1.27055
R27937 VSS.t2385 VSS.n6775 1.27055
R27938 VSS.t2400 VSS.n6725 1.27055
R27939 VSS.t2415 VSS.n6675 1.27055
R27940 VSS.t2430 VSS.n6625 1.27055
R27941 VSS.t2445 VSS.n6575 1.27055
R27942 VSS.t2585 VSS.n4744 1.27055
R27943 VSS.t2600 VSS.n4694 1.27055
R27944 VSS.t2615 VSS.n4644 1.27055
R27945 VSS.t2630 VSS.n4594 1.27055
R27946 VSS.t2645 VSS.n4544 1.27055
R27947 VSS.t2660 VSS.n4494 1.27055
R27948 VSS.t2800 VSS.n135 1.27055
R27949 VSS.n5678 VSS.t2815 1.27055
R27950 VSS.n5572 VSS.t2830 1.27055
R27951 VSS.n5466 VSS.t2845 1.27055
R27952 VSS.n5360 VSS.t2860 1.27055
R27953 VSS.n5254 VSS.t2875 1.27055
R27954 VSS.t3018 VSS.n3721 1.27055
R27955 VSS.t3033 VSS.n3671 1.27055
R27956 VSS.t3048 VSS.n3621 1.27055
R27957 VSS.t3063 VSS.n3571 1.27055
R27958 VSS.t3078 VSS.n3521 1.27055
R27959 VSS.t3093 VSS.n3471 1.27055
R27960 VSS.n15120 VSS.t257 0.526527
R27961 VSS.t495 VSS.n195 0.409011
R27962 VSS.n164 VSS.n124 1.58997
R27963 VSS.n167 VSS.n122 1.58997
R27964 VSS.n169 VSS.n120 1.58997
R27965 VSS.n171 VSS.n118 1.58997
R27966 VSS.n174 VSS.n116 1.58997
R27967 VSS.n177 VSS.n114 1.58997
R27968 VSS.n179 VSS.n112 1.58997
R27969 VSS.n181 VSS.n110 1.58997
R27970 VSS.n184 VSS.n108 1.58997
R27971 VSS.n187 VSS.n106 1.58997
R27972 VSS.n189 VSS.n104 1.58997
R27973 VSS.n192 VSS.n102 1.58997
R27974 VSS.n15142 VSS.n4 1.09685
R27975 VSS.n15245 VSS.n2 1.09685
R27976 VSS.n238 VSS.n0 1.09685
R27977 VSS.n30 VSS.n29 1.06293
R27978 VSS.n28 VSS.n27 1.06293
R27979 VSS.n26 VSS.n25 1.06293
R27980 VSS.n24 VSS.n23 1.06293
R27981 VSS.n22 VSS.n21 1.06293
R27982 VSS.n20 VSS.n19 1.06293
R27983 VSS.n18 VSS.n17 1.06293
R27984 VSS.n16 VSS.n15 1.06293
R27985 VSS.n14 VSS.n13 1.06293
R27986 VSS.n12 VSS.n11 1.06293
R27987 VSS.n10 VSS.n9 1.06293
R27988 VSS.n8 VSS.n7 1.06293
R27989 VSS.n6 VSS.n5 1.06293
R27990 VSS.n4 VSS.n33 1.05328
R27991 VSS.n2898 VSS.n0 1.05328
R27992 VSS.n656 VSS.n2 1.05328
R27993 VSS.n513 VSS.n37 1.02858
R27994 VSS.n2593 VSS.n35 1.02858
R27995 VSS.n3433 VSS.n35 1.0031
R27996 VSS.n1262 VSS.n37 1.0031
R27997 a_20787_15253.t1 a_20787_15253.n6 735.244
R27998 a_20787_15253.t1 a_20787_15253.n6 717.596
R27999 a_20787_15253.n2 a_20787_15253.t4 443.44
R28000 a_20787_15253.n3 a_20787_15253.t3 345.305
R28001 a_20787_15253.n3 a_20787_15253.t6 296.969
R28002 a_20787_15253.n1 a_20787_15253.t0 287.998
R28003 a_20787_15253.n0 a_20787_15253.t5 263.173
R28004 a_20787_15253.n2 a_20787_15253.t7 254.389
R28005 a_20787_15253.n0 a_20787_15253.t2 227.826
R28006 a_20787_15253.n4 a_20787_15253.n2 193.59
R28007 a_20787_15253.n1 a_20787_15253.n0 152
R28008 a_20787_15253.n5 a_20787_15253.n1 35.3396
R28009 a_20787_15253.n6 a_20787_15253.n5 26.91
R28010 a_20787_15253.n4 a_20787_15253.n3 12.4401
R28011 a_20787_15253.n5 a_20787_15253.n4 11.0742
R28012 _53_.A.n5 _53_.A 585.582
R28013 _53_.A.n5 _53_.A 585
R28014 _53_.A _53_.A.n5 585
R28015 _53_.A.n2 _53_.A.t4 235.763
R28016 _53_.A.n1 _53_.A.n0 185
R28017 _53_.A.n2 _53_.A.t3 163.464
R28018 _53_.A.n3 _53_.A.n2 156
R28019 _53_.A.n0 _53_.A.t0 40.6159
R28020 _53_.A.n0 _53_.A.t1 40.6159
R28021 _53_.A.n4 _53_.A.n3 32.8699
R28022 _53_.A.n5 _53_.A.t2 27.5805
R28023 _53_.A _53_.A.n1 20.7381
R28024 _53_.A.n4 _53_.A 9.89141
R28025 _53_.A.n3 _53_.A 4.26717
R28026 _53_.A.n1 _53_.A 3.50239
R28027 _53_.A _53_.A.n4 3.29747
R28028 _51_.X _51_.X.t1 736.42
R28029 _51_.X.t1 _51_.X.n3 683.5
R28030 _51_.X.n3 _51_.X.t0 289.469
R28031 _51_.X.n0 _51_.X.t2 231.017
R28032 _51_.X.n0 _51_.X.t3 158.716
R28033 _51_.X.n1 _51_.X.n0 153.647
R28034 _51_.X.n2 _51_.X.n1 19.4521
R28035 _51_.X _51_.X.n2 3.95686
R28036 _51_.X.n1 _51_.X 3.10907
R28037 _51_.X.n3 _51_.X.n2 1.16414
R28038 a_21914_15823.n48 a_21914_15823.n47 330.308
R28039 a_21914_15823.t5 a_21914_15823.t2 327.253
R28040 a_21914_15823.n48 a_21914_15823.n46 217.256
R28041 a_21914_15823.n43 a_21914_15823.t22 212.081
R28042 a_21914_15823.n42 a_21914_15823.t21 212.081
R28043 a_21914_15823.n40 a_21914_15823.t20 212.081
R28044 a_21914_15823.n34 a_21914_15823.t19 212.081
R28045 a_21914_15823.n33 a_21914_15823.t18 212.081
R28046 a_21914_15823.n31 a_21914_15823.t17 212.081
R28047 a_21914_15823.n4 a_21914_15823.t16 212.081
R28048 a_21914_15823.n25 a_21914_15823.t15 212.081
R28049 a_21914_15823.n6 a_21914_15823.t14 212.081
R28050 a_21914_15823.n20 a_21914_15823.t13 212.081
R28051 a_21914_15823.n0 a_21914_15823.t12 212.081
R28052 a_21914_15823.n15 a_21914_15823.t11 212.081
R28053 a_21914_15823.n13 a_21914_15823.t10 212.081
R28054 a_21914_15823.n11 a_21914_15823.t9 212.081
R28055 a_21914_15823.n10 a_21914_15823.t8 212.081
R28056 a_21914_15823.n9 a_21914_15823.t7 212.081
R28057 a_21914_15823.n12 a_21914_15823.n8 169.409
R28058 a_21914_15823.n43 a_21914_15823.t38 162.274
R28059 a_21914_15823.n42 a_21914_15823.t37 162.274
R28060 a_21914_15823.n40 a_21914_15823.t36 162.274
R28061 a_21914_15823.n34 a_21914_15823.t35 162.274
R28062 a_21914_15823.n33 a_21914_15823.t34 162.274
R28063 a_21914_15823.n31 a_21914_15823.t33 162.274
R28064 a_21914_15823.n4 a_21914_15823.t32 162.274
R28065 a_21914_15823.n25 a_21914_15823.t31 162.274
R28066 a_21914_15823.n6 a_21914_15823.t30 162.274
R28067 a_21914_15823.n20 a_21914_15823.t29 162.274
R28068 a_21914_15823.n0 a_21914_15823.t28 162.274
R28069 a_21914_15823.n15 a_21914_15823.t27 162.274
R28070 a_21914_15823.n13 a_21914_15823.t26 162.274
R28071 a_21914_15823.n11 a_21914_15823.t25 162.274
R28072 a_21914_15823.n10 a_21914_15823.t24 162.274
R28073 a_21914_15823.n9 a_21914_15823.t23 162.274
R28074 a_21914_15823.n14 a_21914_15823.n8 152
R28075 a_21914_15823.n17 a_21914_15823.n16 152
R28076 a_21914_15823.n0 a_21914_15823.n18 152
R28077 a_21914_15823.n19 a_21914_15823.n7 152
R28078 a_21914_15823.n22 a_21914_15823.n21 152
R28079 a_21914_15823.n24 a_21914_15823.n23 152
R28080 a_21914_15823.n26 a_21914_15823.n5 152
R28081 a_21914_15823.n28 a_21914_15823.n27 152
R28082 a_21914_15823.n30 a_21914_15823.n29 152
R28083 a_21914_15823.n32 a_21914_15823.n3 152
R28084 a_21914_15823.n36 a_21914_15823.n35 152
R28085 a_21914_15823.n37 a_21914_15823.n2 152
R28086 a_21914_15823.n39 a_21914_15823.n38 152
R28087 a_21914_15823.n41 a_21914_15823.n1 152
R28088 a_21914_15823.n45 a_21914_15823.n44 152
R28089 a_21914_15823.n11 a_21914_15823.n10 55.2698
R28090 a_21914_15823.n10 a_21914_15823.n9 55.2698
R28091 a_21914_15823.t2 a_21914_15823.n48 44.0325
R28092 a_21914_15823.n16 a_21914_15823.n0 43.7018
R28093 a_21914_15823.n39 a_21914_15823.n2 43.7018
R28094 a_21914_15823.n27 a_21914_15823.n26 43.7018
R28095 a_21914_15823.n19 a_21914_15823.n0 43.7018
R28096 a_21914_15823.t2 a_21914_15823.n45 43.5205
R28097 a_21914_15823.n30 a_21914_15823.n4 42.4165
R28098 a_21914_15823.n46 a_21914_15823.t0 40.0005
R28099 a_21914_15823.n46 a_21914_15823.t1 40.0005
R28100 a_21914_15823.n41 a_21914_15823.n40 39.8458
R28101 a_21914_15823.n35 a_21914_15823.n34 35.9898
R28102 a_21914_15823.n12 a_21914_15823.n11 35.3472
R28103 a_21914_15823.n25 a_21914_15823.n24 33.4192
R28104 a_21914_15823.n21 a_21914_15823.n20 32.7765
R28105 a_21914_15823.n15 a_21914_15823.n14 31.4912
R28106 a_21914_15823.n32 a_21914_15823.n31 30.8485
R28107 a_21914_15823.n44 a_21914_15823.n42 28.2778
R28108 a_21914_15823.t6 a_21914_15823.t5 27.5805
R28109 a_21914_15823.n47 a_21914_15823.t3 27.5805
R28110 a_21914_15823.n47 a_21914_15823.t4 27.5805
R28111 a_21914_15823.n44 a_21914_15823.n43 26.9925
R28112 a_21914_15823.n33 a_21914_15823.n32 24.4218
R28113 a_21914_15823.n14 a_21914_15823.n13 23.7792
R28114 a_21914_15823.n21 a_21914_15823.n6 22.4938
R28115 a_21914_15823.n24 a_21914_15823.n6 21.2085
R28116 a_21914_15823.n13 a_21914_15823.n12 19.9232
R28117 a_21914_15823.n35 a_21914_15823.n33 19.2805
R28118 a_21914_15823.n45 a_21914_15823.n1 17.4085
R28119 a_21914_15823.n38 a_21914_15823.n1 17.4085
R28120 a_21914_15823.n38 a_21914_15823.n37 17.4085
R28121 a_21914_15823.n37 a_21914_15823.n36 17.4085
R28122 a_21914_15823.n36 a_21914_15823.n3 17.4085
R28123 a_21914_15823.n29 a_21914_15823.n3 17.4085
R28124 a_21914_15823.n29 a_21914_15823.n28 17.4085
R28125 a_21914_15823.n28 a_21914_15823.n5 17.4085
R28126 a_21914_15823.n23 a_21914_15823.n5 17.4085
R28127 a_21914_15823.n23 a_21914_15823.n22 17.4085
R28128 a_21914_15823.n22 a_21914_15823.n7 17.4085
R28129 a_21914_15823.n18 a_21914_15823.n7 17.4085
R28130 a_21914_15823.n18 a_21914_15823.n17 17.4085
R28131 a_21914_15823.n17 a_21914_15823.n8 17.4085
R28132 a_21914_15823.n42 a_21914_15823.n41 15.4245
R28133 a_21914_15823.n31 a_21914_15823.n30 12.8538
R28134 a_21914_15823.n16 a_21914_15823.n15 12.2112
R28135 a_21914_15823.n20 a_21914_15823.n19 10.9258
R28136 a_21914_15823.n26 a_21914_15823.n25 10.2832
R28137 a_21914_15823.n34 a_21914_15823.n2 7.7125
R28138 a_21914_15823.n40 a_21914_15823.n39 3.8565
R28139 a_21914_15823.n27 a_21914_15823.n4 1.28583
R28140 a_16762_15823.t0 a_16762_15823.n46 330.308
R28141 a_16762_15823.t4 a_16762_15823.t1 327.253
R28142 a_16762_15823.n43 a_16762_15823.t21 212.081
R28143 a_16762_15823.n42 a_16762_15823.t20 212.081
R28144 a_16762_15823.n40 a_16762_15823.t19 212.081
R28145 a_16762_15823.n34 a_16762_15823.t18 212.081
R28146 a_16762_15823.n33 a_16762_15823.t17 212.081
R28147 a_16762_15823.n31 a_16762_15823.t16 212.081
R28148 a_16762_15823.n4 a_16762_15823.t15 212.081
R28149 a_16762_15823.n25 a_16762_15823.t14 212.081
R28150 a_16762_15823.n6 a_16762_15823.t13 212.081
R28151 a_16762_15823.n20 a_16762_15823.t12 212.081
R28152 a_16762_15823.n0 a_16762_15823.t11 212.081
R28153 a_16762_15823.n15 a_16762_15823.t10 212.081
R28154 a_16762_15823.n13 a_16762_15823.t9 212.081
R28155 a_16762_15823.n11 a_16762_15823.t8 212.081
R28156 a_16762_15823.n10 a_16762_15823.t7 212.081
R28157 a_16762_15823.n9 a_16762_15823.t6 212.081
R28158 a_16762_15823.n12 a_16762_15823.n8 169.409
R28159 a_16762_15823.n43 a_16762_15823.t37 162.274
R28160 a_16762_15823.n42 a_16762_15823.t36 162.274
R28161 a_16762_15823.n40 a_16762_15823.t35 162.274
R28162 a_16762_15823.n34 a_16762_15823.t34 162.274
R28163 a_16762_15823.n33 a_16762_15823.t33 162.274
R28164 a_16762_15823.n31 a_16762_15823.t32 162.274
R28165 a_16762_15823.n4 a_16762_15823.t31 162.274
R28166 a_16762_15823.n25 a_16762_15823.t30 162.274
R28167 a_16762_15823.n6 a_16762_15823.t29 162.274
R28168 a_16762_15823.n20 a_16762_15823.t28 162.274
R28169 a_16762_15823.n0 a_16762_15823.t27 162.274
R28170 a_16762_15823.n15 a_16762_15823.t26 162.274
R28171 a_16762_15823.n13 a_16762_15823.t25 162.274
R28172 a_16762_15823.n11 a_16762_15823.t24 162.274
R28173 a_16762_15823.n10 a_16762_15823.t23 162.274
R28174 a_16762_15823.n9 a_16762_15823.t22 162.274
R28175 a_16762_15823.n14 a_16762_15823.n8 152
R28176 a_16762_15823.n17 a_16762_15823.n16 152
R28177 a_16762_15823.n0 a_16762_15823.n18 152
R28178 a_16762_15823.n19 a_16762_15823.n7 152
R28179 a_16762_15823.n22 a_16762_15823.n21 152
R28180 a_16762_15823.n24 a_16762_15823.n23 152
R28181 a_16762_15823.n26 a_16762_15823.n5 152
R28182 a_16762_15823.n28 a_16762_15823.n27 152
R28183 a_16762_15823.n30 a_16762_15823.n29 152
R28184 a_16762_15823.n32 a_16762_15823.n3 152
R28185 a_16762_15823.n36 a_16762_15823.n35 152
R28186 a_16762_15823.n37 a_16762_15823.n2 152
R28187 a_16762_15823.n39 a_16762_15823.n38 152
R28188 a_16762_15823.n41 a_16762_15823.n1 152
R28189 a_16762_15823.n45 a_16762_15823.n44 152
R28190 a_16762_15823.n11 a_16762_15823.n10 55.2698
R28191 a_16762_15823.n10 a_16762_15823.n9 55.2698
R28192 a_16762_15823.t1 a_16762_15823.t0 44.0325
R28193 a_16762_15823.n16 a_16762_15823.n0 43.7018
R28194 a_16762_15823.n39 a_16762_15823.n2 43.7018
R28195 a_16762_15823.n27 a_16762_15823.n26 43.7018
R28196 a_16762_15823.n19 a_16762_15823.n0 43.7018
R28197 a_16762_15823.t1 a_16762_15823.n45 43.5205
R28198 a_16762_15823.n30 a_16762_15823.n4 42.4165
R28199 a_16762_15823.n41 a_16762_15823.n40 39.8458
R28200 a_16762_15823.n35 a_16762_15823.n34 35.9898
R28201 a_16762_15823.n12 a_16762_15823.n11 35.3472
R28202 a_16762_15823.n25 a_16762_15823.n24 33.4192
R28203 a_16762_15823.n21 a_16762_15823.n20 32.7765
R28204 a_16762_15823.n15 a_16762_15823.n14 31.4912
R28205 a_16762_15823.n32 a_16762_15823.n31 30.8485
R28206 a_16762_15823.n44 a_16762_15823.n42 28.2778
R28207 a_16762_15823.t5 a_16762_15823.t4 27.5805
R28208 a_16762_15823.n46 a_16762_15823.t2 27.5805
R28209 a_16762_15823.n46 a_16762_15823.t3 27.5805
R28210 a_16762_15823.n44 a_16762_15823.n43 26.9925
R28211 a_16762_15823.n33 a_16762_15823.n32 24.4218
R28212 a_16762_15823.n14 a_16762_15823.n13 23.7792
R28213 a_16762_15823.n21 a_16762_15823.n6 22.4938
R28214 a_16762_15823.n24 a_16762_15823.n6 21.2085
R28215 a_16762_15823.n13 a_16762_15823.n12 19.9232
R28216 a_16762_15823.n35 a_16762_15823.n33 19.2805
R28217 a_16762_15823.n45 a_16762_15823.n1 17.4085
R28218 a_16762_15823.n38 a_16762_15823.n1 17.4085
R28219 a_16762_15823.n38 a_16762_15823.n37 17.4085
R28220 a_16762_15823.n37 a_16762_15823.n36 17.4085
R28221 a_16762_15823.n36 a_16762_15823.n3 17.4085
R28222 a_16762_15823.n29 a_16762_15823.n3 17.4085
R28223 a_16762_15823.n29 a_16762_15823.n28 17.4085
R28224 a_16762_15823.n28 a_16762_15823.n5 17.4085
R28225 a_16762_15823.n23 a_16762_15823.n5 17.4085
R28226 a_16762_15823.n23 a_16762_15823.n22 17.4085
R28227 a_16762_15823.n22 a_16762_15823.n7 17.4085
R28228 a_16762_15823.n18 a_16762_15823.n7 17.4085
R28229 a_16762_15823.n18 a_16762_15823.n17 17.4085
R28230 a_16762_15823.n17 a_16762_15823.n8 17.4085
R28231 a_16762_15823.n42 a_16762_15823.n41 15.4245
R28232 a_16762_15823.n31 a_16762_15823.n30 12.8538
R28233 a_16762_15823.n16 a_16762_15823.n15 12.2112
R28234 a_16762_15823.n20 a_16762_15823.n19 10.9258
R28235 a_16762_15823.n26 a_16762_15823.n25 10.2832
R28236 a_16762_15823.n34 a_16762_15823.n2 7.7125
R28237 a_16762_15823.n40 a_16762_15823.n39 3.8565
R28238 a_16762_15823.n27 a_16762_15823.n4 1.28583
R28239 _69_.X _69_.X.t1 744.352
R28240 _69_.X.t1 _69_.X.n2 732.75
R28241 _69_.X.n0 _69_.X.t3 302.731
R28242 _69_.X.n1 _69_.X.t0 216.155
R28243 _69_.X.n0 _69_.X.t2 212.757
R28244 _69_.X _69_.X.n0 162.286
R28245 _69_.X.n2 _69_.X 80.894
R28246 _69_.X.n1 _69_.X 42.2983
R28247 _69_.X _69_.X.n1 3.2005
R28248 _69_.X.n2 _69_.X 2.84494
R28249 _48_.A.n2 _48_.A.n1 585
R28250 _48_.A.n1 _48_.A.n0 292.788
R28251 _48_.A.n3 _48_.A.t3 235.763
R28252 _48_.A.n7 _48_.A.n6 185
R28253 _48_.A.n3 _48_.A.t4 163.464
R28254 _48_.A.n4 _48_.A.n3 156
R28255 _48_.A.n6 _48_.A.t2 40.6159
R28256 _48_.A.n6 _48_.A.t0 40.6159
R28257 _48_.A.n5 _48_.A.n4 33.8436
R28258 _48_.A.n8 _48_.A.n7 30.5104
R28259 _48_.A.n1 _48_.A.t1 27.5805
R28260 _48_.A.n0 _48_.A 10.1493
R28261 _48_.A _48_.A.n2 7.17626
R28262 _48_.A.n8 _48_.A 6.18717
R28263 _48_.A.n2 _48_.A 6.01262
R28264 _48_.A.n4 _48_.A 4.26717
R28265 _48_.A _48_.A.n8 3.87929
R28266 _48_.A.n0 _48_.A 3.01002
R28267 _48_.A.n5 _48_.A 2.53073
R28268 _48_.A.n7 _48_.A.n5 1.48887
R28269 _43_.A.n2 _43_.A.n1 585
R28270 _43_.A.n1 _43_.A.n0 292.788
R28271 _43_.A.n3 _43_.A.t3 235.763
R28272 _43_.A.n7 _43_.A.n6 185
R28273 _43_.A.n3 _43_.A.t4 163.464
R28274 _43_.A.n4 _43_.A.n3 156
R28275 _43_.A.n6 _43_.A.t1 40.6159
R28276 _43_.A.n6 _43_.A.t0 40.6159
R28277 _43_.A.n5 _43_.A.n4 34.5485
R28278 _43_.A.n8 _43_.A.n7 30.5104
R28279 _43_.A.n1 _43_.A.t2 27.5805
R28280 _43_.A.n0 _43_.A 10.1493
R28281 _43_.A _43_.A.n2 7.17626
R28282 _43_.A.n8 _43_.A 6.18717
R28283 _43_.A.n2 _43_.A 6.01262
R28284 _43_.A.n4 _43_.A 4.26717
R28285 _43_.A _43_.A.n8 3.87929
R28286 _43_.A.n0 _43_.A 3.01002
R28287 _43_.A.n5 _43_.A 2.53073
R28288 _43_.A.n7 _43_.A.n5 1.48887
R28289 a_11413_16341.t6 a_11413_16341.n50 330.05
R28290 a_11413_16341.n49 a_11413_16341.n2 327.253
R28291 a_11413_16341.n49 a_11413_16341.n3 217.256
R28292 a_11413_16341.n50 a_11413_16341.n1 217.256
R28293 a_11413_16341.n14 a_11413_16341.t39 212.081
R28294 a_11413_16341.n15 a_11413_16341.t38 212.081
R28295 a_11413_16341.n16 a_11413_16341.t37 212.081
R28296 a_11413_16341.n18 a_11413_16341.t36 212.081
R28297 a_11413_16341.n20 a_11413_16341.t35 212.081
R28298 a_11413_16341.n0 a_11413_16341.t34 212.081
R28299 a_11413_16341.n25 a_11413_16341.t33 212.081
R28300 a_11413_16341.n11 a_11413_16341.t32 212.081
R28301 a_11413_16341.n30 a_11413_16341.t31 212.081
R28302 a_11413_16341.n9 a_11413_16341.t30 212.081
R28303 a_11413_16341.n36 a_11413_16341.t29 212.081
R28304 a_11413_16341.n38 a_11413_16341.t28 212.081
R28305 a_11413_16341.n8 a_11413_16341.t27 212.081
R28306 a_11413_16341.n44 a_11413_16341.t26 212.081
R28307 a_11413_16341.n46 a_11413_16341.t25 212.081
R28308 a_11413_16341.n5 a_11413_16341.t24 212.081
R28309 a_11413_16341.n17 a_11413_16341.n13 169.409
R28310 a_11413_16341.n14 a_11413_16341.t23 162.274
R28311 a_11413_16341.n15 a_11413_16341.t22 162.274
R28312 a_11413_16341.n16 a_11413_16341.t21 162.274
R28313 a_11413_16341.n18 a_11413_16341.t20 162.274
R28314 a_11413_16341.n20 a_11413_16341.t19 162.274
R28315 a_11413_16341.n0 a_11413_16341.t18 162.274
R28316 a_11413_16341.n25 a_11413_16341.t17 162.274
R28317 a_11413_16341.n11 a_11413_16341.t16 162.274
R28318 a_11413_16341.n30 a_11413_16341.t15 162.274
R28319 a_11413_16341.n9 a_11413_16341.t14 162.274
R28320 a_11413_16341.n36 a_11413_16341.t13 162.274
R28321 a_11413_16341.n38 a_11413_16341.t12 162.274
R28322 a_11413_16341.n8 a_11413_16341.t11 162.274
R28323 a_11413_16341.n44 a_11413_16341.t10 162.274
R28324 a_11413_16341.n46 a_11413_16341.t9 162.274
R28325 a_11413_16341.n5 a_11413_16341.t8 162.274
R28326 a_11413_16341.n48 a_11413_16341.n47 152
R28327 a_11413_16341.n45 a_11413_16341.n4 152
R28328 a_11413_16341.n43 a_11413_16341.n42 152
R28329 a_11413_16341.n41 a_11413_16341.n6 152
R28330 a_11413_16341.n40 a_11413_16341.n39 152
R28331 a_11413_16341.n37 a_11413_16341.n7 152
R28332 a_11413_16341.n35 a_11413_16341.n34 152
R28333 a_11413_16341.n33 a_11413_16341.n32 152
R28334 a_11413_16341.n31 a_11413_16341.n10 152
R28335 a_11413_16341.n29 a_11413_16341.n28 152
R28336 a_11413_16341.n27 a_11413_16341.n26 152
R28337 a_11413_16341.n24 a_11413_16341.n12 152
R28338 a_11413_16341.n0 a_11413_16341.n23 152
R28339 a_11413_16341.n22 a_11413_16341.n21 152
R28340 a_11413_16341.n19 a_11413_16341.n13 152
R28341 a_11413_16341.n15 a_11413_16341.n14 55.2698
R28342 a_11413_16341.n16 a_11413_16341.n15 55.2698
R28343 a_11413_16341.n50 a_11413_16341.n49 44.0325
R28344 a_11413_16341.n21 a_11413_16341.n0 43.7018
R28345 a_11413_16341.n24 a_11413_16341.n0 43.7018
R28346 a_11413_16341.n32 a_11413_16341.n31 43.7018
R28347 a_11413_16341.n43 a_11413_16341.n6 43.7018
R28348 a_11413_16341.n49 a_11413_16341.n48 43.5205
R28349 a_11413_16341.n35 a_11413_16341.n9 42.4165
R28350 a_11413_16341.n3 a_11413_16341.t0 40.0005
R28351 a_11413_16341.n3 a_11413_16341.t1 40.0005
R28352 a_11413_16341.n1 a_11413_16341.t2 40.0005
R28353 a_11413_16341.n1 a_11413_16341.t3 40.0005
R28354 a_11413_16341.n45 a_11413_16341.n44 39.8458
R28355 a_11413_16341.n39 a_11413_16341.n8 35.9898
R28356 a_11413_16341.n17 a_11413_16341.n16 35.3472
R28357 a_11413_16341.n30 a_11413_16341.n29 33.4192
R28358 a_11413_16341.n26 a_11413_16341.n25 32.7765
R28359 a_11413_16341.n20 a_11413_16341.n19 31.4912
R28360 a_11413_16341.n37 a_11413_16341.n36 30.8485
R28361 a_11413_16341.n47 a_11413_16341.n46 28.2778
R28362 a_11413_16341.t7 a_11413_16341.t6 27.5805
R28363 a_11413_16341.n2 a_11413_16341.t4 27.5805
R28364 a_11413_16341.n2 a_11413_16341.t5 27.5805
R28365 a_11413_16341.n47 a_11413_16341.n5 26.9925
R28366 a_11413_16341.n38 a_11413_16341.n37 24.4218
R28367 a_11413_16341.n19 a_11413_16341.n18 23.7792
R28368 a_11413_16341.n26 a_11413_16341.n11 22.4938
R28369 a_11413_16341.n29 a_11413_16341.n11 21.2085
R28370 a_11413_16341.n18 a_11413_16341.n17 19.9232
R28371 a_11413_16341.n39 a_11413_16341.n38 19.2805
R28372 a_11413_16341.n22 a_11413_16341.n13 17.4085
R28373 a_11413_16341.n23 a_11413_16341.n22 17.4085
R28374 a_11413_16341.n23 a_11413_16341.n12 17.4085
R28375 a_11413_16341.n27 a_11413_16341.n12 17.4085
R28376 a_11413_16341.n28 a_11413_16341.n27 17.4085
R28377 a_11413_16341.n28 a_11413_16341.n10 17.4085
R28378 a_11413_16341.n33 a_11413_16341.n10 17.4085
R28379 a_11413_16341.n34 a_11413_16341.n33 17.4085
R28380 a_11413_16341.n34 a_11413_16341.n7 17.4085
R28381 a_11413_16341.n40 a_11413_16341.n7 17.4085
R28382 a_11413_16341.n41 a_11413_16341.n40 17.4085
R28383 a_11413_16341.n42 a_11413_16341.n41 17.4085
R28384 a_11413_16341.n42 a_11413_16341.n4 17.4085
R28385 a_11413_16341.n48 a_11413_16341.n4 17.4085
R28386 a_11413_16341.n46 a_11413_16341.n45 15.4245
R28387 a_11413_16341.n36 a_11413_16341.n35 12.8538
R28388 a_11413_16341.n21 a_11413_16341.n20 12.2112
R28389 a_11413_16341.n25 a_11413_16341.n24 10.9258
R28390 a_11413_16341.n31 a_11413_16341.n30 10.2832
R28391 a_11413_16341.n8 a_11413_16341.n6 7.7125
R28392 a_11413_16341.n44 a_11413_16341.n43 3.8565
R28393 a_11413_16341.n32 a_11413_16341.n9 1.28583
R28394 _61_.X _61_.X.t1 744.352
R28395 _61_.X.t1 _61_.X.n2 732.75
R28396 _61_.X.n0 _61_.X.t2 302.731
R28397 _61_.X.n1 _61_.X.t0 216.155
R28398 _61_.X.n0 _61_.X.t3 212.757
R28399 _61_.X _61_.X.n0 170.058
R28400 _61_.X.n2 _61_.X 80.894
R28401 _61_.X.n1 _61_.X 45.7661
R28402 _61_.X _61_.X.n1 3.2005
R28403 _61_.X.n2 _61_.X 2.84494
R28404 a_5055_16341.t1 a_5055_16341.n6 735.244
R28405 a_5055_16341.t1 a_5055_16341.n6 717.596
R28406 a_5055_16341.n2 a_5055_16341.t4 443.44
R28407 a_5055_16341.n3 a_5055_16341.t3 345.305
R28408 a_5055_16341.n3 a_5055_16341.t6 296.969
R28409 a_5055_16341.n1 a_5055_16341.t0 287.998
R28410 a_5055_16341.n0 a_5055_16341.t5 263.173
R28411 a_5055_16341.n2 a_5055_16341.t7 254.389
R28412 a_5055_16341.n0 a_5055_16341.t2 227.826
R28413 a_5055_16341.n4 a_5055_16341.n2 193.59
R28414 a_5055_16341.n1 a_5055_16341.n0 152
R28415 a_5055_16341.n5 a_5055_16341.n1 35.3396
R28416 a_5055_16341.n6 a_5055_16341.n5 26.91
R28417 a_5055_16341.n4 a_5055_16341.n3 12.4401
R28418 a_5055_16341.n5 a_5055_16341.n4 11.0742
R28419 _74_.D _74_.D.t1 744.352
R28420 _74_.D.t1 _74_.D.n3 732.75
R28421 _74_.D.n0 _74_.D.t2 302.731
R28422 _74_.D _74_.D.t0 219.355
R28423 _74_.D.n0 _74_.D.t3 212.757
R28424 _74_.D.n1 _74_.D.n0 166.172
R28425 _74_.D.n3 _74_.D 80.894
R28426 _74_.D.n2 _74_.D.n1 29.3117
R28427 _74_.D _74_.D.n2 12.0894
R28428 _74_.D _74_.D.n2 4.03013
R28429 _74_.D.n1 _74_.D 3.88621
R28430 _74_.D.n3 _74_.D 2.84494
R28431 _50_.B1.t8 _50_.B1.t7 276.464
R28432 _50_.B1.n1 _50_.B1.t6 230.576
R28433 _50_.B1.n8 _50_.B1.t1 217.13
R28434 _50_.B1 _50_.B1.t4 161.504
R28435 _50_.B1.n1 _50_.B1.t5 158.275
R28436 _50_.B1.n0 _50_.B1.t8 153.385
R28437 _50_.B1.n2 _50_.B1.n1 152
R28438 _50_.B1.t4 _50_.B1.t3 148.35
R28439 _50_.B1.t0 _50_.B1.n8 102.269
R28440 _50_.B1.n7 _50_.B1.n0 43.6235
R28441 _50_.B1.n5 _50_.B1.n2 20.488
R28442 _50_.B1.n8 _50_.B1.n7 19.7292
R28443 _50_.B1.n3 _50_.B1 14.1581
R28444 _50_.B1.n5 _50_.B1.n4 13.8005
R28445 _50_.B1.n4 _50_.B1.n3 13.4569
R28446 _50_.B1.n7 _50_.B1.n6 13.1135
R28447 _50_.B1.n6 _50_.B1.n5 9.94109
R28448 _50_.B1.n6 _50_.B1.t2 9.68838
R28449 _50_.B1 _50_.B1.t0 5.84085
R28450 _50_.B1.n4 _50_.B1 5.57999
R28451 _50_.B1.n3 _50_.B1 3.68535
R28452 _50_.B1.n0 _50_.B1 2.94104
R28453 _50_.B1.t2 _50_.B1 2.90959
R28454 _50_.B1.n2 _50_.B1 2.13383
R28455 input2.X.n34 input2.X.n33 585.503
R28456 input2.X.n35 input2.X.n34 585
R28457 input2.X.n1 input2.X.t11 283.844
R28458 input2.X.n15 input2.X.t10 283.844
R28459 input2.X.n4 input2.X.t7 283.844
R28460 input2.X.n20 input2.X.t20 256.07
R28461 input2.X.n23 input2.X.t15 256.07
R28462 input2.X.n26 input2.X.t17 256.07
R28463 input2.X.n30 input2.X.t8 256.07
R28464 input2.X.n10 input2.X.t4 236.18
R28465 input2.X.n8 input2.X.t18 229.369
R28466 input2.X.n0 input2.X.t13 201.369
R28467 input2.X.n14 input2.X.t12 201.369
R28468 input2.X.n5 input2.X.t5 201.369
R28469 input2.X.n37 input2.X.n36 185
R28470 input2.X.n10 input2.X.t6 163.881
R28471 input2.X.n8 input2.X.t19 157.07
R28472 input2.X.n0 input2.X 155.061
R28473 input2.X.n14 input2.X 155.061
R28474 input2.X.n7 input2.X.n4 153.671
R28475 input2.X.n9 input2.X.n8 153.66
R28476 input2.X.n2 input2.X.n1 152
R28477 input2.X.n16 input2.X.n15 152
R28478 input2.X.n6 input2.X.n5 152
R28479 input2.X.n11 input2.X.n10 152
R28480 input2.X.n21 input2.X.n20 152
R28481 input2.X.n24 input2.X.n23 152
R28482 input2.X.n27 input2.X.n26 152
R28483 input2.X.n31 input2.X.n30 152
R28484 input2.X.n20 input2.X.t21 150.03
R28485 input2.X.n23 input2.X.t14 150.03
R28486 input2.X.n26 input2.X.t16 150.03
R28487 input2.X.n30 input2.X.t9 150.03
R28488 input2.X input2.X.n37 81.3181
R28489 input2.X.n1 input2.X.n0 60.6968
R28490 input2.X.n15 input2.X.n14 60.6968
R28491 input2.X.n5 input2.X.n4 60.6968
R28492 input2.X.n33 input2.X.n32 50.4449
R28493 input2.X.n25 input2.X.n22 33.5625
R28494 input2.X.n29 input2.X.n25 29.9456
R28495 input2.X.n34 input2.X.t2 26.5955
R28496 input2.X.n34 input2.X.t3 26.5955
R28497 input2.X.n32 input2.X 26.1175
R28498 input2.X.n25 input2.X 24.9492
R28499 input2.X.n36 input2.X.t0 24.9236
R28500 input2.X.n36 input2.X.t1 24.9236
R28501 input2.X.n12 input2.X.n11 22.2205
R28502 input2.X.n22 input2.X 21.6175
R28503 input2.X.n18 input2.X.n17 21.0438
R28504 input2.X.n18 input2.X.n13 20.017
R28505 input2.X.n32 input2.X.n29 16.9332
R28506 input2.X.n13 input2.X.n7 16.7043
R28507 input2.X.n35 input2.X 15.5613
R28508 input2.X.n19 input2.X.n3 15.4901
R28509 input2.X.n12 input2.X.n9 15.4901
R28510 input2.X.n13 input2.X.n12 15.4401
R28511 input2.X.n22 input2.X.n19 14.3056
R28512 input2.X.n19 input2.X.n18 14.2258
R28513 input2.X.n3 input2.X 14.1918
R28514 input2.X.n17 input2.X 14.1918
R28515 input2.X input2.X.n6 12.5222
R28516 input2.X.n29 input2.X.n28 9.3005
R28517 input2.X.n24 input2.X 9.22489
R28518 input2.X input2.X.n21 8.23114
R28519 input2.X input2.X.n31 8.23114
R28520 input2.X.n21 input2.X 7.6805
R28521 input2.X input2.X.n24 7.6805
R28522 input2.X.n27 input2.X 7.6805
R28523 input2.X.n31 input2.X 7.6805
R28524 input2.X.n11 input2.X 7.46717
R28525 input2.X.n28 input2.X.n27 7.44129
R28526 input2.X.n6 input2.X 6.4005
R28527 input2.X.n37 input2.X 5.27109
R28528 input2.X.n7 input2.X 4.73093
R28529 input2.X.n33 input2.X 4.26717
R28530 input2.X.n9 input2.X 4.26717
R28531 input2.X.n2 input2.X 3.06137
R28532 input2.X.n16 input2.X 3.06137
R28533 input2.X.n28 input2.X 1.78411
R28534 input2.X.n3 input2.X.n2 1.67007
R28535 input2.X.n17 input2.X.n16 1.67007
R28536 input2.X input2.X.n35 1.50638
R28537 _36_.B.t10 _36_.B.t12 378.255
R28538 _36_.B.t18 _36_.B.t15 378.255
R28539 _36_.B.n8 _36_.B.t10 316.318
R28540 _36_.B.n12 _36_.B.t18 316.318
R28541 _36_.B.n3 _36_.B.n0 283.012
R28542 _36_.B.n4 _36_.B.t11 280.363
R28543 _36_.B.n5 _36_.B.t20 257.56
R28544 _36_.B.n7 _36_.B.t5 257.56
R28545 _36_.B.n0 _36_.B.t8 241.536
R28546 _36_.B.n1 _36_.B.t9 241.536
R28547 _36_.B.n10 _36_.B.t17 241.536
R28548 _36_.B.n4 _36_.B.t13 219.31
R28549 _36_.B.n5 _36_.B.t21 197.018
R28550 _36_.B.n7 _36_.B.t4 197.018
R28551 _36_.B.n21 _36_.B.n20 196.846
R28552 _36_.B.n15 _36_.B.t16 185.376
R28553 _36_.B.n0 _36_.B.t6 169.237
R28554 _36_.B.n1 _36_.B.t7 169.237
R28555 _36_.B.n10 _36_.B.t14 169.237
R28556 _36_.B _36_.B.n1 166.891
R28557 _36_.B _36_.B.n10 165.518
R28558 _36_.B _36_.B.n4 155.468
R28559 _36_.B.n16 _36_.B.n15 152
R28560 _36_.B.n15 _36_.B.t19 137.177
R28561 _36_.B.n6 _36_.B.n5 72.2643
R28562 _36_.B _36_.B.n7 68.9673
R28563 _36_.B.n21 _36_.B.n19 54.5077
R28564 _36_.B.t3 _36_.B.n21 48.6768
R28565 _36_.B.n18 _36_.B 28.3277
R28566 _36_.B.n20 _36_.B.t2 26.5955
R28567 _36_.B.n20 _36_.B.t1 26.5955
R28568 _36_.B.n9 _36_.B.n8 25.9505
R28569 _36_.B _36_.B.t0 24.1783
R28570 _36_.B.n13 _36_.B.n12 20.335
R28571 _36_.B.n9 _36_.B 18.7126
R28572 _36_.B.n11 _36_.B 18.4303
R28573 _36_.B.n19 _36_.B.n18 16.9346
R28574 _36_.B.n14 _36_.B.n6 16.302
R28575 _36_.B.n19 _36_.B.n3 15.4806
R28576 _36_.B.n18 _36_.B.n17 13.5884
R28577 _36_.B.n8 _36_.B 13.2419
R28578 _36_.B.n13 _36_.B.n11 12.6628
R28579 _36_.B.n17 _36_.B.n16 10.4135
R28580 _36_.B.n14 _36_.B.n13 10.1339
R28581 _36_.B.n17 _36_.B.n14 9.66533
R28582 _36_.B.t0 _36_.B.t3 5.81868
R28583 _36_.B.n12 _36_.B 5.73843
R28584 _36_.B.n2 _36_.B 4.89462
R28585 _36_.B.n2 _36_.B 4.44132
R28586 _36_.B.n6 _36_.B 3.29747
R28587 _36_.B.n11 _36_.B.n9 3.20792
R28588 _36_.B.n16 _36_.B 2.04108
R28589 _36_.B.n3 _36_.B.n2 1.50638
R28590 _36_.A.t7 _36_.A.t9 230.576
R28591 _36_.A.n0 _36_.A.t8 230.363
R28592 _36_.A.n8 _36_.A.t1 217.13
R28593 _36_.A.n5 _36_.A.t5 170.24
R28594 _36_.A.n0 _36_.A.t6 158.064
R28595 _36_.A.n1 _36_.A.t7 156.268
R28596 _36_.A _36_.A.n0 155.201
R28597 _36_.A.n4 _36_.A.t4 152
R28598 _36_.A.t0 _36_.A.n8 102.269
R28599 _36_.A.t4 _36_.A.t3 37.246
R28600 _36_.A.n2 _36_.A 33.9864
R28601 _36_.A.n8 _36_.A.n7 28.6305
R28602 _36_.A.n3 _36_.A.t2 19.8625
R28603 _36_.A.n7 _36_.A.t10 16.1949
R28604 _36_.A.n3 _36_.A.n2 13.8108
R28605 _36_.A.t3 _36_.A.t5 12.4157
R28606 _36_.A.n7 _36_.A.n6 10.4222
R28607 _36_.A.n6 _36_.A.n5 9.3005
R28608 _36_.A.n2 _36_.A.n1 9.3005
R28609 _36_.A.n6 _36_.A.n3 8.08292
R28610 _36_.A _36_.A.t0 5.84085
R28611 _36_.A.t2 _36_.A 4.26717
R28612 _36_.A.n5 _36_.A.n4 3.5205
R28613 _36_.A.t10 _36_.A 3.06529
R28614 _36_.A.n1 _36_.A 2.4005
R28615 _36_.A.n4 _36_.A 1.9205
R28616 _67_.A.n19 _67_.A.t1 313.481
R28617 _67_.A.n0 _67_.A.t14 276.464
R28618 _67_.A.n2 _67_.A.t2 266.853
R28619 _67_.A.n19 _67_.A.t0 265.769
R28620 _67_.A.t0 _67_.A.n18 265.615
R28621 _67_.A.n8 _67_.A.t10 234.573
R28622 _67_.A.n9 _67_.A.t13 221.72
R28623 _67_.A.n10 _67_.A.t12 221.72
R28624 _67_.A.n13 _67_.A.t11 221.72
R28625 _67_.A.n4 _67_.A.t3 212.081
R28626 _67_.A.n0 _67_.A.t15 196.131
R28627 _67_.A.n7 _67_.A.n2 170.24
R28628 _67_.A.n8 _67_.A.t6 162.274
R28629 _67_.A.n8 _67_.A 154.881
R28630 _67_.A.n1 _67_.A.n0 153.083
R28631 _67_.A.n6 _67_.A.n5 152
R28632 _67_.A _67_.A.n14 152
R28633 _67_.A.n12 _67_.A.n11 152
R28634 _67_.A.n9 _67_.A.t9 149.421
R28635 _67_.A.n10 _67_.A.t8 149.421
R28636 _67_.A.n13 _67_.A.t7 149.421
R28637 _67_.A.n4 _67_.A.t5 139.78
R28638 _67_.A.n3 _67_.A.t4 139.78
R28639 _67_.A.n10 _67_.A.n9 74.9783
R28640 _67_.A.n13 _67_.A.n12 53.5561
R28641 _67_.A.n14 _67_.A.n8 40.1672
R28642 _67_.A.n5 _67_.A.n3 37.246
R28643 _67_.A.n11 _67_.A 26.2405
R28644 _67_.A.n5 _67_.A.n4 24.1005
R28645 _67_.A.n15 _67_.A 23.6805
R28646 _67_.A.n16 _67_.A.n7 23.052
R28647 _67_.A.n12 _67_.A.n10 21.4227
R28648 _67_.A.n14 _67_.A.n13 21.4227
R28649 _67_.A.n17 _67_.A.n1 16.4008
R28650 _67_.A.n17 _67_.A.n16 16.2264
R28651 _67_.A.n18 _67_.A.n17 15.1865
R28652 _67_.A.n3 _67_.A.n2 12.4157
R28653 _67_.A.n16 _67_.A.n15 9.3005
R28654 _67_.A.n15 _67_.A 5.7605
R28655 _67_.A _67_.A.n19 5.4308
R28656 _67_.A.n7 _67_.A.n6 3.5205
R28657 _67_.A _67_.A.n18 3.29747
R28658 _67_.A.n11 _67_.A 3.2005
R28659 _67_.A.n1 _67_.A 3.06529
R28660 _67_.A.n6 _67_.A 1.9205
R28661 _63_.A.n23 _63_.A.t1 313.481
R28662 _63_.A.n13 _63_.A.t16 276.464
R28663 _63_.A.n18 _63_.A.t3 266.853
R28664 _63_.A.t0 _63_.A.n23 265.769
R28665 _63_.A _63_.A.t0 262.318
R28666 _63_.A.n11 _63_.A.t15 241.536
R28667 _63_.A.n7 _63_.A.t14 221.72
R28668 _63_.A.n6 _63_.A.t13 221.72
R28669 _63_.A.n0 _63_.A.t12 221.72
R28670 _63_.A.n1 _63_.A.t11 221.72
R28671 _63_.A.n15 _63_.A.t2 212.081
R28672 _63_.A.n13 _63_.A.t17 196.131
R28673 _63_.A.n11 _63_.A.t10 169.237
R28674 _63_.A _63_.A.n18 164.8
R28675 _63_.A.n19 _63_.A.n16 155.52
R28676 _63_.A _63_.A.n11 153.877
R28677 _63_.A.n14 _63_.A.n13 153.083
R28678 _63_.A.n3 _63_.A.n2 152
R28679 _63_.A.n5 _63_.A.n4 152
R28680 _63_.A.n9 _63_.A.n8 152
R28681 _63_.A.n7 _63_.A.t9 149.421
R28682 _63_.A.n6 _63_.A.t8 149.421
R28683 _63_.A.n0 _63_.A.t7 149.421
R28684 _63_.A.n1 _63_.A.t6 149.421
R28685 _63_.A.n17 _63_.A.t5 139.78
R28686 _63_.A.n15 _63_.A.t4 139.78
R28687 _63_.A.n8 _63_.A.n6 38.382
R28688 _63_.A.n6 _63_.A.n5 37.4894
R28689 _63_.A.n5 _63_.A.n0 37.4894
R28690 _63_.A.n2 _63_.A.n0 37.4894
R28691 _63_.A.n2 _63_.A.n1 37.4894
R28692 _63_.A.n17 _63_.A.n16 37.246
R28693 _63_.A.n8 _63_.A.n7 36.5968
R28694 _63_.A.n16 _63_.A.n15 24.1005
R28695 _63_.A.n4 _63_.A 21.1205
R28696 _63_.A.n20 _63_.A.n19 19.5878
R28697 _63_.A _63_.A.n3 18.5605
R28698 _63_.A.n10 _63_.A.n9 18.2405
R28699 _63_.A.n20 _63_.A.n14 18.1235
R28700 _63_.A.n12 _63_.A 18.0045
R28701 _63_.A.n18 _63_.A.n17 12.4157
R28702 _63_.A.n12 _63_.A.n10 12.3128
R28703 _63_.A.n3 _63_.A 10.8805
R28704 _63_.A.n22 _63_.A.n21 9.3005
R28705 _63_.A.n23 _63_.A.n22 8.72777
R28706 _63_.A.n4 _63_.A 8.3205
R28707 _63_.A.n9 _63_.A 6.0805
R28708 _63_.A.n19 _63_.A 5.4405
R28709 _63_.A.n10 _63_.A 5.1205
R28710 _63_.A.n21 _63_.A.n20 4.5005
R28711 _63_.A _63_.A.n22 3.29747
R28712 _63_.A.n14 _63_.A 3.06529
R28713 _63_.A.n21 _63_.A.n12 2.12653
R28714 _64_.X.n4 _64_.X.n3 588.617
R28715 _64_.X.n5 _64_.X.n4 585
R28716 _64_.X _64_.X.t0 269.426
R28717 _64_.X.n1 _64_.X.t2 260.322
R28718 _64_.X.n1 _64_.X.t3 175.169
R28719 _64_.X.n2 _64_.X.n1 153.385
R28720 _64_.X.n4 _64_.X.t1 46.2955
R28721 _64_.X.n3 _64_.X.n2 29.9299
R28722 _64_.X _64_.X.n0 11.2645
R28723 _64_.X.n6 _64_.X 6.6565
R28724 _64_.X.n0 _64_.X 6.1445
R28725 _64_.X.n0 _64_.X 4.63498
R28726 _64_.X _64_.X.n6 3.61789
R28727 _64_.X.n5 _64_.X 3.47876
R28728 _64_.X.n2 _64_.X 2.94104
R28729 _64_.X.n6 _64_.X.n5 2.36572
R28730 _64_.X.n3 _64_.X 2.36572
R28731 input1.X.n23 input1.X.n22 585.503
R28732 input1.X.n24 input1.X.n23 585
R28733 input1.X.n6 input1.X.t13 232.214
R28734 input1.X.n4 input1.X.t18 230.155
R28735 input1.X.n16 input1.X.t12 221.72
R28736 input1.X.n8 input1.X.t11 221.72
R28737 input1.X.n11 input1.X.t10 221.72
R28738 input1.X.n9 input1.X.t9 221.72
R28739 input1.X.n1 input1.X.t17 212.081
R28740 input1.X.n0 input1.X.t16 212.081
R28741 input1.X.n17 input1.X.n16 194.845
R28742 input1.X.n26 input1.X.n25 185
R28743 input1.X.n10 input1.X 162.881
R28744 input1.X.n6 input1.X.t8 159.915
R28745 input1.X.n4 input1.X.t19 157.856
R28746 input1.X.n5 input1.X.n4 153.147
R28747 input1.X.n3 input1.X.n2 152
R28748 input1.X.n7 input1.X.n6 152
R28749 input1.X.n13 input1.X.n12 152
R28750 input1.X.n15 input1.X.n14 152
R28751 input1.X.n16 input1.X.t7 149.421
R28752 input1.X.n8 input1.X.t6 149.421
R28753 input1.X.n11 input1.X.t5 149.421
R28754 input1.X.n9 input1.X.t4 149.421
R28755 input1.X.n1 input1.X.t15 139.78
R28756 input1.X.n0 input1.X.t14 139.78
R28757 input1.X input1.X.n26 81.3181
R28758 input1.X.n22 input1.X.n21 79.7842
R28759 input1.X.n16 input1.X.n15 37.4894
R28760 input1.X.n15 input1.X.n8 37.4894
R28761 input1.X.n12 input1.X.n8 37.4894
R28762 input1.X.n12 input1.X.n11 37.4894
R28763 input1.X.n11 input1.X.n10 37.4894
R28764 input1.X.n10 input1.X.n9 37.4894
R28765 input1.X.n2 input1.X.n0 37.246
R28766 input1.X.n23 input1.X.t2 26.5955
R28767 input1.X.n23 input1.X.t3 26.5955
R28768 input1.X.n25 input1.X.t0 24.9236
R28769 input1.X.n25 input1.X.t1 24.9236
R28770 input1.X.n2 input1.X.n1 24.1005
R28771 input1.X.n20 input1.X.n5 23.2016
R28772 input1.X.n21 input1.X.n3 19.0101
R28773 input1.X.n19 input1.X.n18 18.2732
R28774 input1.X.n21 input1.X.n20 17.1667
R28775 input1.X.n14 input1.X 16.0005
R28776 input1.X.n13 input1.X 16.0005
R28777 input1.X.n24 input1.X 15.5613
R28778 input1.X.n19 input1.X.n7 15.5145
R28779 input1.X.n20 input1.X.n19 14.142
R28780 input1.X.n14 input1.X 13.4405
R28781 input1.X input1.X.n13 13.4405
R28782 input1.X.n18 input1.X.n17 12.8005
R28783 input1.X.n17 input1.X 12.8005
R28784 input1.X.n26 input1.X 5.27109
R28785 input1.X.n22 input1.X 4.26717
R28786 input1.X.n18 input1.X 3.8405
R28787 input1.X.n5 input1.X 3.24826
R28788 input1.X.n7 input1.X 2.27147
R28789 input1.X.n3 input1.X 1.9205
R28790 input1.X input1.X.n24 1.50638
R28791 output3.A.n17 output3.A.t17 276.464
R28792 output3.A.t0 output3.A.n25 265.769
R28793 output3.A output3.A.t0 262.318
R28794 output3.A.n22 output3.A.n19 248.376
R28795 output3.A.n19 output3.A.t14 241.536
R28796 output3.A.n20 output3.A.t15 241.536
R28797 output3.A.n8 output3.A.t10 234.392
R28798 output3.A.n11 output3.A.t11 230.363
R28799 output3.A.n13 output3.A.t16 229.369
R28800 output3.A.n24 output3.A.t1 222.679
R28801 output3.A.n0 output3.A.t9 221.72
R28802 output3.A.n3 output3.A.t8 221.72
R28803 output3.A.n1 output3.A.t7 221.72
R28804 output3.A.n17 output3.A.t19 196.131
R28805 output3.A.n19 output3.A.t12 169.237
R28806 output3.A.n20 output3.A.t13 169.237
R28807 output3.A output3.A.n20 166.891
R28808 output3.A.n8 output3.A.t5 162.091
R28809 output3.A.n11 output3.A.t6 158.064
R28810 output3.A.n13 output3.A.t18 157.07
R28811 output3.A output3.A.n11 155.201
R28812 output3.A.n14 output3.A.n13 153.66
R28813 output3.A.n18 output3.A.n17 153.083
R28814 output3.A.n2 output3.A 152
R28815 output3.A.n5 output3.A.n4 152
R28816 output3.A.n7 output3.A.n6 152
R28817 output3.A.n9 output3.A.n8 152
R28818 output3.A.n0 output3.A.t4 149.421
R28819 output3.A.n3 output3.A.t3 149.421
R28820 output3.A.n1 output3.A.t2 149.421
R28821 output3.A.n25 output3.A.n24 92.3548
R28822 output3.A.n7 output3.A.n0 37.4894
R28823 output3.A.n4 output3.A.n0 37.4894
R28824 output3.A.n4 output3.A.n3 37.4894
R28825 output3.A.n3 output3.A.n2 37.4894
R28826 output3.A.n2 output3.A.n1 37.4894
R28827 output3.A.n5 output3.A 26.8805
R28828 output3.A.n6 output3.A 24.9605
R28829 output3.A.n23 output3.A.n18 24.5878
R28830 output3.A.n12 output3.A 24.1369
R28831 output3.A.n8 output3.A.n7 24.1005
R28832 output3.A.n15 output3.A.n14 21.5079
R28833 output3.A.n9 output3.A 21.4405
R28834 output3.A.n16 output3.A.n15 18.2196
R28835 output3.A.n24 output3.A.n23 15.8321
R28836 output3.A.n12 output3.A.n10 11.7989
R28837 output3.A.n23 output3.A.n22 9.3005
R28838 output3.A.n25 output3.A.n16 8.72777
R28839 output3.A.n15 output3.A.n12 8.27676
R28840 output3.A.n10 output3.A 5.1205
R28841 output3.A.n21 output3.A 4.89462
R28842 output3.A.n6 output3.A 4.4805
R28843 output3.A.n21 output3.A 4.44132
R28844 output3.A.n14 output3.A 4.26717
R28845 output3.A output3.A.n16 3.29747
R28846 output3.A.n18 output3.A 3.06529
R28847 output3.A.n10 output3.A.n9 2.8805
R28848 output3.A output3.A.n5 1.9205
R28849 output3.A.n22 output3.A.n21 1.50638
C0 _42_.A2 _40_.A1 0.13511f
C1 input2.X _54_.Y 0.15722f
C2 _36_.A a_20540_16617# 0.03952f
C3 a_1407_3311# enable_i 0.12196f
C4 _64_.X _75_.CLK 0.11344f
C5 a_12134_15797# VDD 0.14568f
C6 _36_.B _36_.Y 0.03771f
C7 a_12684_16885# VDD 0.23502f
C8 input1.X input2.X 1.42174f
C9 a_22568_16911# VDD 0.01061f
C10 input2.X a_5609_16367# 0.01215f
C11 input2.X a_26965_16617# 0.03492f
C12 _36_.B _69_.A 0.03001f
C13 _63_.A a_7699_16733# 0.01339f
C14 _48_.X a_23009_15279# 0.15519f
C15 a_22843_15279# a_23450_15391# 0.08535f
C16 _44_.Y a_22751_16733# 0.0386f
C17 _67_.B VDD 0.55604f
C18 _36_.A a_20267_16733# 0.04653f
C19 a_4057_16617# VDD 0.16668f
C20 _55_.A_N a_28253_15823# 0.09337f
C21 a_28433_17143# a_28529_16885# 0.27397f
C22 hold12.A a_27995_16367# 0.01677f
C23 _50_.B1 a_27755_15645# 0.03802f
C24 a_11527_15829# a_11881_15823# 0.04548f
C25 _67_.A _69_.A 0.05283f
C26 _36_.B a_10547_16395# 0.04058f
C27 a_12391_15823# clock_i 0.01115f
C28 _42_.A2 a_20540_16617# 0.06328f
C29 _36_.Y a_17857_16367# 0.03037f
C30 input2.X _53_.A 0.02528f
C31 _38_.A a_17691_16367# 0.01863f
C32 _77_.CLK _53_.X 0.11756f
C33 a_4771_16341# clock_i 0.01307f
C34 a_7274_16733# VDD 0.19966f
C35 _54_.Y a_27133_16617# 0.03048f
C36 _77_.CLK a_25460_15797# 0.04256f
C37 a_17857_16367# a_18130_16733# 0.07176f
C38 output3.A _74_.D 0.04151f
C39 a_27245_15279# VDD 0.05042f
C40 a_17691_16367# _38_.X 0.07118f
C41 _67_.A a_10547_16395# 0.06507f
C42 _75_.CLK a_17691_16367# 0.13701f
C43 _69_.A clock_i 0.05403f
C44 _63_.A a_6883_16055# 0.05647f
C45 _50_.A2 a_22189_16367# 0.01083f
C46 input1.X _75_.CLK 0.07143f
C47 _36_.B _50_.B1 0.2333f
C48 _36_.A a_20407_15431# 0.0625f
C49 a_26965_16617# a_27133_16617# 0.08485f
C50 _44_.Y _77_.Q 0.2758f
C51 clkbuf_0_clock_i.X _43_.A 0.02816f
C52 _63_.A VDD 1.09709f
C53 _63_.B a_7001_16367# 0.03225f
C54 a_29027_16635# VDD 0.34328f
C55 input2.X a_4107_16161# 0.0693f
C56 VDD counter_value_o[2] 0.12759f
C57 _77_.Q _43_.X 0.21518f
C58 output3.A a_6835_16367# 0.09105f
C59 _46_.X _50_.A2 0.01964f
C60 _70_.Q a_23352_16519# 0.17232f
C61 _50_.B1 _77_.CLK 0.12945f
C62 _55_.Y hold12.A 0.17793f
C63 a_26891_15279# a_27057_15279# 0.55626f
C64 _36_.A a_21341_15279# 0.01134f
C65 _77_.Q _43_.A 0.10906f
C66 a_6927_16911# _63_.B 0.04352f
C67 _53_.A a_26339_15279# 0.16048f
C68 _50_.A2 _51_.X 0.01021f
C69 _36_.B a_18611_15831# 0.02778f
C70 _67_.A a_9523_16143# 0.06471f
C71 a_11527_15829# a_11693_15829# 0.56916f
C72 _64_.X a_6835_16367# 0.04894f
C73 _77_.CLK a_23009_15279# 0.01097f
C74 a_12559_15797# VDD 0.31805f
C75 input2.X hold12.A 0.01829f
C76 _45_.Y VDD 0.37568f
C77 a_4675_16519# VDD 0.3264f
C78 _55_.A_N _55_.Y 0.01129f
C79 _36_.B a_22751_16733# 0.02503f
C80 input1.X _60_.X 0.08333f
C81 _50_.B1 _57_.Y 0.12497f
C82 a_9523_16143# clock_i 0.01269f
C83 a_18298_16479# VDD 0.14198f
C84 _48_.X a_23282_15645# 0.01632f
C85 a_22843_15279# a_23875_15547# 0.02545f
C86 _44_.Y _70_.Q 0.23201f
C87 a_6407_16395# VDD 0.1645f
C88 a_4675_16519# a_5062_16641# 0.01914f
C89 a_28529_16885# a_28787_16885# 0.14651f
C90 _36_.B a_24777_15939# 0.10208f
C91 _36_.B clkbuf_0_clock_i.X 0.51223f
C92 _40_.Y _43_.A 0.11312f
C93 _36_.Y a_18130_16733# 0.01727f
C94 input2.X _55_.A_N 0.04463f
C95 a_7699_16733# VDD 0.15553f
C96 _77_.CLK a_28017_15823# 0.05096f
C97 _77_.CLK a_24777_15939# 0.07017f
C98 hold12.X a_28161_16367# 0.18508f
C99 _36_.B a_17987_15279# 0.2579f
C100 a_27995_16367# a_28602_16479# 0.09081f
C101 output3.A a_3889_16617# 0.01735f
C102 a_17857_16367# a_18555_16733# 0.10662f
C103 _36_.B _77_.Q 0.74997f
C104 _36_.A input2.X 0.23311f
C105 _57_.Y a_25309_16617# 0.01725f
C106 _67_.A clkbuf_0_clock_i.X 0.04405f
C107 input1.X a_6835_16367# 0.01914f
C108 _36_.A a_20794_15553# 0.24749f
C109 _63_.Y clock_i 0.04519f
C110 a_27133_16617# hold12.A 0.1006f
C111 a_28349_16367# VDD 0.05355f
C112 a_20794_15553# a_20923_15279# 0.0669f
C113 a_20503_15253# _43_.X 0.01071f
C114 _77_.Q _77_.CLK 0.11898f
C115 output3.A a_7442_16479# 0.04711f
C116 a_10547_16395# _69_.A 0.06925f
C117 _48_.X a_23027_14735# 0.21179f
C118 a_4107_16161# _60_.X 0.08221f
C119 a_27057_15279# a_27498_15391# 0.0669f
C120 a_26891_15279# a_27330_15645# 0.14732f
C121 clkbuf_0_clock_i.X clock_i 0.1448f
C122 _77_.Q a_22480_17277# 0.01043f
C123 _36_.A a_18225_15279# 0.04823f
C124 _63_.A _63_.B 0.19595f
C125 a_6883_16055# VDD 0.2512f
C126 VDD counter_value_o[3] 0.11362f
C127 _50_.B1 a_32503_16919# 0.12892f
C128 _44_.Y _48_.A 0.05309f
C129 _54_.A VDD 0.30606f
C130 _36_.A _38_.A 0.02943f
C131 a_11527_15829# a_11966_15823# 0.16041f
C132 input2.X _50_.A2 0.05897f
C133 _36_.A _38_.X 0.06778f
C134 a_5062_16641# VDD 0.27145f
C135 output3.A _36_.B 0.13055f
C136 input2.X counter_value_o[1] 0.04587f
C137 _50_.Y _53_.A 0.07156f
C138 a_37471_16919# VDD 0.21657f
C139 _36_.B _40_.Y 0.12665f
C140 _48_.A _48_.X 0.05691f
C141 _36_.B _70_.Q 0.09487f
C142 _50_.B1 _53_.X 0.06847f
C143 a_11527_15829# clock_i 0.01871f
C144 a_20868_16519# VDD 0.12333f
C145 a_18723_16635# VDD 0.30013f
C146 _45_.Y counter_value_o[4] 0.03344f
C147 a_6927_16911# input2.X 0.03466f
C148 _70_.Q _77_.CLK 0.09559f
C149 a_28787_16885# _55_.A_N 0.17446f
C150 output3.A a_3807_16617# 0.15396f
C151 _55_.A_N counter_value_o[6] 0.05423f
C152 _40_.A1 VDD 0.64649f
C153 a_7001_16367# a_7189_16367# 0.0632f
C154 _45_.Y _46_.X 0.07628f
C155 a_27366_16055# VDD 0.12392f
C156 a_18183_17249# input2.X 0.11046f
C157 a_5191_16367# clock_i 0.01005f
C158 a_27995_16367# a_29027_16635# 0.02545f
C159 hold12.X a_28434_16733# 0.03631f
C160 output3.A clock_i 0.22414f
C161 a_17691_16367# a_18045_16367# 0.04043f
C162 output3.A _60_.B 0.11911f
C163 a_17652_16885# _36_.A 0.12206f
C164 a_25235_15823# VDD 0.11649f
C165 _36_.A a_20994_15253# 0.03084f
C166 _75_.CLK a_7001_16367# 0.04703f
C167 _36_.Y clkbuf_0_clock_i.X 0.06852f
C168 a_26965_16367# VDD 0.03067f
C169 a_12684_16885# input2.X 0.05028f
C170 a_20994_15253# a_20923_15279# 0.16113f
C171 _57_.Y a_26799_16367# 0.2001f
C172 output3.A a_7867_16635# 0.07157f
C173 a_20868_16519# _40_.A1 0.10229f
C174 VDD reset_n_i 0.24553f
C175 _63_.A a_6925_16143# 0.0261f
C176 _36_.Y a_17987_15279# 0.10566f
C177 a_27057_15279# a_27923_15547# 0.01914f
C178 a_27498_15391# a_27330_15645# 0.16113f
C179 a_26891_15279# a_27755_15645# 0.02944f
C180 _64_.X clock_i 0.01882f
C181 a_18183_17249# _38_.A 0.06926f
C182 _36_.B _48_.A 0.01979f
C183 _77_.CLK hold12.X 0.02144f
C184 a_10883_15823# VDD 0.1944f
C185 a_20540_16617# VDD 0.12143f
C186 _40_.A1 a_20627_16189# 0.04231f
C187 _48_.A _77_.CLK 0.13406f
C188 _36_.B a_17691_16367# 0.11236f
C189 a_11527_15829# a_12391_15823# 0.03079f
C190 a_23450_15391# VDD 0.1442f
C191 input1.X _36_.B 0.19758f
C192 _67_.Y VDD 0.27384f
C193 _63_.B a_6883_16055# 0.23906f
C194 _48_.A a_23024_16617# 0.04694f
C195 VDD counter_value_o[4] 0.1025f
C196 a_5262_16341# VDD 0.20459f
C197 _63_.B VDD 0.50074f
C198 a_2748_16885# VDD 0.23068f
C199 input1.X _67_.A 0.03779f
C200 _77_.CLK a_26891_15279# 0.20527f
C201 _50_.B1 a_24777_15939# 0.17235f
C202 _46_.X VDD 0.12233f
C203 a_20267_16733# VDD 0.17833f
C204 _48_.X a_23197_15279# 0.10084f
C205 input1.X a_3807_16617# 0.06192f
C206 a_4771_16341# a_5191_16367# 0.0205f
C207 _63_.A input2.X 0.08558f
C208 a_5062_16641# a_5262_16341# 0.06803f
C209 a_4675_16519# _61_.X 0.04617f
C210 input2.X counter_value_o[2] 0.05115f
C211 _36_.B _53_.A 0.01039f
C212 output3.A a_4771_16341# 0.03177f
C213 a_17691_16367# a_17857_16367# 0.56029f
C214 input1.X a_9369_16367# 0.16412f
C215 _40_.A1 a_20540_16617# 0.01752f
C216 a_7274_16733# a_7189_16367# 0.02068f
C217 a_28253_15823# VDD 0.25976f
C218 _75_.CLK _67_.B 0.31703f
C219 _51_.X VDD 0.1388f
C220 input1.X _60_.B 0.0514f
C221 input1.X clock_i 0.23544f
C222 _77_.CLK _53_.A 0.11103f
C223 _74_.D a_7001_16367# 0.15091f
C224 a_27995_16367# a_28349_16367# 0.04548f
C225 a_23352_16519# _50_.A2 0.0399f
C226 a_20359_14735# VDD 0.34753f
C227 _36_.A _44_.Y 0.04076f
C228 _57_.Y a_26965_16617# 0.02298f
C229 clkbuf_0_clock_i.X a_18611_15831# 0.07292f
C230 _55_.A_N counter_value_o[7] 0.03661f
C231 a_20407_15431# VDD 0.31997f
C232 _36_.A _43_.X 0.20058f
C233 a_6835_16367# a_7001_16367# 0.56037f
C234 _75_.CLK a_7274_16733# 0.03306f
C235 a_6927_16911# _74_.D 0.06742f
C236 a_20923_15279# _43_.X 0.04484f
C237 input2.X _45_.Y 0.13622f
C238 a_20267_16733# _40_.A1 0.06578f
C239 input2.X a_4675_16519# 0.0595f
C240 _50_.A2 _50_.Y 0.04292f
C241 _36_.A _43_.A 0.13407f
C242 a_27995_16367# VDD 0.51404f
C243 a_21341_15279# VDD 0.0552f
C244 a_27057_15279# a_27245_15279# 0.06023f
C245 a_27498_15391# a_27755_15645# 0.0205f
C246 _63_.A _75_.CLK 0.06892f
C247 _69_.X VDD 0.30992f
C248 input2.X a_6407_16395# 0.06194f
C249 a_6883_16055# a_6925_16143# 0.01271f
C250 a_23875_15547# VDD 0.31123f
C251 VDD enable_i 0.24549f
C252 input1.X a_4535_15823# 0.04198f
C253 _60_.B a_4107_16161# 0.11007f
C254 a_23009_15279# a_23282_15645# 0.07505f
C255 a_28161_16367# a_28602_16479# 0.08006f
C256 _36_.A a_18045_16367# 0.03018f
C257 _44_.Y _50_.A2 0.31628f
C258 a_22843_15279# _48_.X 0.07118f
C259 _61_.X VDD 0.26369f
C260 _51_.X a_25235_15823# 0.07682f
C261 hold12.A _77_.CLK 0.11684f
C262 _67_.A a_9761_16143# 0.05046f
C263 _77_.Q clkbuf_0_clock_i.X 0.03203f
C264 _77_.CLK a_27498_15391# 0.04777f
C265 _55_.Y VDD 0.3224f
C266 _36_.Y a_17691_16367# 0.03f
C267 a_5062_16641# _61_.X 0.12703f
C268 VDD counter_value_o[5] 0.10501f
C269 _54_.A counter_value_o[5] 0.11201f
C270 _70_.Q a_23009_15279# 0.02618f
C271 _38_.X a_18298_16479# 0.0473f
C272 a_17691_16367# a_18130_16733# 0.14732f
C273 a_28433_17143# VDD 0.15328f
C274 _75_.CLK a_6407_16395# 0.06365f
C275 _54_.A a_28433_17143# 0.0824f
C276 _36_.A _36_.B 0.74983f
C277 _55_.A_N _77_.CLK 0.1431f
C278 input2.X counter_value_o[3] 0.05183f
C279 output3.A _63_.Y 0.08502f
C280 input2.X _54_.A 0.04096f
C281 input2.X VDD 14.9052f
C282 a_1407_9839# VDD 0.23514f
C283 _70_.Q a_22751_16733# 0.0386f
C284 _53_.X a_26891_15279# 0.07424f
C285 _36_.A _77_.CLK 0.20678f
C286 a_20794_15553# VDD 0.27249f
C287 a_6835_16367# a_7274_16733# 0.14732f
C288 a_7001_16367# a_7442_16479# 0.07515f
C289 _75_.CLK a_7699_16733# 0.03801f
C290 _63_.A _74_.D 0.01827f
C291 input2.X a_5062_16641# 0.25178f
C292 _55_.Y a_27366_16055# 0.11631f
C293 clkbuf_0_clock_i.X _40_.Y 0.07074f
C294 a_10883_15823# _69_.X 0.07437f
C295 a_11693_15829# a_12134_15797# 0.08347f
C296 a_27923_15547# a_27755_15645# 0.20625f
C297 a_27330_15645# a_27245_15279# 0.02068f
C298 a_7716_16885# counter_value_o[1] 0.11499f
C299 _77_.CLK a_22843_15279# 0.1647f
C300 _53_.A _53_.X 0.01185f
C301 a_7189_16367# VDD 0.04875f
C302 _36_.A a_17857_16367# 0.0728f
C303 _38_.A VDD 0.48593f
C304 a_25460_15797# _53_.A 0.13665f
C305 _36_.B _50_.A2 0.98993f
C306 _77_.Q _40_.Y 0.12795f
C307 _70_.Q _77_.Q 0.16198f
C308 a_26799_16367# a_27133_16367# 0.02983f
C309 _50_.B1 a_26891_15279# 0.22825f
C310 _55_.Y a_26965_16367# 0.04131f
C311 _48_.A a_23009_15279# 0.04123f
C312 a_26339_15279# VDD 0.33289f
C313 a_28161_16367# a_29027_16635# 0.01914f
C314 a_28602_16479# a_28434_16733# 0.16113f
C315 input2.X _40_.A1 0.08303f
C316 input2.X a_27366_16055# 0.13452f
C317 _38_.X VDD 0.28442f
C318 a_23009_15279# a_23707_15645# 0.10857f
C319 _75_.CLK VDD 4.67694f
C320 _50_.A2 _77_.CLK 0.05148f
C321 a_27133_16617# VDD 0.09269f
C322 a_27057_15279# VDD 0.26463f
C323 _55_.A_N a_28859_16733# 0.01481f
C324 _67_.B a_8657_16367# 0.01172f
C325 a_22751_16733# _48_.A 0.10498f
C326 _50_.A2 a_23024_16617# 0.03809f
C327 _77_.CLK a_27923_15547# 0.04272f
C328 _56_.Y VDD 0.18617f
C329 _38_.A a_18723_16635# 0.01279f
C330 _50_.B1 _53_.A 0.05022f
C331 _63_.B a_6925_16143# 0.0504f
C332 _77_.Q a_22843_16919# 0.11212f
C333 a_5262_16341# _61_.X 0.01387f
C334 input2.X a_26965_16367# 0.05051f
C335 _70_.Q a_23282_15645# 0.01587f
C336 _77_.Q a_20503_15253# 0.0511f
C337 output3.A a_5191_16367# 0.02115f
C338 _38_.X a_18723_16635# 0.02819f
C339 a_17691_16367# a_18555_16733# 0.02944f
C340 a_1407_9839# reset_n_i 0.12196f
C341 a_28787_16885# VDD 0.26312f
C342 input1.X _63_.Y 0.17389f
C343 a_7001_16367# clock_i 0.02122f
C344 VDD counter_value_o[6] 0.1216f
C345 a_17652_16885# counter_value_o[3] 0.11431f
C346 _50_.A2 _57_.Y 0.08999f
C347 a_17652_16885# VDD 0.21988f
C348 clkbuf_0_clock_i.X a_17691_16367# 0.05911f
C349 a_20994_15253# VDD 0.20457f
C350 a_6835_16367# a_7699_16733# 0.02944f
C351 a_7442_16479# a_7274_16733# 0.16113f
C352 _55_.A_N a_32503_16919# 0.04959f
C353 a_7001_16367# a_7867_16635# 0.01914f
C354 _54_.Y a_27133_16367# 0.06235f
C355 input2.X _67_.Y 0.08494f
C356 _60_.X VDD 0.22027f
C357 input2.X counter_value_o[4] 0.02528f
C358 input2.X a_5262_16341# 0.03215f
C359 output3.A _64_.X 0.15399f
C360 _44_.Y _45_.Y 0.18236f
C361 input2.X _63_.B 0.1068f
C362 _36_.A _36_.Y 0.24083f
C363 _70_.Q a_27535_16919# 0.12611f
C364 a_11693_15829# a_12559_15797# 0.01914f
C365 a_12134_15797# a_11966_15823# 0.16113f
C366 _36_.B _67_.B 0.19242f
C367 a_12684_16885# _67_.A 0.13271f
C368 a_27133_16617# a_26965_16367# 0.01282f
C369 input2.X a_20267_16733# 0.14836f
C370 _70_.Q a_22843_16919# 0.05342f
C371 _50_.Y a_25148_15279# 0.02935f
C372 _36_.A a_18130_16733# 0.05023f
C373 _74_.D VDD 0.35217f
C374 _50_.B1 a_27498_15391# 0.01662f
C375 a_9523_16143# a_9761_16143# 0.01271f
C376 a_7716_16885# _63_.A 0.12203f
C377 _67_.A _67_.B 0.2566f
C378 a_28161_16367# a_28349_16367# 0.0632f
C379 a_23352_16519# VDD 0.11236f
C380 a_28602_16479# a_28859_16733# 0.0205f
C381 a_23009_15279# a_23197_15279# 0.0632f
C382 a_11881_15823# VDD 0.05353f
C383 a_3807_16617# a_4057_16617# 0.01818f
C384 a_6835_16367# VDD 0.36639f
C385 a_27330_15645# VDD 0.20094f
C386 a_8951_16367# a_9369_16367# 0.09762f
C387 _67_.B a_9369_16367# 0.02045f
C388 _63_.A _36_.B 0.16644f
C389 _54_.Y a_26799_16367# 0.03038f
C390 _67_.B clock_i 0.07377f
C391 _70_.Q _48_.A 0.11789f
C392 _77_.CLK a_27245_15279# 0.01846f
C393 _50_.Y VDD 0.29722f
C394 a_8951_16367# clock_i 0.01692f
C395 _55_.A_N _50_.B1 0.05734f
C396 _70_.Q _54_.Y 0.0455f
C397 a_4057_16617# _60_.B 0.04704f
C398 a_28161_16367# VDD 0.27889f
C399 _63_.B _75_.CLK 0.02202f
C400 hold12.X a_28359_15823# 0.0803f
C401 a_20407_15431# a_20794_15553# 0.01914f
C402 _70_.Q a_23707_15645# 0.04782f
C403 output3.A input1.X 0.38362f
C404 output3.A a_5609_16367# 0.01631f
C405 a_26799_16367# a_26965_16617# 0.08152f
C406 a_27535_16919# _54_.Y 0.01401f
C407 _67_.A counter_value_o[2] 0.01009f
C408 a_7274_16733# clock_i 0.01119f
C409 a_20794_15553# a_21341_15279# 0.06023f
C410 _48_.A a_23027_14735# 0.1572f
C411 _44_.Y VDD 0.61585f
C412 hold12.A a_28017_15823# 0.16771f
C413 _43_.X VDD 0.38265f
C414 _63_.A a_9369_16367# 0.09027f
C415 input1.X _64_.X 0.19407f
C416 a_7442_16479# a_7699_16733# 0.0205f
C417 _63_.A clock_i 0.11473f
C418 _36_.B _45_.Y 0.03538f
C419 a_11693_15829# VDD 0.25835f
C420 a_18183_17249# _36_.Y 0.11409f
C421 VDD counter_value_o[7] 0.12246f
C422 input2.X _61_.X 0.29304f
C423 _43_.A VDD 0.33111f
C424 _36_.B a_9727_16367# 0.09772f
C425 a_12134_15797# a_12391_15823# 0.0205f
C426 _48_.X VDD 0.35676f
C427 _67_.A a_12559_15797# 0.06112f
C428 _63_.A a_7867_16635# 0.07998f
C429 hold12.A a_27133_16367# 0.03986f
C430 input2.X _55_.Y 0.08615f
C431 _50_.B1 _50_.A2 0.56844f
C432 a_22843_15279# a_23009_15279# 0.56491f
C433 _36_.A a_18555_16733# 0.04252f
C434 a_37471_16919# counter_value_o[7] 0.15024f
C435 _45_.Y a_23024_16617# 0.03932f
C436 a_22480_17277# _45_.Y 0.02803f
C437 a_3889_16617# VDD 0.01359f
C438 _50_.Y a_25235_15823# 0.04753f
C439 _55_.A_N a_28017_15823# 0.04632f
C440 _50_.B1 a_27923_15547# 0.10724f
C441 _67_.A a_9727_16367# 0.08746f
C442 a_12559_15797# clock_i 0.01459f
C443 a_18045_16367# VDD 0.04854f
C444 _75_.CLK _69_.X 0.06198f
C445 a_28434_16733# a_28349_16367# 0.02068f
C446 a_29027_16635# a_28859_16733# 0.20625f
C447 a_23282_15645# a_23197_15279# 0.02068f
C448 a_4675_16519# clock_i 0.01891f
C449 _54_.Y a_26965_16617# 0.06374f
C450 a_7442_16479# VDD 0.14466f
C451 _36_.B a_25148_15279# 0.03387f
C452 _36_.A clkbuf_0_clock_i.X 0.10009f
C453 _63_.B _74_.D 0.12247f
C454 a_17857_16367# a_18298_16479# 0.07515f
C455 input2.X a_1407_9839# 0.11218f
C456 a_27755_15645# VDD 0.15427f
C457 a_9369_16367# a_9727_16367# 0.09676f
C458 _40_.A1 _43_.A 0.11628f
C459 a_9727_16367# clock_i 0.022f
C460 a_6407_16395# clock_i 0.01359f
C461 _36_.A a_17987_15279# 0.08149f
C462 a_7716_16885# VDD 0.22836f
C463 a_28434_16733# VDD 0.20381f
C464 _36_.A _77_.Q 0.41902f
C465 _63_.B a_6835_16367# 0.03489f
C466 _77_.Q a_20923_15279# 0.02391f
C467 _46_.X a_23352_16519# 0.12263f
C468 a_22751_16733# _50_.A2 0.03082f
C469 _55_.Y a_27133_16617# 0.02343f
C470 a_7699_16733# clock_i 0.01464f
C471 _36_.B VDD 9.29571f
C472 a_20994_15253# a_21341_15279# 0.02068f
C473 input2.X _38_.A 0.06442f
C474 _50_.A2 a_24777_15939# 0.08282f
C475 _77_.CLK VDD 2.58255f
C476 _53_.X a_27245_15279# 0.07557f
C477 _36_.B a_25225_16617# 0.01399f
C478 a_7867_16635# a_7699_16733# 0.20625f
C479 a_11966_15823# VDD 0.20501f
C480 _67_.A VDD 1.00335f
C481 input1.X a_1407_3311# 0.11218f
C482 _43_.A a_20540_16617# 0.04545f
C483 input2.X a_27133_16617# 0.03249f
C484 a_3807_16617# VDD 0.20075f
C485 input2.X _75_.CLK 0.17107f
C486 a_23024_16617# VDD 0.10865f
C487 _51_.X _50_.Y 0.07871f
C488 _77_.Q _50_.A2 0.17056f
C489 _36_.B a_20868_16519# 0.07567f
C490 a_12559_15797# a_12391_15823# 0.20625f
C491 _67_.B a_9523_16143# 0.22435f
C492 input1.X a_4107_16161# 0.06239f
C493 a_6883_16055# clock_i 0.01185f
C494 a_22843_15279# a_23282_15645# 0.15923f
C495 _48_.X a_23450_15391# 0.01001f
C496 input2.X _56_.Y 0.02392f
C497 a_17857_16367# VDD 0.25499f
C498 _44_.Y _46_.X 0.08175f
C499 a_4675_16519# a_4771_16341# 0.20625f
C500 VDD clock_i 2.87866f
C501 _60_.B VDD 0.26517f
C502 _55_.A_N a_28359_15823# 0.06943f
C503 _36_.B _40_.A1 0.20971f
C504 _36_.B a_20627_16189# 0.02662f
C505 a_25236_15601# VDD 0.01037f
C506 _50_.B1 a_27245_15279# 0.01713f
C507 _69_.X a_11881_15823# 0.07574f
C508 a_20267_16733# _43_.A 0.12738f
C509 _57_.Y VDD 0.75936f
C510 _75_.CLK a_7189_16367# 0.01743f
C511 _36_.Y a_18298_16479# 0.01624f
C512 _38_.A _38_.X 0.11584f
C513 _54_.Y hold12.A 0.04177f
C514 a_7867_16635# VDD 0.31599f
C515 a_5062_16641# clock_i 0.02919f
C516 _77_.CLK a_27366_16055# 0.04101f
C517 _70_.Q a_22843_15279# 0.05417f
C518 _36_.B a_25235_15823# 0.02972f
C519 a_27995_16367# a_28161_16367# 0.56528f
C520 a_18298_16479# a_18130_16733# 0.16113f
C521 a_17857_16367# a_18723_16635# 0.01914f
C522 a_17652_16885# input2.X 0.05486f
C523 _50_.A2 a_22273_16367# 0.01172f
C524 _57_.Y a_25225_16617# 0.01206f
C525 _36_.A a_20503_15253# 0.04775f
C526 _43_.X a_20359_14735# 0.20763f
C527 a_26965_16617# hold12.A 0.01439f
C528 a_28859_16733# VDD 0.1691f
C529 a_20503_15253# a_20923_15279# 0.0205f
C530 _55_.A_N hold12.X 0.05884f
C531 a_20794_15553# a_20994_15253# 0.06803f
C532 output3.A a_7001_16367# 0.1626f
C533 _70_.Q _50_.A2 0.15036f
C534 _43_.A a_20359_14735# 0.1583f
C535 _40_.Y _42_.A2 0.07439f
C536 _43_.A a_20407_15431# 0.0208f
C537 a_10547_16395# a_9727_16367# 0.01362f
C538 a_26891_15279# a_27498_15391# 0.08536f
C539 _43_.X a_21341_15279# 0.08827f
C540 a_4535_15823# VDD 0.15921f
C541 input2.X _74_.D 0.04461f
C542 _36_.B _67_.Y 0.01518f
C543 a_11527_15829# a_12134_15797# 0.09081f
C544 _69_.X a_11693_15829# 0.14178f
C545 _36_.B counter_value_o[4] 0.01304f
C546 a_12391_15823# VDD 0.15672f
C547 _36_.A a_17691_16367# 0.18043f
C548 a_4771_16341# VDD 0.16572f
C549 a_32503_16919# VDD 0.21847f
C550 _36_.Y VDD 0.48047f
C551 _36_.B _46_.X 0.02171f
C552 _57_.Y a_26965_16367# 0.03313f
C553 _48_.A a_22843_15279# 0.04176f
C554 _67_.A _67_.Y 0.1927f
C555 _64_.X a_6927_16911# 0.13457f
C556 input2.X _50_.Y 0.01249f
C557 a_18130_16733# VDD 0.18972f
C558 _69_.A VDD 0.26159f
C559 a_22843_15279# a_23707_15645# 0.02944f
C560 _74_.D a_7189_16367# 0.08327f
C561 a_22480_17277# counter_value_o[4] 0.05419f
C562 a_4771_16341# a_5062_16641# 0.10925f
C563 _36_.B _51_.X 0.09908f
C564 _50_.B1 a_25148_15279# 0.04149f
C565 _53_.X VDD 0.34021f
C566 _40_.Y a_20624_16367# 0.01156f
C567 _46_.X a_23024_16617# 0.06328f
C568 _50_.A2 _48_.A 0.01972f
C569 _67_.Y clock_i 0.05448f
C570 a_6835_16367# a_7189_16367# 0.04087f
C571 _45_.Y a_22751_16733# 0.03938f
C572 a_25460_15797# VDD 0.19641f
C573 a_10547_16395# VDD 0.15232f
C574 a_5262_16341# clock_i 0.01065f
C575 _74_.D _75_.CLK 0.02489f
C576 _77_.CLK a_28253_15823# 0.01868f
C577 _63_.B clock_i 0.06197f
C578 _77_.CLK _51_.X 0.06661f
C579 output3.A a_8951_16367# 0.13099f
C580 output3.A _67_.B 0.18187f
C581 hold12.X a_28602_16479# 0.03811f
C582 a_27995_16367# a_28434_16733# 0.16041f
C583 output3.A a_4057_16617# 0.09535f
C584 _44_.Y input2.X 0.26127f
C585 a_18298_16479# a_18555_16733# 0.0205f
C586 _75_.CLK a_6835_16367# 0.38166f
C587 a_6407_16395# _63_.Y 0.11222f
C588 a_20794_15553# _43_.X 0.13704f
C589 input2.X _43_.A 0.01629f
C590 _50_.B1 VDD 4.97342f
C591 output3.A a_7274_16733# 0.03114f
C592 a_26891_15279# a_27923_15547# 0.02545f
C593 a_27057_15279# a_27330_15645# 0.06803f
C594 _77_.Q _45_.Y 0.05098f
C595 _77_.CLK a_27995_16367# 0.15928f
C596 a_9523_16143# VDD 0.25637f
C597 output3.A _63_.A 0.37131f
C598 _55_.A_N hold12.A 0.1493f
C599 a_23009_15279# VDD 0.2537f
C600 a_11527_15829# a_12559_15797# 0.02545f
C601 a_18611_15831# VDD 0.19427f
C602 _69_.A a_10883_15823# 0.14799f
C603 _63_.Y a_6883_16055# 0.089f
C604 _75_.CLK a_11693_15829# 0.01111f
C605 a_22751_16733# VDD 0.18801f
C606 _69_.X clock_i 0.01743f
C607 a_22843_15279# a_23197_15279# 0.04548f
C608 a_18555_16733# VDD 0.1399f
C609 _63_.Y VDD 0.21758f
C610 _55_.Y _77_.CLK 0.15866f
C611 a_7716_16885# input2.X 0.04479f
C612 output3.A a_4675_16519# 0.0846f
C613 _67_.Y _69_.A 0.04308f
C614 input1.X a_8951_16367# 0.1039f
C615 input1.X _67_.B 0.20753f
C616 a_28017_15823# VDD 0.26575f
C617 _70_.Q _45_.Y 0.20005f
C618 a_24777_15939# VDD 0.13192f
C619 _61_.X _60_.B 0.01957f
C620 _61_.X clock_i 0.07419f
C621 clkbuf_0_clock_i.X VDD 2.07287f
C622 _36_.B input2.X 0.21554f
C623 _74_.D a_6835_16367# 0.06598f
C624 a_27995_16367# a_28859_16733# 0.03079f
C625 output3.A a_6407_16395# 0.07706f
C626 _38_.X a_18045_16367# 0.09551f
C627 a_18723_16635# a_18555_16733# 0.20625f
C628 a_10547_16395# _67_.Y 0.10582f
C629 input2.X _77_.CLK 0.18549f
C630 a_17987_15279# VDD 0.27941f
C631 _36_.A a_20923_15279# 0.02978f
C632 _77_.Q VDD 1.48821f
C633 _75_.CLK a_7442_16479# 0.01667f
C634 _67_.A input2.X 0.15771f
C635 a_20994_15253# _43_.X 0.01522f
C636 _36_.B a_18225_15279# 0.04134f
C637 input2.X a_3807_16617# 0.04061f
C638 output3.A a_7699_16733# 0.05558f
C639 a_22843_16919# _45_.Y 0.04904f
C640 a_26891_15279# a_27245_15279# 0.04087f
C641 a_27057_15279# a_27755_15645# 0.10662f
C642 input1.X _63_.A 0.70691f
C643 _64_.X a_6407_16395# 0.06871f
C644 _36_.B _38_.A 0.02758f
C645 a_11527_15829# VDD 0.51384f
C646 input2.X _60_.B 0.23014f
C647 input2.X clock_i 0.18182f
C648 _77_.Q a_20868_16519# 0.16316f
C649 clkbuf_0_clock_i.X _40_.A1 0.05368f
C650 clkbuf_0_clock_i.X a_20627_16189# 0.03449f
C651 _36_.B _38_.X 0.06994f
C652 _67_.Y a_9523_16143# 0.08896f
C653 a_23282_15645# VDD 0.20466f
C654 _36_.B _75_.CLK 1.60415f
C655 _61_.X a_4535_15823# 0.07114f
C656 input2.X _57_.Y 0.36817f
C657 _77_.CLK a_26339_15279# 0.01485f
C658 a_23009_15279# a_23450_15391# 0.08347f
C659 _36_.A _50_.A2 0.05339f
C660 _44_.Y a_23352_16519# 0.11149f
C661 _36_.A _42_.A2 0.07696f
C662 _45_.Y _48_.A 0.09059f
C663 a_5191_16367# VDD 0.152f
C664 _77_.Q _40_.A1 0.06968f
C665 _36_.B _56_.Y 0.04583f
C666 output3.A VDD 1.70815f
C667 a_11693_15829# a_11881_15823# 0.06685f
C668 _69_.A _69_.X 0.01051f
C669 a_26799_16367# VDD 0.23705f
C670 _50_.B1 _51_.X 0.0182f
C671 _67_.A _75_.CLK 0.56668f
C672 _77_.CLK a_27057_15279# 0.26875f
C673 _38_.A a_17857_16367# 0.03644f
C674 _40_.Y VDD 0.1594f
C675 _70_.Q VDD 2.34745f
C676 _70_.Q _54_.A 0.08829f
C677 a_5062_16641# a_5191_16367# 0.0669f
C678 a_4771_16341# _61_.X 0.03175f
C679 output3.A a_5062_16641# 0.02483f
C680 a_17691_16367# a_18298_16479# 0.08536f
C681 _38_.X a_17857_16367# 0.24406f
C682 _67_.B a_9761_16143# 0.05471f
C683 input1.X a_9727_16367# 0.03772f
C684 a_26965_16367# a_27133_16367# 0.05175f
C685 a_28359_15823# VDD 0.14084f
C686 a_27535_16919# VDD 0.22375f
C687 _54_.A a_27535_16919# 0.04636f
C688 _75_.CLK clock_i 0.23268f
C689 _64_.X VDD 0.2647f
C690 hold12.X a_28349_16367# 0.09799f
C691 a_22843_16919# VDD 0.20057f
C692 a_23027_14735# VDD 0.33191f
C693 a_20503_15253# VDD 0.15605f
C694 a_6835_16367# a_7442_16479# 0.08536f
C695 _75_.CLK a_7867_16635# 0.05048f
C696 input2.X a_4771_16341# 0.04514f
C697 input2.X _36_.Y 0.11561f
C698 _56_.Y _57_.Y 0.11969f
C699 _40_.Y _40_.A1 0.13822f
C700 _40_.Y a_20627_16189# 0.0375f
C701 hold12.X VDD 0.24316f
C702 _43_.A _43_.X 0.03201f
C703 _77_.Q counter_value_o[4] 0.07332f
C704 _54_.Y VDD 0.38723f
C705 _48_.A VDD 0.24887f
C706 _54_.A _54_.Y 0.09046f
C707 a_28017_15823# a_28253_15823# 0.14651f
C708 a_24777_15939# _51_.X 0.08784f
C709 _36_.B a_23352_16519# 0.07998f
C710 a_26799_16367# a_26965_16367# 0.03527f
C711 a_23707_15645# VDD 0.15085f
C712 _36_.Y a_18225_15279# 0.02344f
C713 input1.X a_6883_16055# 0.05535f
C714 _60_.B _60_.X 0.02218f
C715 input2.X a_25460_15797# 0.14556f
C716 a_28161_16367# a_28434_16733# 0.07233f
C717 a_23450_15391# a_23282_15645# 0.16113f
C718 a_23009_15279# a_23875_15547# 0.01914f
C719 a_17691_16367# VDD 0.39808f
C720 input1.X VDD 5.88941f
C721 a_5609_16367# VDD 0.0552f
C722 input2.X a_10547_16395# 0.06588f
C723 a_26965_16617# VDD 0.06589f
C724 _36_.Y _38_.A 0.10441f
C725 _36_.B _50_.Y 0.13253f
C726 a_26891_15279# VDD 0.40504f
C727 a_11966_15823# a_11881_15823# 0.02068f
C728 _67_.B a_8573_16367# 0.01083f
C729 _55_.A_N a_29027_16635# 0.08035f
C730 _77_.CLK a_27330_15645# 0.04212f
C731 _40_.Y a_20540_16617# 0.03261f
C732 _36_.Y _38_.X 0.02592f
C733 a_5262_16341# a_5191_16367# 0.16113f
C734 a_5062_16641# a_5609_16367# 0.06023f
C735 _74_.D clock_i 0.01473f
C736 _77_.CLK _50_.Y 0.0487f
C737 _70_.Q a_23450_15391# 0.02584f
C738 _77_.Q a_20407_15431# 0.13413f
C739 input2.X _50_.B1 0.02391f
C740 output3.A a_5262_16341# 0.02371f
C741 _77_.CLK a_28161_16367# 0.01045f
C742 a_17691_16367# a_18723_16635# 0.02545f
C743 _38_.X a_18130_16733# 0.03064f
C744 output3.A _63_.B 0.0747f
C745 _75_.CLK _69_.A 0.04559f
C746 _63_.Y a_6925_16143# 0.02684f
C747 a_2748_16885# output3.A 0.12018f
C748 _70_.Q counter_value_o[4] 0.04344f
C749 _53_.A VDD 0.80503f
C750 a_26339_15279# _53_.X 0.20065f
C751 a_28529_16885# VDD 0.27154f
C752 a_6835_16367# clock_i 0.02624f
C753 _36_.B _44_.Y 0.1555f
C754 _77_.Q a_21341_15279# 0.01782f
C755 a_20267_16733# _40_.Y 0.02252f
C756 _70_.Q _46_.X 0.08902f
C757 a_1407_3311# VDD 0.23514f
C758 _60_.X a_4535_15823# 0.17792f
C759 _44_.Y _77_.CLK 0.13039f
C760 _53_.X a_27057_15279# 0.11424f
C761 a_7001_16367# a_7274_16733# 0.07176f
C762 _75_.CLK a_10547_16395# 0.01649f
C763 a_6835_16367# a_7867_16635# 0.02545f
C764 _36_.B _43_.A 0.02518f
C765 _54_.Y a_26965_16367# 0.04814f
C766 a_4107_16161# VDD 0.1911f
C767 _64_.X _63_.B 0.06162f
C768 a_32503_16919# counter_value_o[6] 0.14448f
C769 a_22843_16919# counter_value_o[4] 0.14123f
C770 _44_.Y a_23024_16617# 0.02839f
C771 _44_.Y a_22480_17277# 0.02718f
C772 a_11693_15829# a_11966_15823# 0.07623f
C773 _50_.B1 a_26339_15279# 0.06415f
C774 a_11527_15829# _69_.X 0.09064f
C775 a_26965_16617# a_26965_16367# 0.01235f
C776 input2.X a_22751_16733# 0.13001f
C777 _36_.A a_18298_16479# 0.01918f
C778 input2.X _63_.Y 0.07498f
C779 VDD counter_value_o[0] 0.13979f
C780 a_28253_15823# a_28359_15823# 0.27397f
C781 _36_.B a_18045_16367# 0.01014f
C782 _50_.B1 a_27057_15279# 0.03886f
C783 a_23197_15279# VDD 0.05353f
C784 a_11693_15829# clock_i 0.01776f
C785 a_28161_16367# a_28859_16733# 0.1112f
C786 _50_.B1 _56_.Y 0.15819f
C787 a_23450_15391# a_23707_15645# 0.0205f
C788 _38_.A a_18611_15831# 0.15318f
C789 hold12.A VDD 0.5221f
C790 _53_.A a_25235_15823# 0.04855f
C791 _38_.X a_18611_15831# 0.12191f
C792 a_27498_15391# VDD 0.14972f
C793 _45_.Y _50_.A2 0.02645f
C794 _38_.A a_18555_16733# 0.0188f
C795 _77_.CLK a_27755_15645# 0.06321f
C796 _77_.Q input2.X 0.10408f
C797 a_5262_16341# a_5609_16367# 0.02068f
C798 input1.X _63_.B 0.29219f
C799 a_5191_16367# _61_.X 0.0393f
C800 hold12.X a_28253_15823# 0.01537f
C801 _50_.B1 counter_value_o[6] 0.02712f
C802 a_20407_15431# a_20503_15253# 0.20625f
C803 _70_.Q a_23875_15547# 0.11083f
C804 _77_.Q a_20794_15553# 0.02672f
C805 a_17857_16367# a_18045_16367# 0.0632f
C806 output3.A _61_.X 0.30997f
C807 _38_.X a_18555_16733# 0.05779f
C808 _55_.A_N VDD 4.50035f
C809 a_12684_16885# counter_value_o[2] 0.11431f
C810 a_7442_16479# clock_i 0.01078f
C811 _75_.CLK _63_.Y 0.02068f
C812 _38_.A clkbuf_0_clock_i.X 0.07137f
C813 a_17987_15279# a_18225_15279# 0.01271f
C814 _36_.B _77_.CLK 0.04532f
C815 _36_.A VDD 2.40347f
C816 clkbuf_0_clock_i.X _38_.X 0.0766f
C817 hold12.A a_27366_16055# 0.01487f
C818 _67_.A _36_.B 0.45983f
C819 _63_.A a_8951_16367# 0.09918f
C820 _63_.A _67_.B 0.22646f
C821 a_20923_15279# VDD 0.15162f
C822 _36_.B a_23024_16617# 0.0262f
C823 _55_.A_N a_37471_16919# 0.11678f
C824 a_7001_16367# a_7699_16733# 0.10662f
C825 _75_.CLK clkbuf_0_clock_i.X 0.70482f
C826 a_27995_16367# hold12.X 0.0722f
C827 _36_.B a_22480_17277# 0.03304f
C828 _50_.A2 a_25148_15279# 0.0272f
C829 input2.X a_5191_16367# 0.03044f
C830 _50_.Y a_25460_15797# 0.03133f
C831 a_11693_15829# a_12391_15823# 0.1112f
C832 _36_.B a_17857_16367# 0.04448f
C833 output3.A input2.X 0.31628f
C834 a_22843_15279# VDD 0.50544f
C835 a_27535_16919# counter_value_o[5] 0.13884f
C836 _36_.B clock_i 0.0825f
C837 hold12.A a_26965_16367# 0.06176f
C838 input2.X a_26799_16367# 0.05841f
C839 _36_.A a_20868_16519# 0.08906f
C840 _70_.Q input2.X 0.94498f
C841 _36_.A a_18723_16635# 0.10882f
C842 _55_.A_N a_27366_16055# 0.06237f
C843 _36_.B _57_.Y 0.28914f
C844 _50_.B1 a_27330_15645# 0.03296f
C845 _67_.A clock_i 0.18592f
C846 _75_.CLK a_11527_15829# 0.1564f
C847 _50_.B1 _50_.Y 0.13703f
C848 _50_.A2 VDD 1.48259f
C849 _36_.A _40_.A1 0.26523f
C850 a_23875_15547# a_23707_15645# 0.20625f
C851 _42_.A2 VDD 0.11574f
C852 a_3807_16617# _60_.B 0.12487f
C853 a_3807_16617# clock_i 0.02459f
C854 _64_.X input2.X 0.08343f
C855 a_7001_16367# VDD 0.25475f
C856 VDD counter_value_o[1] 0.11449f
C857 output3.A a_7189_16367# 0.02183f
C858 a_22843_16919# input2.X 0.0278f
C859 a_2748_16885# counter_value_o[0] 0.11587f
C860 a_27923_15547# VDD 0.31713f
C861 _67_.Y a_9761_16143# 0.02679f
C862 a_8951_16367# a_9727_16367# 0.01015f
C863 _67_.B a_9727_16367# 0.016f
C864 input1.X a_6925_16143# 0.04774f
C865 _54_.Y _55_.Y 0.05634f
C866 a_9369_16367# clock_i 0.01107f
C867 input1.X _61_.X 0.04207f
C868 _61_.X a_5609_16367# 0.08781f
C869 a_6927_16911# VDD 0.18022f
C870 _60_.B clock_i 0.0538f
C871 a_28602_16479# VDD 0.14627f
C872 _54_.Y counter_value_o[5] 0.01993f
C873 a_20503_15253# a_20794_15553# 0.10925f
C874 _77_.Q a_20994_15253# 0.02689f
C875 a_18130_16733# a_18045_16367# 0.02068f
C876 output3.A _75_.CLK 0.1731f
C877 _42_.A2 a_20868_16519# 0.07952f
C878 a_26799_16367# a_27133_16617# 0.02042f
C879 a_7867_16635# clock_i 0.01769f
C880 a_18183_17249# VDD 0.15976f
C881 counter_value_o[7] VSS 1.48599f
C882 counter_value_o[6] VSS 1.56637f
C883 counter_value_o[5] VSS 1.97486f
C884 counter_value_o[4] VSS 1.53901f
C885 counter_value_o[3] VSS 1.54452f
C886 counter_value_o[2] VSS 1.50547f
C887 counter_value_o[1] VSS 1.4824f
C888 counter_value_o[0] VSS 1.50048f
C889 a_27881_15279# VSS 0.18f
C890 a_27456_15279# VSS 0.04259f
C891 a_27839_15645# VSS 0.11407f
C892 a_25148_15279# VSS 0.6009f
C893 a_27425_15645# VSS 0.0877f
C894 a_27245_15279# VSS 0.33514f
C895 a_27923_15547# VSS 0.24257f
C896 a_27057_15279# VSS 0.0253f
C897 _53_.X VSS 0.01277f
C898 a_23833_15279# VSS 0.13879f
C899 a_25236_15601# VSS 0.48393f
C900 a_23408_15279# VSS 0.2427f
C901 a_23791_15645# VSS 0.08845f
C902 a_23377_15645# VSS 0.07349f
C903 a_23197_15279# VSS 0.40721f
C904 a_26339_15279# VSS 0.03545f
C905 _48_.X VSS 0.01038f
C906 a_22843_15279# VSS 0.07482f
C907 a_21143_15279# VSS 0.12311f
C908 a_20722_15279# VSS 0.20561f
C909 a_18225_15279# VSS 0.3163f
C910 a_18069_15279# VSS 0.16485f
C911 a_21341_15279# VSS 0.58553f
C912 a_21170_15645# VSS 0.10194f
C913 a_18317_15529# VSS 0.14654f
C914 a_20923_15279# VSS 0.08784f
C915 a_20407_15431# VSS 0.03515f
C916 a_17987_15279# VSS 0.08663f
C917 a_25235_15823# VSS 0.42887f
C918 a_24931_15939# VSS 0.08974f
C919 a_24859_15939# VSS 0.06221f
C920 a_20716_15823# VSS 0.04433f
C921 a_27432_16143# VSS 0.8996f
C922 _53_.A VSS 0.5518f
C923 a_25320_16143# VSS 0.02303f
C924 a_28359_15823# VSS 0.14562f
C925 a_28253_15823# VSS 0.17731f
C926 _51_.X VSS 0.22556f
C927 a_20627_16189# VSS 0.48219f
C928 a_12517_16201# VSS 0.33425f
C929 a_9853_15823# VSS 0.25635f
C930 a_7033_15823# VSS 0.03643f
C931 a_12092_16201# VSS 0.21686f
C932 a_11881_15823# VSS 0.09512f
C933 a_9761_16143# VSS 0.17738f
C934 a_9605_16143# VSS 0.04838f
C935 a_7281_16143# VSS 0.0612f
C936 a_6925_16143# VSS 0.3521f
C937 a_4193_16161# VSS 0.27516f
C938 _69_.X VSS 0.72599f
C939 a_11527_15829# VSS 0.01249f
C940 a_10883_15823# VSS 0.27224f
C941 a_9523_16143# VSS 0.06417f
C942 a_6883_16055# VSS 0.03051f
C943 _60_.X VSS 0.12596f
C944 a_4107_16161# VSS 0.02515f
C945 a_28985_16367# VSS 0.1828f
C946 a_28943_16733# VSS 0.13226f
C947 a_27133_16367# VSS 0.24252f
C948 a_26965_16367# VSS 0.59258f
C949 a_28529_16733# VSS 0.20191f
C950 a_28349_16367# VSS 0.50619f
C951 _77_.CLK VSS 0.01142f
C952 hold12.A VSS 0.04645f
C953 a_27133_16617# VSS 0.38465f
C954 a_26965_16617# VSS 0.4478f
C955 a_22189_16367# VSS 0.0299f
C956 a_25309_16617# VSS 0.19736f
C957 a_25225_16617# VSS 0.07026f
C958 a_23583_16617# VSS 0.06221f
C959 a_23487_16617# VSS 0.06221f
C960 a_23024_16617# VSS 0.31927f
C961 _48_.A VSS 0.64248f
C962 a_21099_16617# VSS 0.02871f
C963 a_20540_16617# VSS 0.42344f
C964 _43_.A VSS 0.73338f
C965 a_18256_16367# VSS 0.09517f
C966 a_18639_16733# VSS 0.21196f
C967 a_10633_16395# VSS 0.53095f
C968 a_18225_16733# VSS 0.03613f
C969 a_18045_16367# VSS 0.4242f
C970 a_20868_16519# VSS 0.02871f
C971 _42_.A2 VSS 0.13962f
C972 a_17857_16367# VSS 0.02335f
C973 a_9727_16367# VSS 0.47621f
C974 a_9369_16367# VSS 0.2373f
C975 a_8951_16367# VSS 0.48912f
C976 a_8657_16367# VSS 0.05065f
C977 a_8573_16367# VSS 0.04888f
C978 a_7825_16367# VSS 0.1703f
C979 _67_.B VSS 0.0367f
C980 a_7783_16733# VSS 0.16696f
C981 a_6493_16395# VSS 0.25257f
C982 a_7369_16733# VSS 0.15504f
C983 a_7189_16367# VSS 0.21431f
C984 clkbuf_0_clock_i.X VSS 0.02956f
C985 a_7442_16479# VSS 0.04907f
C986 a_5411_16367# VSS 0.12966f
C987 a_4990_16367# VSS 0.17799f
C988 a_4057_16367# VSS 0.0573f
C989 a_6407_16395# VSS 0.09521f
C990 _75_.CLK VSS 0.0904f
C991 a_5609_16367# VSS 0.17157f
C992 a_5438_16733# VSS 0.23462f
C993 a_5013_16733# VSS 0.01626f
C994 a_4057_16617# VSS 0.10233f
C995 a_3889_16617# VSS 0.07007f
C996 _61_.X VSS 1.04965f
C997 a_22568_16911# VSS 0.0502f
C998 a_27253_17231# VSS 0.25922f
C999 _45_.Y VSS 0.03626f
C1000 a_22480_17277# VSS 0.51856f
C1001 a_18269_17249# VSS 0.238f
C1002 _74_.D VSS 0.46357f
C1003 _63_.B VSS 0.03661f
C1004 a_6737_17231# VSS 0.05348f
C1005 a_32503_16919# VSS 0.04163f
C1006 _50_.B1 VSS 2.42426f
C1007 a_28787_16885# VSS 0.04706f
C1008 _54_.A VSS 0.09725f
C1009 input2.X VSS 7.06097f
C1010 _36_.B VSS 3.00348f
C1011 a_18183_17249# VSS 0.06307f
C1012 _36_.A VSS 2.74611f
C1013 _67_.A VSS 1.87433f
C1014 _63_.A VSS 1.64873f
C1015 a_7716_16885# VSS 0.02112f
C1016 a_6927_16911# VSS 0.05274f
C1017 _64_.X VSS 0.40577f
C1018 input1.X VSS 7.02743f
C1019 output3.A VSS 2.76707f
C1020 output3.A.n0 VSS 0.06585f
C1021 output3.A.n1 VSS 0.06213f
C1022 output3.A.n2 VSS 0.02605f
C1023 output3.A.n3 VSS 0.06585f
C1024 output3.A.n4 VSS 0.02605f
C1025 output3.A.n5 VSS 0.02068f
C1026 output3.A.n6 VSS 0.02114f
C1027 output3.A.n7 VSS 0.0214f
C1028 output3.A.n8 VSS 0.10056f
C1029 output3.A.n9 VSS 0.01746f
C1030 output3.A.n10 VSS 0.03248f
C1031 output3.A.n11 VSS 0.09732f
C1032 output3.A.n12 VSS 0.53946f
C1033 output3.A.n13 VSS 0.10113f
C1034 output3.A.n14 VSS 0.13598f
C1035 output3.A.n15 VSS 1.06001f
C1036 output3.A.n16 VSS 0.19302f
C1037 output3.A.n17 VSS 0.10247f
C1038 output3.A.n18 VSS 0.27915f
C1039 output3.A.n19 VSS 0.09891f
C1040 output3.A.n20 VSS 0.07335f
C1041 output3.A.n21 VSS 0.01767f
C1042 output3.A.n22 VSS 0.09828f
C1043 output3.A.n23 VSS 0.63452f
C1044 output3.A.t1 VSS 0.17598f
C1045 output3.A.n24 VSS 0.18417f
C1046 output3.A.n25 VSS 0.07507f
C1047 output3.A.t0 VSS 0.0711f
C1048 input1.X.t3 VSS 0.03279f
C1049 input1.X.n0 VSS 0.07235f
C1050 input1.X.n1 VSS 0.06514f
C1051 input1.X.n2 VSS 0.03366f
C1052 input1.X.n3 VSS 0.04725f
C1053 input1.X.n4 VSS 0.10343f
C1054 input1.X.n5 VSS 0.18017f
C1055 input1.X.n6 VSS 0.09574f
C1056 input1.X.n7 VSS 0.04176f
C1057 input1.X.n8 VSS 0.06962f
C1058 input1.X.n9 VSS 0.06568f
C1059 input1.X.n10 VSS 0.02916f
C1060 input1.X.n11 VSS 0.06962f
C1061 input1.X.n12 VSS 0.02754f
C1062 input1.X.n13 VSS 0.02234f
C1063 input1.X.n14 VSS 0.02234f
C1064 input1.X.n15 VSS 0.02754f
C1065 input1.X.n16 VSS 0.10074f
C1066 input1.X.n17 VSS 0.02765f
C1067 input1.X.n18 VSS 0.16363f
C1068 input1.X.n19 VSS 0.71657f
C1069 input1.X.n20 VSS 1.45666f
C1070 input1.X.n21 VSS 3.52084f
C1071 input1.X.n22 VSS 2.23361f
C1072 input1.X.t2 VSS 0.15644f
C1073 input1.X.n23 VSS 0.0656f
C1074 input1.X.n24 VSS 0.02106f
C1075 input1.X.t1 VSS 0.02131f
C1076 input1.X.t0 VSS 0.24925f
C1077 input1.X.n25 VSS 0.04262f
C1078 input1.X.n26 VSS 0.07089f
C1079 _64_.X.t0 VSS 0.16903f
C1080 _64_.X.n0 VSS 0.03989f
C1081 _64_.X.t1 VSS 0.04988f
C1082 _64_.X.n1 VSS 0.08989f
C1083 _64_.X.n2 VSS 0.2073f
C1084 _64_.X.n3 VSS 0.20085f
C1085 _64_.X.n4 VSS 0.15198f
C1086 _64_.X.n5 VSS 0.0205f
C1087 _64_.X.n6 VSS 0.02789f
C1088 _63_.A.n0 VSS 0.06073f
C1089 _63_.A.n1 VSS 0.0573f
C1090 _63_.A.n2 VSS 0.02402f
C1091 _63_.A.n3 VSS 0.01949f
C1092 _63_.A.n4 VSS 0.01949f
C1093 _63_.A.n5 VSS 0.02402f
C1094 _63_.A.n6 VSS 0.06101f
C1095 _63_.A.n7 VSS 0.05701f
C1096 _63_.A.n8 VSS 0.02402f
C1097 _63_.A.n9 VSS 0.0161f
C1098 _63_.A.n10 VSS 0.04702f
C1099 _63_.A.n11 VSS 0.06517f
C1100 _63_.A.n12 VSS 0.31178f
C1101 _63_.A.n13 VSS 0.0945f
C1102 _63_.A.n14 VSS 0.11905f
C1103 _63_.A.n15 VSS 0.05682f
C1104 _63_.A.n16 VSS 0.02973f
C1105 _63_.A.n17 VSS 0.03759f
C1106 _63_.A.n18 VSS 0.07991f
C1107 _63_.A.n19 VSS 0.16915f
C1108 _63_.A.n20 VSS 0.63406f
C1109 _63_.A.n21 VSS 0.10081f
C1110 _63_.A.n22 VSS 0.02167f
C1111 _63_.A.t1 VSS 0.20131f
C1112 _63_.A.n23 VSS 0.18189f
C1113 _63_.A.t0 VSS 0.05597f
C1114 _67_.A.n0 VSS 0.09499f
C1115 _67_.A.n1 VSS 0.07113f
C1116 _67_.A.n2 VSS 0.08144f
C1117 _67_.A.n3 VSS 0.03779f
C1118 _67_.A.n4 VSS 0.05711f
C1119 _67_.A.n5 VSS 0.02952f
C1120 _67_.A.n7 VSS 0.21309f
C1121 _67_.A.n8 VSS 0.09802f
C1122 _67_.A.n9 VSS 0.06967f
C1123 _67_.A.n10 VSS 0.06794f
C1124 _67_.A.n11 VSS 0.01959f
C1125 _67_.A.n12 VSS 0.02415f
C1126 _67_.A.n13 VSS 0.06104f
C1127 _67_.A.n14 VSS 0.01984f
C1128 _67_.A.n15 VSS 0.01917f
C1129 _67_.A.n16 VSS 0.81311f
C1130 _67_.A.n17 VSS 0.67468f
C1131 _67_.A.n18 VSS 0.06286f
C1132 _67_.A.t1 VSS 0.28754f
C1133 _67_.A.t0 VSS 0.05664f
C1134 _67_.A.n19 VSS 0.17686f
C1135 _36_.A.t1 VSS 0.1255f
C1136 _36_.A.n0 VSS 0.11229f
C1137 _36_.A.n1 VSS 0.03332f
C1138 _36_.A.n2 VSS 1.04269f
C1139 _36_.A.n3 VSS 1.26108f
C1140 _36_.A.n5 VSS 0.0495f
C1141 _36_.A.n6 VSS 0.53592f
C1142 _36_.A.n7 VSS 1.01154f
C1143 _36_.A.n8 VSS 0.2714f
C1144 _36_.A.t0 VSS 0.40405f
C1145 _36_.B.n0 VSS 0.16082f
C1146 _36_.B.n1 VSS 0.10509f
C1147 _36_.B.n2 VSS 0.02531f
C1148 _36_.B.n3 VSS 0.22772f
C1149 _36_.B.n4 VSS 0.12372f
C1150 _36_.B.n5 VSS 0.19613f
C1151 _36_.B.n6 VSS 0.2092f
C1152 _36_.B.n7 VSS 0.19121f
C1153 _36_.B.n8 VSS 0.15796f
C1154 _36_.B.n9 VSS 0.64284f
C1155 _36_.B.n10 VSS 0.1059f
C1156 _36_.B.n11 VSS 0.62842f
C1157 _36_.B.n12 VSS 0.09781f
C1158 _36_.B.n13 VSS 1.06794f
C1159 _36_.B.n14 VSS 0.77052f
C1160 _36_.B.n15 VSS 0.12797f
C1161 _36_.B.n16 VSS 0.04007f
C1162 _36_.B.n17 VSS 0.66239f
C1163 _36_.B.n18 VSS 1.3008f
C1164 _36_.B.n19 VSS 3.15887f
C1165 _36_.B.t1 VSS 0.07663f
C1166 _36_.B.t2 VSS 0.07558f
C1167 _36_.B.n20 VSS 0.09219f
C1168 _36_.B.n21 VSS 1.94241f
C1169 _36_.B.t3 VSS 0.48996f
C1170 _36_.B.t0 VSS 3.3615f
C1171 input2.X.t3 VSS 0.04531f
C1172 input2.X.n0 VSS 0.11598f
C1173 input2.X.n1 VSS 0.12575f
C1174 input2.X.n3 VSS 0.05922f
C1175 input2.X.n4 VSS 0.12609f
C1176 input2.X.n5 VSS 0.1154f
C1177 input2.X.n6 VSS 0.02624f
C1178 input2.X.n7 VSS 0.09903f
C1179 input2.X.n8 VSS 0.14773f
C1180 input2.X.n9 VSS 0.08126f
C1181 input2.X.n10 VSS 0.11705f
C1182 input2.X.n11 VSS 0.13784f
C1183 input2.X.n12 VSS 1.13955f
C1184 input2.X.n13 VSS 1.51401f
C1185 input2.X.n14 VSS 0.11598f
C1186 input2.X.n15 VSS 0.12575f
C1187 input2.X.n17 VSS 0.20525f
C1188 input2.X.n18 VSS 2.02795f
C1189 input2.X.n19 VSS 1.11304f
C1190 input2.X.n20 VSS 0.14438f
C1191 input2.X.n21 VSS 0.03618f
C1192 input2.X.n22 VSS 2.50366f
C1193 input2.X.n23 VSS 0.14438f
C1194 input2.X.n24 VSS 0.04645f
C1195 input2.X.n25 VSS 3.55254f
C1196 input2.X.n26 VSS 0.14438f
C1197 input2.X.n27 VSS 0.03353f
C1198 input2.X.n28 VSS 0.06683f
C1199 input2.X.n29 VSS 1.74788f
C1200 input2.X.n30 VSS 0.14438f
C1201 input2.X.n31 VSS 0.03618f
C1202 input2.X.n32 VSS 3.12619f
C1203 input2.X.n33 VSS 1.63728f
C1204 input2.X.t2 VSS 0.04531f
C1205 input2.X.n34 VSS 0.09065f
C1206 input2.X.n35 VSS 0.0291f
C1207 input2.X.t1 VSS 0.1531f
C1208 input2.X.t0 VSS 0.25739f
C1209 input2.X.n36 VSS 0.0589f
C1210 input2.X.n37 VSS 0.09796f
C1211 _50_.B1.t1 VSS 0.14699f
C1212 _50_.B1.n0 VSS 0.95239f
C1213 _50_.B1.n1 VSS 0.12993f
C1214 _50_.B1.n2 VSS 0.22368f
C1215 _50_.B1.n3 VSS 0.05953f
C1216 _50_.B1.n4 VSS 0.03439f
C1217 _50_.B1.n5 VSS 0.86228f
C1218 _50_.B1.n6 VSS 1.001f
C1219 _50_.B1.n7 VSS 2.47129f
C1220 _50_.B1.n8 VSS 0.18504f
C1221 _50_.B1.t0 VSS 0.31927f
C1222 _74_.D.n0 VSS 0.12258f
C1223 _74_.D.n1 VSS 0.19877f
C1224 _74_.D.n2 VSS 0.1554f
C1225 _74_.D.t0 VSS 0.05665f
C1226 _74_.D.n3 VSS 0.08001f
C1227 _74_.D.t1 VSS 0.16355f
C1228 a_5055_16341.t0 VSS 0.0812f
C1229 a_5055_16341.n0 VSS 0.10529f
C1230 a_5055_16341.n1 VSS 0.16882f
C1231 a_5055_16341.n2 VSS 0.1367f
C1232 a_5055_16341.n3 VSS 0.2482f
C1233 a_5055_16341.n4 VSS 0.39996f
C1234 a_5055_16341.n5 VSS 0.08279f
C1235 a_5055_16341.n6 VSS 0.08033f
C1236 a_5055_16341.t1 VSS 0.99515f
C1237 _61_.X.n0 VSS 0.14181f
C1238 _61_.X.t0 VSS 0.06404f
C1239 _61_.X.n1 VSS 0.42457f
C1240 _61_.X.n2 VSS 0.09148f
C1241 _61_.X.t1 VSS 0.22509f
C1242 a_11413_16341.n0 VSS 0.06063f
C1243 a_11413_16341.t2 VSS 0.02304f
C1244 a_11413_16341.n1 VSS 0.02168f
C1245 a_11413_16341.t5 VSS 0.01967f
C1246 a_11413_16341.t4 VSS 0.03445f
C1247 a_11413_16341.n2 VSS 0.04549f
C1248 a_11413_16341.t1 VSS 0.06038f
C1249 a_11413_16341.t0 VSS 0.03432f
C1250 a_11413_16341.n3 VSS 0.02168f
C1251 a_11413_16341.n4 VSS 0.02388f
C1252 a_11413_16341.n5 VSS 0.04352f
C1253 a_11413_16341.n6 VSS 0.02107f
C1254 a_11413_16341.n7 VSS 0.02388f
C1255 a_11413_16341.n8 VSS 0.04246f
C1256 a_11413_16341.n9 VSS 0.04246f
C1257 a_11413_16341.n10 VSS 0.02388f
C1258 a_11413_16341.n11 VSS 0.04245f
C1259 a_11413_16341.n12 VSS 0.02388f
C1260 a_11413_16341.n13 VSS 0.04626f
C1261 a_11413_16341.n14 VSS 0.05511f
C1262 a_11413_16341.n15 VSS 0.06986f
C1263 a_11413_16341.n16 VSS 0.06169f
C1264 a_11413_16341.n17 VSS 0.02521f
C1265 a_11413_16341.n18 VSS 0.04245f
C1266 a_11413_16341.n19 VSS 0.02265f
C1267 a_11413_16341.n20 VSS 0.04245f
C1268 a_11413_16341.n21 VSS 0.02265f
C1269 a_11413_16341.n22 VSS 0.02388f
C1270 a_11413_16341.n23 VSS 0.02388f
C1271 a_11413_16341.n24 VSS 0.02239f
C1272 a_11413_16341.n25 VSS 0.04245f
C1273 a_11413_16341.n26 VSS 0.02265f
C1274 a_11413_16341.n27 VSS 0.02388f
C1275 a_11413_16341.n28 VSS 0.02388f
C1276 a_11413_16341.n29 VSS 0.02239f
C1277 a_11413_16341.n30 VSS 0.04246f
C1278 a_11413_16341.n31 VSS 0.02213f
C1279 a_11413_16341.n32 VSS 0.01844f
C1280 a_11413_16341.n33 VSS 0.02388f
C1281 a_11413_16341.n34 VSS 0.02388f
C1282 a_11413_16341.n35 VSS 0.02265f
C1283 a_11413_16341.n36 VSS 0.04246f
C1284 a_11413_16341.n37 VSS 0.02265f
C1285 a_11413_16341.n38 VSS 0.04246f
C1286 a_11413_16341.n39 VSS 0.02265f
C1287 a_11413_16341.n40 VSS 0.02388f
C1288 a_11413_16341.n41 VSS 0.02388f
C1289 a_11413_16341.n42 VSS 0.02388f
C1290 a_11413_16341.n43 VSS 0.01949f
C1291 a_11413_16341.n44 VSS 0.04246f
C1292 a_11413_16341.n45 VSS 0.02265f
C1293 a_11413_16341.n46 VSS 0.04246f
C1294 a_11413_16341.n47 VSS 0.02265f
C1295 a_11413_16341.n48 VSS 0.04179f
C1296 a_11413_16341.n49 VSS 0.18536f
C1297 a_11413_16341.n50 VSS 0.16288f
C1298 a_11413_16341.t6 VSS 0.09487f
C1299 a_11413_16341.t7 VSS 0.02881f
C1300 _43_.A.t2 VSS 0.16341f
C1301 _43_.A.n0 VSS 0.01511f
C1302 _43_.A.n1 VSS 0.07466f
C1303 _43_.A.n2 VSS 0.02138f
C1304 _43_.A.n3 VSS 0.07285f
C1305 _43_.A.n4 VSS 0.29146f
C1306 _43_.A.n5 VSS 0.29359f
C1307 _43_.A.t0 VSS 0.02724f
C1308 _43_.A.t1 VSS 0.02724f
C1309 _43_.A.n6 VSS 0.05449f
C1310 _43_.A.n7 VSS 0.06087f
C1311 _43_.A.n8 VSS 0.06194f
C1312 _48_.A.t1 VSS 0.07f
C1313 _48_.A.n0 VSS 0.01509f
C1314 _48_.A.n1 VSS 0.07457f
C1315 _48_.A.n2 VSS 0.02135f
C1316 _48_.A.n3 VSS 0.07275f
C1317 _48_.A.n4 VSS 0.27008f
C1318 _48_.A.n5 VSS 0.25603f
C1319 _48_.A.t0 VSS 0.02721f
C1320 _48_.A.t2 VSS 0.12302f
C1321 _48_.A.n6 VSS 0.05442f
C1322 _48_.A.n7 VSS 0.06079f
C1323 _48_.A.n8 VSS 0.06186f
C1324 _69_.X.n0 VSS 0.09251f
C1325 _69_.X.t0 VSS 0.04271f
C1326 _69_.X.n1 VSS 0.21084f
C1327 _69_.X.n2 VSS 0.06101f
C1328 _69_.X.t1 VSS 0.15513f
C1329 a_16762_15823.n0 VSS 0.05478f
C1330 a_16762_15823.n1 VSS 0.02158f
C1331 a_16762_15823.n2 VSS 0.01904f
C1332 a_16762_15823.n3 VSS 0.02158f
C1333 a_16762_15823.n4 VSS 0.03837f
C1334 a_16762_15823.n5 VSS 0.02158f
C1335 a_16762_15823.n6 VSS 0.03836f
C1336 a_16762_15823.n7 VSS 0.02158f
C1337 a_16762_15823.n8 VSS 0.0418f
C1338 a_16762_15823.n9 VSS 0.04979f
C1339 a_16762_15823.n10 VSS 0.06312f
C1340 a_16762_15823.n11 VSS 0.05574f
C1341 a_16762_15823.n12 VSS 0.02278f
C1342 a_16762_15823.n13 VSS 0.03836f
C1343 a_16762_15823.n14 VSS 0.02046f
C1344 a_16762_15823.n15 VSS 0.03836f
C1345 a_16762_15823.n16 VSS 0.02046f
C1346 a_16762_15823.n17 VSS 0.02158f
C1347 a_16762_15823.n18 VSS 0.02158f
C1348 a_16762_15823.n19 VSS 0.02023f
C1349 a_16762_15823.n20 VSS 0.03836f
C1350 a_16762_15823.n21 VSS 0.02046f
C1351 a_16762_15823.n22 VSS 0.02158f
C1352 a_16762_15823.n23 VSS 0.02158f
C1353 a_16762_15823.n24 VSS 0.02023f
C1354 a_16762_15823.n25 VSS 0.03837f
C1355 a_16762_15823.n26 VSS 0.01999f
C1356 a_16762_15823.n27 VSS 0.01666f
C1357 a_16762_15823.n28 VSS 0.02158f
C1358 a_16762_15823.n29 VSS 0.02158f
C1359 a_16762_15823.n30 VSS 0.02047f
C1360 a_16762_15823.n31 VSS 0.03837f
C1361 a_16762_15823.n32 VSS 0.02047f
C1362 a_16762_15823.n33 VSS 0.03837f
C1363 a_16762_15823.n34 VSS 0.03837f
C1364 a_16762_15823.n35 VSS 0.02047f
C1365 a_16762_15823.n36 VSS 0.02158f
C1366 a_16762_15823.n37 VSS 0.02158f
C1367 a_16762_15823.n38 VSS 0.02158f
C1368 a_16762_15823.n39 VSS 0.01761f
C1369 a_16762_15823.n40 VSS 0.03837f
C1370 a_16762_15823.n41 VSS 0.02047f
C1371 a_16762_15823.n42 VSS 0.03837f
C1372 a_16762_15823.n43 VSS 0.03932f
C1373 a_16762_15823.n44 VSS 0.02047f
C1374 a_16762_15823.n45 VSS 0.03776f
C1375 a_16762_15823.t3 VSS 0.01777f
C1376 a_16762_15823.t2 VSS 0.01777f
C1377 a_16762_15823.n46 VSS 0.04129f
C1378 a_16762_15823.t0 VSS 0.18164f
C1379 a_16762_15823.t1 VSS 4.04034f
C1380 a_16762_15823.t4 VSS 0.05888f
C1381 a_16762_15823.t5 VSS 0.01777f
C1382 a_21914_15823.n0 VSS 0.05546f
C1383 a_21914_15823.n1 VSS 0.02185f
C1384 a_21914_15823.n2 VSS 0.01928f
C1385 a_21914_15823.n3 VSS 0.02185f
C1386 a_21914_15823.n4 VSS 0.03884f
C1387 a_21914_15823.n5 VSS 0.02185f
C1388 a_21914_15823.n6 VSS 0.03884f
C1389 a_21914_15823.n7 VSS 0.02185f
C1390 a_21914_15823.n8 VSS 0.04231f
C1391 a_21914_15823.n9 VSS 0.05041f
C1392 a_21914_15823.n10 VSS 0.0639f
C1393 a_21914_15823.n11 VSS 0.05643f
C1394 a_21914_15823.n12 VSS 0.02306f
C1395 a_21914_15823.n13 VSS 0.03884f
C1396 a_21914_15823.n14 VSS 0.02072f
C1397 a_21914_15823.n15 VSS 0.03884f
C1398 a_21914_15823.n16 VSS 0.02072f
C1399 a_21914_15823.n17 VSS 0.02185f
C1400 a_21914_15823.n18 VSS 0.02185f
C1401 a_21914_15823.n19 VSS 0.02048f
C1402 a_21914_15823.n20 VSS 0.03884f
C1403 a_21914_15823.n21 VSS 0.02072f
C1404 a_21914_15823.n22 VSS 0.02185f
C1405 a_21914_15823.n23 VSS 0.02185f
C1406 a_21914_15823.n24 VSS 0.02048f
C1407 a_21914_15823.n25 VSS 0.03884f
C1408 a_21914_15823.n26 VSS 0.02024f
C1409 a_21914_15823.n27 VSS 0.01687f
C1410 a_21914_15823.n28 VSS 0.02185f
C1411 a_21914_15823.n29 VSS 0.02185f
C1412 a_21914_15823.n30 VSS 0.02072f
C1413 a_21914_15823.n31 VSS 0.03884f
C1414 a_21914_15823.n32 VSS 0.02072f
C1415 a_21914_15823.n33 VSS 0.03884f
C1416 a_21914_15823.n34 VSS 0.03884f
C1417 a_21914_15823.n35 VSS 0.02072f
C1418 a_21914_15823.n36 VSS 0.02185f
C1419 a_21914_15823.n37 VSS 0.02185f
C1420 a_21914_15823.n38 VSS 0.02185f
C1421 a_21914_15823.n39 VSS 0.01783f
C1422 a_21914_15823.n40 VSS 0.03884f
C1423 a_21914_15823.n41 VSS 0.02072f
C1424 a_21914_15823.n42 VSS 0.03884f
C1425 a_21914_15823.n43 VSS 0.03981f
C1426 a_21914_15823.n44 VSS 0.02072f
C1427 a_21914_15823.n45 VSS 0.03823f
C1428 a_21914_15823.n46 VSS 0.01984f
C1429 a_21914_15823.t4 VSS 0.04541f
C1430 a_21914_15823.t3 VSS 2.59936f
C1431 a_21914_15823.n47 VSS 0.04181f
C1432 a_21914_15823.n48 VSS 0.14895f
C1433 a_21914_15823.t2 VSS 0.23193f
C1434 a_21914_15823.t5 VSS 0.05961f
C1435 a_21914_15823.t6 VSS 0.02363f
C1436 _51_.X.n0 VSS 0.06812f
C1437 _51_.X.n1 VSS 0.06782f
C1438 _51_.X.n2 VSS 0.04735f
C1439 _51_.X.t0 VSS 0.13378f
C1440 _51_.X.n3 VSS 0.09955f
C1441 _51_.X.t1 VSS 0.19915f
C1442 _53_.A.t1 VSS 0.17793f
C1443 _53_.A.t0 VSS 0.03349f
C1444 _53_.A.n0 VSS 0.06697f
C1445 _53_.A.n1 VSS 0.09123f
C1446 _53_.A.t2 VSS 0.03278f
C1447 _53_.A.n2 VSS 0.08954f
C1448 _53_.A.n3 VSS 0.27352f
C1449 _53_.A.n4 VSS 0.33382f
C1450 _53_.A.n5 VSS 0.09135f
C1451 a_20787_15253.t0 VSS 0.06739f
C1452 a_20787_15253.n0 VSS 0.10326f
C1453 a_20787_15253.n1 VSS 0.16556f
C1454 a_20787_15253.n2 VSS 0.13407f
C1455 a_20787_15253.n3 VSS 0.24342f
C1456 a_20787_15253.n4 VSS 0.39226f
C1457 a_20787_15253.n5 VSS 0.08119f
C1458 a_20787_15253.n6 VSS 0.07878f
C1459 a_20787_15253.t1 VSS 1.7084f
C1460 VSS.t3401 VSS 0.12365f
C1461 VSS.t109 VSS 0.16909f
C1462 VSS.t2830 VSS 0.08348f
C1463 VSS.t1755 VSS 0.01011f
C1464 VSS.t1567 VSS 0.01851f
C1465 VSS.t1137 VSS 0.15314f
C1466 VSS.t922 VSS 0.03675f
C1467 VSS.t521 VSS 0.01829f
C1468 VSS.t522 VSS 0.01829f
C1469 VSS.t3124 VSS 0.02097f
C1470 VSS.t243 VSS 0.17886f
C1471 VSS.t3415 VSS 0.12951f
C1472 VSS.t10 VSS 0.13316f
C1473 VSS.t3269 VSS 0.04296f
C1474 VSS.t154 VSS 0.02497f
C1475 VSS.t416 VSS 0.01557f
C1476 VSS.t419 VSS 0.08145f
C1477 VSS.t82 VSS 0.02256f
C1478 VSS.t3257 VSS 0.02256f
C1479 VSS.t424 VSS 0.01813f
C1480 VSS.t44 VSS 0.04536f
C1481 VSS.t138 VSS 0.02884f
C1482 VSS.t214 VSS 0.02284f
C1483 VSS.t209 VSS 0.01142f
C1484 VSS.t159 VSS 0.01797f
C1485 VSS.t3294 VSS 0.03379f
C1486 VSS.t89 VSS 1.59635f
C1487 VSS.t3336 VSS 0.51864f
C1488 VSS.t366 VSS 0.04807f
C1489 VSS.t3242 VSS 0.08389f
C1490 VSS.t359 VSS 0.03626f
C1491 VSS.t94 VSS 0.17505f
C1492 VSS.t329 VSS 0.01749f
C1493 VSS.t299 VSS 0.01549f
C1494 VSS.t65 VSS 0.02496f
C1495 VSS.t3369 VSS 0.02218f
C1496 VSS.t204 VSS 0.02112f
C1497 VSS.t300 VSS 0.01549f
C1498 VSS.t309 VSS 0.01245f
C1499 VSS.t308 VSS 0.01245f
C1500 VSS.t26 VSS 0.01428f
C1501 VSS.t28 VSS 0.14013f
C1502 VSS.t320 VSS 0.06007f
C1503 VSS.t321 VSS 0.06007f
C1504 VSS.t330 VSS 0.01749f
C1505 VSS.t92 VSS 0.11571f
C1506 VSS.t3284 VSS 0.29812f
C1507 VSS.t63 VSS 0.42291f
C1508 VSS.t41 VSS 0.03646f
C1509 VSS.t3373 VSS 1.03981f
C1510 VSS.t360 VSS 0.03626f
C1511 VSS.t365 VSS 0.04807f
C1512 VSS.t375 VSS 0.02432f
C1513 VSS.t96 VSS 0.2261f
C1514 VSS.t374 VSS 0.02432f
C1515 VSS.t925 VSS 0.01897f
C1516 VSS.t790 VSS 0.01428f
C1517 VSS.t874 VSS 0.14562f
C1518 VSS.t763 VSS 0.01377f
C1519 VSS.t859 VSS 0.87518f
C1520 VSS.t740 VSS 0.03219f
C1521 VSS.t856 VSS 0.01011f
C1522 VSS.t1187 VSS 0.09716f
C1523 VSS.t1241 VSS 0.06739f
C1524 VSS.t1269 VSS 0.01806f
C1525 VSS.t1683 VSS 0.05904f
C1526 VSS.t1671 VSS 0.04813f
C1527 VSS.t1668 VSS 0.01371f
C1528 VSS.t1758 VSS 0.01011f
C1529 VSS.t1626 VSS 0.10898f
C1530 VSS.t3399 VSS 0.68381f
C1531 VSS.t2152 VSS 0.02884f
C1532 VSS.t2047 VSS 0.05317f
C1533 VSS.t2153 VSS 0.02884f
C1534 VSS.t2048 VSS 0.05317f
C1535 VSS.t2132 VSS 0.17731f
C1536 VSS.t3219 VSS 0.01745f
C1537 VSS.t3220 VSS 0.01745f
C1538 VSS.t3214 VSS 0.0251f
C1539 VSS.t3202 VSS 0.44186f
C1540 VSS.t3151 VSS 0.06593f
C1541 VSS.t3130 VSS 0.01557f
C1542 VSS.t3123 VSS 0.02097f
C1543 VSS.t3127 VSS 0.04444f
C1544 VSS.t3126 VSS 0.04444f
C1545 VSS.t3129 VSS 0.01557f
C1546 VSS.t3150 VSS 0.06593f
C1547 VSS.t3172 VSS 0.01835f
C1548 VSS.t3171 VSS 0.01835f
C1549 VSS.t3201 VSS 0.44186f
C1550 VSS.t3213 VSS 0.0251f
C1551 VSS.t2992 VSS 0.03139f
C1552 VSS.t3103 VSS 0.01011f
C1553 VSS.t2989 VSS 0.11546f
C1554 VSS.t2988 VSS 0.11546f
C1555 VSS.t2964 VSS 0.04129f
C1556 VSS.t2958 VSS 0.01011f
C1557 VSS.t2943 VSS 0.0168f
C1558 VSS.t3040 VSS 0.01168f
C1559 VSS.t3039 VSS 0.01168f
C1560 VSS.t2928 VSS 0.01011f
C1561 VSS.t3030 VSS 0.0618f
C1562 VSS.t2919 VSS 0.04008f
C1563 VSS.t3010 VSS 0.0621f
C1564 VSS.t3356 VSS 0.22793f
C1565 VSS.t3009 VSS 0.0621f
C1566 VSS.t2902 VSS 0.05063f
C1567 VSS.t3012 VSS 0.07281f
C1568 VSS.t3013 VSS 0.07281f
C1569 VSS.t2920 VSS 0.04008f
C1570 VSS.t3031 VSS 0.0618f
C1571 VSS.t2929 VSS 0.01011f
C1572 VSS.t2940 VSS 0.01011f
C1573 VSS.t2941 VSS 0.01011f
C1574 VSS.t2944 VSS 0.0168f
C1575 VSS.t2959 VSS 0.01011f
C1576 VSS.t2965 VSS 0.04129f
C1577 VSS.t2991 VSS 0.03139f
C1578 VSS.t3106 VSS 0.01011f
C1579 VSS.t3105 VSS 0.01011f
C1580 VSS.t3102 VSS 0.01011f
C1581 VSS.t2652 VSS 0.02623f
C1582 VSS.t2651 VSS 0.02623f
C1583 VSS.t2622 VSS 0.02864f
C1584 VSS.t2621 VSS 0.02864f
C1585 VSS.t2607 VSS 0.02506f
C1586 VSS.t2606 VSS 0.02506f
C1587 VSS.t2603 VSS 0.35089f
C1588 VSS.t2469 VSS 0.01549f
C1589 VSS.t2468 VSS 0.01549f
C1590 VSS.t2704 VSS 0.0251f
C1591 VSS.t2708 VSS 0.07349f
C1592 VSS.t2764 VSS 0.01011f
C1593 VSS.t2869 VSS 0.08731f
C1594 VSS.t2870 VSS 0.08731f
C1595 VSS.t2768 VSS 0.01821f
C1596 VSS.t2779 VSS 0.09301f
C1597 VSS.t2784 VSS 0.01755f
C1598 VSS.t2785 VSS 0.01755f
C1599 VSS.t2780 VSS 0.09301f
C1600 VSS.t2882 VSS 0.08456f
C1601 VSS.t2881 VSS 0.08456f
C1602 VSS.t2767 VSS 0.01821f
C1603 VSS.t2765 VSS 0.01011f
C1604 VSS.t2864 VSS 0.02527f
C1605 VSS.t2863 VSS 0.02527f
C1606 VSS.t2744 VSS 0.13442f
C1607 VSS.t2743 VSS 0.13442f
C1608 VSS.t2834 VSS 0.02068f
C1609 VSS.t2833 VSS 0.02068f
C1610 VSS.t2831 VSS 0.08348f
C1611 VSS.t2707 VSS 0.07349f
C1612 VSS.t2705 VSS 0.0251f
C1613 VSS.t2683 VSS 0.02125f
C1614 VSS.t2684 VSS 0.02125f
C1615 VSS.t2477 VSS 0.02532f
C1616 VSS.t2478 VSS 0.02532f
C1617 VSS.t2492 VSS 0.02285f
C1618 VSS.t2493 VSS 0.02285f
C1619 VSS.t2604 VSS 0.35089f
C1620 VSS.t2624 VSS 1.44397p
C1621 VSS.t2625 VSS 1.44397p
C1622 VSS.t2639 VSS 0.02341f
C1623 VSS.t2640 VSS 0.02341f
C1624 VSS.t2540 VSS 0.01772f
C1625 VSS.t2541 VSS 0.01772f
C1626 VSS.t2552 VSS 0.10947f
C1627 VSS.t2553 VSS 0.10947f
C1628 VSS.t2555 VSS 0.03428f
C1629 VSS.t2556 VSS 0.03428f
C1630 VSS.t2666 VSS 0.01549f
C1631 VSS.t2667 VSS 0.01549f
C1632 VSS.t2565 VSS 0.25609f
C1633 VSS.t2564 VSS 0.25609f
C1634 VSS.t2422 VSS 0.06232f
C1635 VSS.t2421 VSS 0.06232f
C1636 VSS.t2418 VSS 0.0654f
C1637 VSS.t2407 VSS 0.02068f
C1638 VSS.t2406 VSS 0.02068f
C1639 VSS.t2260 VSS 0.09615f
C1640 VSS.t2262 VSS 0.05584f
C1641 VSS.t2263 VSS 0.05584f
C1642 VSS.t2265 VSS 0.20025f
C1643 VSS.t2266 VSS 0.20025f
C1644 VSS.t2379 VSS 0.07752f
C1645 VSS.t2380 VSS 0.07752f
C1646 VSS.t2310 VSS 0.0327f
C1647 VSS.t2311 VSS 0.0327f
C1648 VSS.t2419 VSS 0.0654f
C1649 VSS.t2337 VSS 0.0154f
C1650 VSS.t2338 VSS 0.0154f
C1651 VSS.t2458 VSS 0.07354f
C1652 VSS.t2457 VSS 0.07354f
C1653 VSS.t2134 VSS 0.03681f
C1654 VSS.t2139 VSS 0.08836f
C1655 VSS.t2140 VSS 0.08836f
C1656 VSS.t2135 VSS 0.03681f
C1657 VSS.t2131 VSS 0.17731f
C1658 VSS.t2114 VSS 0.45829f
C1659 VSS.t2113 VSS 0.45829f
C1660 VSS.t2213 VSS 0.0142f
C1661 VSS.t2212 VSS 0.0142f
C1662 VSS.t2207 VSS 0.01736f
C1663 VSS.t2206 VSS 0.01736f
C1664 VSS.t2099 VSS 0.01776f
C1665 VSS.t2098 VSS 0.01776f
C1666 VSS.t2159 VSS 0.01749f
C1667 VSS.t2158 VSS 0.01749f
C1668 VSS.t1865 VSS 0.06567f
C1669 VSS.t1910 VSS 0.0183f
C1670 VSS.t1914 VSS 0.02594f
C1671 VSS.t2019 VSS 0.01776f
C1672 VSS.t1913 VSS 0.02594f
C1673 VSS.t1911 VSS 0.0183f
C1674 VSS.t2018 VSS 0.01776f
C1675 VSS.t1866 VSS 0.06567f
C1676 VSS.t1959 VSS 0.0269f
C1677 VSS.t1958 VSS 0.0269f
C1678 VSS.t1734 VSS 0.06182f
C1679 VSS.t1735 VSS 0.06182f
C1680 VSS.t1627 VSS 0.10898f
C1681 VSS.t1632 VSS 0.01011f
C1682 VSS.t1633 VSS 0.01011f
C1683 VSS.t1644 VSS 0.0168f
C1684 VSS.t1645 VSS 0.0168f
C1685 VSS.t1756 VSS 0.01011f
C1686 VSS.t1759 VSS 0.01011f
C1687 VSS.t1662 VSS 0.05833f
C1688 VSS.t1663 VSS 0.05833f
C1689 VSS.t1669 VSS 0.01371f
C1690 VSS.t1672 VSS 0.04813f
C1691 VSS.t1684 VSS 0.05904f
C1692 VSS.t1564 VSS 0.06376f
C1693 VSS.t1544 VSS 0.03741f
C1694 VSS.t1543 VSS 0.03741f
C1695 VSS.t1388 VSS 0.14023f
C1696 VSS.t1387 VSS 0.14023f
C1697 VSS.t1417 VSS 0.01999f
C1698 VSS.t1418 VSS 0.01999f
C1699 VSS.t1565 VSS 0.06376f
C1700 VSS.t1568 VSS 0.01851f
C1701 VSS.t1271 VSS 0.0144f
C1702 VSS.t1382 VSS 0.01011f
C1703 VSS.t1381 VSS 0.01011f
C1704 VSS.t1272 VSS 0.0144f
C1705 VSS.t1268 VSS 0.01806f
C1706 VSS.t1242 VSS 0.06739f
C1707 VSS.t1305 VSS 0.01897f
C1708 VSS.t1304 VSS 0.01897f
C1709 VSS.t1188 VSS 0.09716f
C1710 VSS.t1284 VSS 0.01732f
C1711 VSS.t1283 VSS 0.01732f
C1712 VSS.t969 VSS 0.01618f
C1713 VSS.t970 VSS 0.01618f
C1714 VSS.t996 VSS 0.03753f
C1715 VSS.t1059 VSS 0.05416f
C1716 VSS.t1061 VSS 0.01442f
C1717 VSS.t1062 VSS 0.01442f
C1718 VSS.t1060 VSS 0.05416f
C1719 VSS.t1051 VSS 0.01011f
C1720 VSS.t1050 VSS 0.01011f
C1721 VSS.t1138 VSS 0.15314f
C1722 VSS.t1135 VSS 0.01258f
C1723 VSS.t1134 VSS 0.01258f
C1724 VSS.t1114 VSS 0.01831f
C1725 VSS.t1113 VSS 0.01831f
C1726 VSS.t997 VSS 0.03753f
C1727 VSS.t1081 VSS 0.13391f
C1728 VSS.t1080 VSS 0.13391f
C1729 VSS.t957 VSS 0.04595f
C1730 VSS.t958 VSS 0.04595f
C1731 VSS.t857 VSS 0.01011f
C1732 VSS.t860 VSS 0.87518f
C1733 VSS.t764 VSS 0.01377f
C1734 VSS.t875 VSS 0.14562f
C1735 VSS.t886 VSS 0.06945f
C1736 VSS.t887 VSS 0.06945f
C1737 VSS.t791 VSS 0.01428f
C1738 VSS.t923 VSS 0.03675f
C1739 VSS.t926 VSS 0.01897f
C1740 VSS.t950 VSS 0.02672f
C1741 VSS.t842 VSS 0.04529f
C1742 VSS.t949 VSS 0.02672f
C1743 VSS.t841 VSS 0.04529f
C1744 VSS.t613 VSS 0.01998f
C1745 VSS.t232 VSS 0.36847f
C1746 VSS.t3316 VSS 0.10336f
C1747 VSS.t268 VSS 0.01142f
C1748 VSS.t699 VSS 1.29068f
C1749 VSS.t201 VSS 0.48362f
C1750 VSS.t72 VSS 0.17593f
C1751 VSS.t67 VSS 0.02554f
C1752 VSS.t3396 VSS 0.13318f
C1753 VSS.t3267 VSS 0.09278f
C1754 VSS.t3430 VSS 0.1596f
C1755 VSS.t127 VSS 0.21482f
C1756 VSS.t598 VSS 0.01265f
C1757 VSS.t688 VSS 0.02068f
C1758 VSS.t551 VSS 0.01478f
C1759 VSS.t548 VSS 0.01751f
C1760 VSS.t547 VSS 0.01751f
C1761 VSS.t550 VSS 0.01478f
C1762 VSS.t84 VSS 0.03635f
C1763 VSS.t683 VSS 0.01897f
C1764 VSS.t682 VSS 0.01897f
C1765 VSS.t689 VSS 0.02068f
C1766 VSS.t599 VSS 0.01265f
C1767 VSS.t121 VSS 0.0893f
C1768 VSS.t3350 VSS 0.01039f
C1769 VSS.t3321 VSS 0.21038f
C1770 VSS.t3313 VSS 0.37605f
C1771 VSS.t266 VSS 0.02779f
C1772 VSS.t178 VSS 0.02075f
C1773 VSS.t183 VSS 0.35964f
C1774 VSS.t227 VSS 0.01038f
C1775 VSS.t230 VSS 0.19278f
C1776 VSS.t698 VSS 1.29068f
C1777 VSS.t185 VSS 0.14506f
C1778 VSS.t3339 VSS 0.2861f
C1779 VSS.t614 VSS 0.01998f
C1780 VSS.t636 VSS 0.01549f
C1781 VSS.t637 VSS 0.01549f
C1782 VSS.t113 VSS 0.18825f
C1783 VSS.t12 VSS 0.15872f
C1784 VSS.t3328 VSS 0.2783f
C1785 VSS.t136 VSS 0.25013f
C1786 VSS.t149 VSS 0.1898f
C1787 VSS.t3286 VSS 0.01689f
C1788 VSS.t3280 VSS 0.03635f
C1789 VSS.t436 VSS 0.13679f
C1790 VSS.t22 VSS 0.04946f
C1791 VSS.t236 VSS 0.04946f
C1792 VSS.t3333 VSS 0.14539f
C1793 VSS.t211 VSS 0.02284f
C1794 VSS.t3405 VSS 0.02284f
C1795 VSS.t3408 VSS 0.02284f
C1796 VSS.t46 VSS 0.14116f
C1797 VSS.t3411 VSS 0.02284f
C1798 VSS.t430 VSS 0.01257f
C1799 VSS.t431 VSS 0.01257f
C1800 VSS.t170 VSS 0.02284f
C1801 VSS.t173 VSS 0.02284f
C1802 VSS.t176 VSS 0.01142f
C1803 VSS.t3308 VSS 0.02742f
C1804 VSS.t234 VSS 0.03205f
C1805 VSS.t3 VSS 0.01603f
C1806 VSS.t20 VSS 0.36485f
C1807 VSS.t207 VSS 0.08467f
C1808 VSS.t425 VSS 0.01813f
C1809 VSS.t3385 VSS 0.44707f
C1810 VSS.t30 VSS 0.24113f
C1811 VSS.t3255 VSS 0.01128f
C1812 VSS.t134 VSS 0.08703f
C1813 VSS.t74 VSS 0.02256f
C1814 VSS.t54 VSS 0.37663f
C1815 VSS.t76 VSS 0.02256f
C1816 VSS.t189 VSS 0.18751f
C1817 VSS.t79 VSS 0.02256f
C1818 VSS.t162 VSS 0.02256f
C1819 VSS.t165 VSS 0.02256f
C1820 VSS.t168 VSS 0.01128f
C1821 VSS.t3360 VSS 3.83833f
C1822 VSS.t418 VSS 0.08145f
C1823 VSS.t415 VSS 0.01557f
C1824 VSS.t3303 VSS 0.0669f
C1825 VSS.t118 VSS 0.02497f
C1826 VSS.t143 VSS 0.02497f
C1827 VSS.t270 VSS 0.21029f
C1828 VSS.t220 VSS 0.02497f
C1829 VSS.t151 VSS 0.02497f
C1830 VSS.t3403 VSS 0.02186f
C1831 VSS.t217 VSS 0.02497f
C1832 VSS.t140 VSS 0.02497f
C1833 VSS.t59 VSS 0.13898f
C1834 VSS.t116 VSS 0.03855f
C1835 VSS.t57 VSS 0.27782f
C1836 VSS.t125 VSS 0.01249f
C1837 VSS.t195 VSS 0.60524f
C1838 VSS.t52 VSS 0.01325f
C1839 VSS.t1 VSS 0.04738f
C1840 VSS.t24 VSS 0.0487f
C1841 VSS.t485 VSS 0.025f
C1842 VSS.t102 VSS 0.10688f
C1843 VSS.t3319 VSS 0.12826f
C1844 VSS.t48 VSS 0.19217f
C1845 VSS.t181 VSS 0.31746f
C1846 VSS.t3366 VSS 0.02866f
C1847 VSS.t129 VSS 0.04274f
C1848 VSS.t251 VSS 0.03124f
C1849 VSS.t3380 VSS 0.15345f
C1850 VSS.t100 VSS 0.33181f
C1851 VSS.t147 VSS 0.049f
C1852 VSS.t157 VSS 0.02537f
C1853 VSS.t187 VSS 0.04082f
C1854 VSS.t239 VSS 0.03277f
.ends

* NGSPICE file created from counter_top.ext - technology: sky130A

* Black-box entry subcircuit for sky130_fd_sc_hd__decap_12 abstract view
.subckt sky130_fd_sc_hd__decap_12 VGND VNB VPB VPWR
.ends

* Black-box entry subcircuit for sky130_fd_sc_hd__decap_6 abstract view
.subckt sky130_fd_sc_hd__decap_6 VGND VNB VPB VPWR
.ends

* Black-box entry subcircuit for sky130_fd_sc_hd__tapvpwrvgnd_1 abstract view
.subckt sky130_fd_sc_hd__tapvpwrvgnd_1 VGND VPWR
.ends

* Black-box entry subcircuit for sky130_fd_sc_hd__fill_1 abstract view
.subckt sky130_fd_sc_hd__fill_1 VGND VNB VPB VPWR
.ends

* Black-box entry subcircuit for sky130_fd_sc_hd__nand3_1 abstract view
.subckt sky130_fd_sc_hd__nand3_1 A B C VGND VNB VPB VPWR Y
.ends

* Black-box entry subcircuit for sky130_fd_sc_hd__fill_2 abstract view
.subckt sky130_fd_sc_hd__fill_2 VGND VNB VPB VPWR
.ends

* Black-box entry subcircuit for sky130_fd_sc_hd__decap_3 abstract view
.subckt sky130_fd_sc_hd__decap_3 VGND VNB VPB VPWR
.ends

* Black-box entry subcircuit for sky130_fd_sc_hd__buf_2 abstract view
.subckt sky130_fd_sc_hd__buf_2 A VGND VNB VPB VPWR X
.ends

* Black-box entry subcircuit for sky130_fd_sc_hd__buf_1 abstract view
.subckt sky130_fd_sc_hd__buf_1 A VGND VNB VPB VPWR X
.ends

* Black-box entry subcircuit for sky130_fd_sc_hd__buf_4 abstract view
.subckt sky130_fd_sc_hd__buf_4 A VGND VNB VPB VPWR X
.ends

* Black-box entry subcircuit for sky130_fd_sc_hd__and2_1 abstract view
.subckt sky130_fd_sc_hd__and2_1 A B VGND VNB VPB VPWR X
.ends

* Black-box entry subcircuit for sky130_fd_sc_hd__a21boi_1 abstract view
.subckt sky130_fd_sc_hd__a21boi_1 A1 A2 B1_N VGND VNB VPB VPWR Y
.ends

* Black-box entry subcircuit for sky130_fd_sc_hd__xnor2_1 abstract view
.subckt sky130_fd_sc_hd__xnor2_1 A B VGND VNB VPB VPWR Y
.ends

* Black-box entry subcircuit for sky130_fd_sc_hd__or3_1 abstract view
.subckt sky130_fd_sc_hd__or3_1 A B C VGND VNB VPB VPWR X
.ends

* Black-box entry subcircuit for sky130_fd_sc_hd__dlygate4sd3_1 abstract view
.subckt sky130_fd_sc_hd__dlygate4sd3_1 A VGND VNB VPB VPWR X
.ends

* Black-box entry subcircuit for sky130_fd_sc_hd__nand2_1 abstract view
.subckt sky130_fd_sc_hd__nand2_1 A B VGND VNB VPB VPWR Y
.ends

* Black-box entry subcircuit for sky130_fd_sc_hd__o21ai_0 abstract view
.subckt sky130_fd_sc_hd__o21ai_0 A1 A2 B1 VGND VNB VPB VPWR Y
.ends

* Black-box entry subcircuit for sky130_fd_sc_hd__decap_8 abstract view
.subckt sky130_fd_sc_hd__decap_8 VGND VNB VPB VPWR
.ends

* Black-box entry subcircuit for sky130_fd_sc_hd__decap_4 abstract view
.subckt sky130_fd_sc_hd__decap_4 VGND VNB VPB VPWR
.ends

* Black-box entry subcircuit for sky130_fd_sc_hd__clkbuf_16 abstract view
.subckt sky130_fd_sc_hd__clkbuf_16 A VGND VNB VPB VPWR X
.ends

* Black-box entry subcircuit for sky130_fd_sc_hd__dfxtp_1 abstract view
.subckt sky130_fd_sc_hd__dfxtp_1 CLK D VGND VNB VPB VPWR Q
.ends

* Black-box entry subcircuit for sky130_fd_sc_hd__xor2_1 abstract view
.subckt sky130_fd_sc_hd__xor2_1 A B VGND VNB VPB VPWR X
.ends

* Black-box entry subcircuit for sky130_fd_sc_hd__mux2i_2 abstract view
.subckt sky130_fd_sc_hd__mux2i_2 A0 A1 S VGND VNB VPB VPWR Y
.ends

* Black-box entry subcircuit for sky130_fd_sc_hd__nor3_1 abstract view
.subckt sky130_fd_sc_hd__nor3_1 A B C VGND VNB VPB VPWR Y
.ends

* Black-box entry subcircuit for sky130_fd_sc_hd__inv_1 abstract view
.subckt sky130_fd_sc_hd__inv_1 A VGND VNB VPB VPWR Y
.ends

* Black-box entry subcircuit for sky130_fd_sc_hd__nand2b_1 abstract view
.subckt sky130_fd_sc_hd__nand2b_1 A_N B VGND VNB VPB VPWR Y
.ends

* Black-box entry subcircuit for sky130_fd_sc_hd__nand4_4 abstract view
.subckt sky130_fd_sc_hd__nand4_4 A B C D VGND VNB VPB VPWR Y
.ends

.subckt counter_top VDD VSS clock_i counter_value_o[0] counter_value_o[1] counter_value_o[2]
+ counter_value_o[3] counter_value_o[4] counter_value_o[5] counter_value_o[6] counter_value_o[7]
+ enable_i reset_n_i
XFILLER_22_177 VSS VSS VDD VDD sky130_fd_sc_hd__decap_12
XFILLER_22_133 VSS VSS VDD VDD sky130_fd_sc_hd__decap_6
XTAP_TAPCELL_ROW_9_126 VSS VDD sky130_fd_sc_hd__tapvpwrvgnd_1
XFILLER_13_111 VSS VSS VDD VDD sky130_fd_sc_hd__fill_1
XFILLER_9_137 VSS VSS VDD VDD sky130_fd_sc_hd__decap_12
XFILLER_27_225 VSS VSS VDD VDD sky130_fd_sc_hd__decap_6
XTAP_TAPCELL_ROW_14_161 VSS VDD sky130_fd_sc_hd__tapvpwrvgnd_1
XTAP_TAPCELL_ROW_6_107 VSS VDD sky130_fd_sc_hd__tapvpwrvgnd_1
XFILLER_12_65 VSS VSS VDD VDD sky130_fd_sc_hd__decap_12
XFILLER_2_357 VSS VSS VDD VDD sky130_fd_sc_hd__decap_6
X_66_ _66_/A _74_/Q _73_/Q VSS VSS VDD VDD _67_/B sky130_fd_sc_hd__nand3_1
XFILLER_20_401 VSS VSS VDD VDD sky130_fd_sc_hd__decap_6
XTAP_TAPCELL_ROW_11_142 VSS VDD sky130_fd_sc_hd__tapvpwrvgnd_1
XFILLER_15_217 VSS VSS VDD VDD sky130_fd_sc_hd__decap_6
XFILLER_7_405 VSS VSS VDD VDD sky130_fd_sc_hd__fill_2
XFILLER_9_55 VSS VSS VDD VDD sky130_fd_sc_hd__fill_1
XFILLER_0_57 VSS VSS VDD VDD sky130_fd_sc_hd__decap_12
XFILLER_2_121 VSS VSS VDD VDD sky130_fd_sc_hd__decap_12
XFILLER_2_165 VSS VSS VDD VDD sky130_fd_sc_hd__decap_12
X_49_ _70_/Q _77_/Q _76_/Q VSS VSS VDD VDD _57_/C sky130_fd_sc_hd__nand3_1
XFILLER_20_253 VSS VSS VDD VDD sky130_fd_sc_hd__decap_12
XFILLER_12_209 VSS VSS VDD VDD sky130_fd_sc_hd__decap_12
XPHY_EDGE_ROW_8_Left_36 VSS VSS VDD VDD sky130_fd_sc_hd__decap_3
XFILLER_18_97 VSS VSS VDD VDD sky130_fd_sc_hd__decap_12
XFILLER_18_53 VSS VSS VDD VDD sky130_fd_sc_hd__decap_12
XFILLER_7_279 VSS VSS VDD VDD sky130_fd_sc_hd__fill_1
XFILLER_25_312 VSS VSS VDD VDD sky130_fd_sc_hd__decap_12
XFILLER_20_65 VSS VSS VDD VDD sky130_fd_sc_hd__decap_12
XFILLER_16_389 VSS VSS VDD VDD sky130_fd_sc_hd__decap_12
XFILLER_16_345 VSS VSS VDD VDD sky130_fd_sc_hd__decap_12
XFILLER_16_301 VSS VSS VDD VDD sky130_fd_sc_hd__decap_6
XFILLER_19_161 VSS VSS VDD VDD sky130_fd_sc_hd__decap_6
XFILLER_13_3 VSS VSS VDD VDD sky130_fd_sc_hd__decap_12
XFILLER_3_293 VSS VSS VDD VDD sky130_fd_sc_hd__decap_12
XFILLER_25_153 VSS VSS VDD VDD sky130_fd_sc_hd__decap_12
XFILLER_13_337 VSS VSS VDD VDD sky130_fd_sc_hd__decap_12
Xoutput7 _77_/Q VSS VSS VDD VDD counter_value_o[4] sky130_fd_sc_hd__buf_2
XFILLER_16_197 VSS VSS VDD VDD sky130_fd_sc_hd__decap_12
XFILLER_16_153 VSS VSS VDD VDD sky130_fd_sc_hd__decap_12
XFILLER_8_363 VSS VSS VDD VDD sky130_fd_sc_hd__fill_1
XTAP_TAPCELL_ROW_2_79 VSS VDD sky130_fd_sc_hd__tapvpwrvgnd_1
XFILLER_22_189 VSS VSS VDD VDD sky130_fd_sc_hd__decap_6
XFILLER_10_307 VSS VSS VDD VDD sky130_fd_sc_hd__fill_1
XTAP_TAPCELL_ROW_9_127 VSS VDD sky130_fd_sc_hd__tapvpwrvgnd_1
XPHY_EDGE_ROW_21_Left_49 VSS VSS VDD VDD sky130_fd_sc_hd__decap_3
XFILLER_13_167 VSS VSS VDD VDD sky130_fd_sc_hd__fill_1
XFILLER_9_149 VSS VSS VDD VDD sky130_fd_sc_hd__decap_12
XFILLER_9_105 VSS VSS VDD VDD sky130_fd_sc_hd__decap_6
XFILLER_3_57 VSS VSS VDD VDD sky130_fd_sc_hd__decap_12
XTAP_TAPCELL_ROW_14_162 VSS VDD sky130_fd_sc_hd__tapvpwrvgnd_1
XTAP_TAPCELL_ROW_6_108 VSS VDD sky130_fd_sc_hd__tapvpwrvgnd_1
XFILLER_12_77 VSS VSS VDD VDD sky130_fd_sc_hd__decap_6
X_65_ _65_/A VSS VSS VDD VDD _74_/D sky130_fd_sc_hd__buf_1
XFILLER_17_281 VSS VSS VDD VDD sky130_fd_sc_hd__decap_12
XTAP_TAPCELL_ROW_11_143 VSS VDD sky130_fd_sc_hd__tapvpwrvgnd_1
XFILLER_1_391 VSS VSS VDD VDD sky130_fd_sc_hd__fill_1
XPHY_EDGE_ROW_21_Right_21 VSS VSS VDD VDD sky130_fd_sc_hd__decap_3
XPHY_EDGE_ROW_12_Right_12 VSS VSS VDD VDD sky130_fd_sc_hd__decap_3
XFILLER_14_251 VSS VSS VDD VDD sky130_fd_sc_hd__fill_1
XFILLER_0_69 VSS VSS VDD VDD sky130_fd_sc_hd__decap_12
XFILLER_2_133 VSS VSS VDD VDD sky130_fd_sc_hd__decap_6
XFILLER_2_177 VSS VSS VDD VDD sky130_fd_sc_hd__decap_12
XPHY_EDGE_ROW_24_Left_52 VSS VSS VDD VDD sky130_fd_sc_hd__decap_3
X_48_ _48_/A VSS VSS VDD VDD _70_/D sky130_fd_sc_hd__buf_4
XFILLER_20_265 VSS VSS VDD VDD sky130_fd_sc_hd__decap_12
XFILLER_20_221 VSS VSS VDD VDD sky130_fd_sc_hd__decap_12
XFILLER_18_65 VSS VSS VDD VDD sky130_fd_sc_hd__decap_12
XFILLER_7_225 VSS VSS VDD VDD sky130_fd_sc_hd__decap_12
XFILLER_25_324 VSS VSS VDD VDD sky130_fd_sc_hd__decap_12
XFILLER_20_77 VSS VSS VDD VDD sky130_fd_sc_hd__decap_6
XFILLER_16_357 VSS VSS VDD VDD sky130_fd_sc_hd__decap_6
XFILLER_3_261 VSS VSS VDD VDD sky130_fd_sc_hd__decap_12
XFILLER_25_165 VSS VSS VDD VDD sky130_fd_sc_hd__decap_3
XFILLER_15_55 VSS VSS VDD VDD sky130_fd_sc_hd__fill_1
XFILLER_13_349 VSS VSS VDD VDD sky130_fd_sc_hd__decap_12
XFILLER_13_305 VSS VSS VDD VDD sky130_fd_sc_hd__decap_12
XPHY_EDGE_ROW_6_Right_6 VSS VSS VDD VDD sky130_fd_sc_hd__decap_3
Xoutput10 _72_/Q VSS VSS VDD VDD counter_value_o[7] sky130_fd_sc_hd__buf_2
Xoutput8 _70_/Q VSS VSS VDD VDD counter_value_o[5] sky130_fd_sc_hd__buf_2
XFILLER_21_393 VSS VSS VDD VDD sky130_fd_sc_hd__decap_12
XFILLER_16_165 VSS VSS VDD VDD sky130_fd_sc_hd__decap_12
XFILLER_16_121 VSS VSS VDD VDD sky130_fd_sc_hd__decap_12
XFILLER_0_253 VSS VSS VDD VDD sky130_fd_sc_hd__decap_12
XTAP_TAPCELL_ROW_17_182 VSS VDD sky130_fd_sc_hd__tapvpwrvgnd_1
XFILLER_26_54 VSS VSS VDD VDD sky130_fd_sc_hd__decap_3
XFILLER_13_113 VSS VSS VDD VDD sky130_fd_sc_hd__decap_12
XTAP_TAPCELL_ROW_9_128 VSS VDD sky130_fd_sc_hd__tapvpwrvgnd_1
XTAP_TAPCELL_ROW_14_163 VSS VDD sky130_fd_sc_hd__tapvpwrvgnd_1
XTAP_TAPCELL_ROW_6_109 VSS VDD sky130_fd_sc_hd__tapvpwrvgnd_1
XFILLER_3_69 VSS VSS VDD VDD sky130_fd_sc_hd__decap_12
XTAP_TAPCELL_ROW_3_90 VSS VDD sky130_fd_sc_hd__tapvpwrvgnd_1
XFILLER_6_109 VSS VSS VDD VDD sky130_fd_sc_hd__decap_12
X_64_ _68_/A _64_/B VSS VSS VDD VDD _65_/A sky130_fd_sc_hd__and2_1
XTAP_TAPCELL_ROW_19_200 VSS VDD sky130_fd_sc_hd__tapvpwrvgnd_1
XTAP_TAPCELL_ROW_11_144 VSS VDD sky130_fd_sc_hd__tapvpwrvgnd_1
XFILLER_17_293 VSS VSS VDD VDD sky130_fd_sc_hd__decap_12
XFILLER_23_55 VSS VSS VDD VDD sky130_fd_sc_hd__fill_1
XFILLER_0_15 VSS VSS VDD VDD sky130_fd_sc_hd__decap_12
XFILLER_2_189 VSS VSS VDD VDD sky130_fd_sc_hd__decap_6
XFILLER_3_3 VSS VSS VDD VDD sky130_fd_sc_hd__decap_12
X_47_ _45_/Y _46_/X _68_/A VSS VSS VDD VDD _48_/A sky130_fd_sc_hd__a21boi_1
XTAP_TAPCELL_ROW_22_217 VSS VDD sky130_fd_sc_hd__tapvpwrvgnd_1
XFILLER_20_233 VSS VSS VDD VDD sky130_fd_sc_hd__decap_12
XFILLER_9_57 VSS VSS VDD VDD sky130_fd_sc_hd__decap_12
XFILLER_20_277 VSS VSS VDD VDD sky130_fd_sc_hd__decap_12
XFILLER_18_77 VSS VSS VDD VDD sky130_fd_sc_hd__decap_6
XFILLER_7_237 VSS VSS VDD VDD sky130_fd_sc_hd__decap_12
XFILLER_3_273 VSS VSS VDD VDD sky130_fd_sc_hd__decap_6
XFILLER_15_391 VSS VSS VDD VDD sky130_fd_sc_hd__fill_1
Xoutput9 _71_/Q VSS VSS VDD VDD counter_value_o[6] sky130_fd_sc_hd__buf_2
XFILLER_21_361 VSS VSS VDD VDD sky130_fd_sc_hd__decap_12
XFILLER_16_133 VSS VSS VDD VDD sky130_fd_sc_hd__decap_6
XFILLER_13_317 VSS VSS VDD VDD sky130_fd_sc_hd__decap_12
XFILLER_0_265 VSS VSS VDD VDD sky130_fd_sc_hd__decap_12
XFILLER_0_221 VSS VSS VDD VDD sky130_fd_sc_hd__decap_3
XTAP_TAPCELL_ROW_17_183 VSS VDD sky130_fd_sc_hd__tapvpwrvgnd_1
XFILLER_16_177 VSS VSS VDD VDD sky130_fd_sc_hd__decap_12
XFILLER_8_365 VSS VSS VDD VDD sky130_fd_sc_hd__decap_12
XFILLER_8_321 VSS VSS VDD VDD sky130_fd_sc_hd__decap_12
XFILLER_13_169 VSS VSS VDD VDD sky130_fd_sc_hd__decap_12
XFILLER_13_125 VSS VSS VDD VDD sky130_fd_sc_hd__decap_12
XFILLER_10_309 VSS VSS VDD VDD sky130_fd_sc_hd__decap_12
XTAP_TAPCELL_ROW_9_129 VSS VDD sky130_fd_sc_hd__tapvpwrvgnd_1
XTAP_TAPCELL_ROW_14_164 VSS VDD sky130_fd_sc_hd__tapvpwrvgnd_1
XFILLER_8_195 VSS VSS VDD VDD sky130_fd_sc_hd__fill_1
XFILLER_3_15 VSS VSS VDD VDD sky130_fd_sc_hd__decap_12
XFILLER_5_335 VSS VSS VDD VDD sky130_fd_sc_hd__fill_1
XFILLER_10_139 VSS VSS VDD VDD sky130_fd_sc_hd__fill_1
XFILLER_14_401 VSS VSS VDD VDD sky130_fd_sc_hd__decap_6
XTAP_TAPCELL_ROW_11_145 VSS VDD sky130_fd_sc_hd__tapvpwrvgnd_1
X_63_ _74_/Q _63_/B VSS VSS VDD VDD _64_/B sky130_fd_sc_hd__xnor2_1
XTAP_TAPCELL_ROW_19_201 VSS VDD sky130_fd_sc_hd__tapvpwrvgnd_1
XFILLER_17_261 VSS VSS VDD VDD sky130_fd_sc_hd__decap_12
XFILLER_1_393 VSS VSS VDD VDD sky130_fd_sc_hd__decap_12
XFILLER_0_27 VSS VSS VDD VDD sky130_fd_sc_hd__fill_1
X_46_ _70_/Q _57_/B _46_/C VSS VSS VDD VDD _46_/X sky130_fd_sc_hd__or3_1
XFILLER_14_253 VSS VSS VDD VDD sky130_fd_sc_hd__decap_12
XFILLER_9_69 VSS VSS VDD VDD sky130_fd_sc_hd__decap_12
XTAP_TAPCELL_ROW_22_218 VSS VDD sky130_fd_sc_hd__tapvpwrvgnd_1
XFILLER_20_289 VSS VSS VDD VDD sky130_fd_sc_hd__decap_12
XFILLER_20_245 VSS VSS VDD VDD sky130_fd_sc_hd__decap_6
XFILLER_11_223 VSS VSS VDD VDD sky130_fd_sc_hd__fill_1
XFILLER_7_249 VSS VSS VDD VDD sky130_fd_sc_hd__decap_12
XFILLER_7_205 VSS VSS VDD VDD sky130_fd_sc_hd__decap_12
XFILLER_25_337 VSS VSS VDD VDD sky130_fd_sc_hd__decap_12
XFILLER_1_81 VSS VSS VDD VDD sky130_fd_sc_hd__decap_12
Xhold11 _72_/Q VSS VSS VDD VDD _54_/A sky130_fd_sc_hd__dlygate4sd3_1
XFILLER_6_15 VSS VSS VDD VDD sky130_fd_sc_hd__decap_12
XFILLER_22_307 VSS VSS VDD VDD sky130_fd_sc_hd__fill_1
XFILLER_25_189 VSS VSS VDD VDD sky130_fd_sc_hd__fill_1
XFILLER_21_373 VSS VSS VDD VDD sky130_fd_sc_hd__decap_12
XFILLER_15_57 VSS VSS VDD VDD sky130_fd_sc_hd__decap_12
XFILLER_13_329 VSS VSS VDD VDD sky130_fd_sc_hd__decap_6
XFILLER_0_277 VSS VSS VDD VDD sky130_fd_sc_hd__decap_3
XFILLER_16_189 VSS VSS VDD VDD sky130_fd_sc_hd__decap_6
XFILLER_11_3 VSS VSS VDD VDD sky130_fd_sc_hd__decap_12
XFILLER_8_377 VSS VSS VDD VDD sky130_fd_sc_hd__decap_12
XFILLER_8_333 VSS VSS VDD VDD sky130_fd_sc_hd__decap_12
XFILLER_26_78 VSS VSS VDD VDD sky130_fd_sc_hd__fill_2
XTAP_TAPCELL_ROW_17_184 VSS VDD sky130_fd_sc_hd__tapvpwrvgnd_1
XFILLER_21_181 VSS VSS VDD VDD sky130_fd_sc_hd__decap_12
XFILLER_13_137 VSS VSS VDD VDD sky130_fd_sc_hd__decap_12
XFILLER_3_27 VSS VSS VDD VDD sky130_fd_sc_hd__decap_12
XTAP_TAPCELL_ROW_14_165 VSS VDD sky130_fd_sc_hd__tapvpwrvgnd_1
XFILLER_8_141 VSS VSS VDD VDD sky130_fd_sc_hd__decap_12
XTAP_TAPCELL_ROW_11_146 VSS VDD sky130_fd_sc_hd__tapvpwrvgnd_1
XFILLER_5_111 VSS VSS VDD VDD sky130_fd_sc_hd__fill_1
XTAP_TAPCELL_ROW_5_100 VSS VDD sky130_fd_sc_hd__tapvpwrvgnd_1
X_62_ _66_/A _73_/Q VSS VSS VDD VDD _63_/B sky130_fd_sc_hd__nand2_1
XTAP_TAPCELL_ROW_19_202 VSS VDD sky130_fd_sc_hd__tapvpwrvgnd_1
XFILLER_17_273 VSS VSS VDD VDD sky130_fd_sc_hd__decap_6
XFILLER_1_361 VSS VSS VDD VDD sky130_fd_sc_hd__decap_12
XTAP_TAPCELL_ROW_25_238 VSS VDD sky130_fd_sc_hd__tapvpwrvgnd_1
XFILLER_23_57 VSS VSS VDD VDD sky130_fd_sc_hd__decap_12
XFILLER_11_405 VSS VSS VDD VDD sky130_fd_sc_hd__fill_2
XFILLER_14_265 VSS VSS VDD VDD sky130_fd_sc_hd__decap_12
XFILLER_14_221 VSS VSS VDD VDD sky130_fd_sc_hd__decap_12
XFILLER_9_15 VSS VSS VDD VDD sky130_fd_sc_hd__decap_12
XTAP_TAPCELL_ROW_0_60 VSS VDD sky130_fd_sc_hd__tapvpwrvgnd_1
X_45_ _57_/B _46_/C _70_/Q VSS VSS VDD VDD _45_/Y sky130_fd_sc_hd__o21ai_0
XTAP_TAPCELL_ROW_22_219 VSS VDD sky130_fd_sc_hd__tapvpwrvgnd_1
XFILLER_19_335 VSS VSS VDD VDD sky130_fd_sc_hd__fill_1
XFILLER_11_279 VSS VSS VDD VDD sky130_fd_sc_hd__fill_1
XFILLER_7_217 VSS VSS VDD VDD sky130_fd_sc_hd__decap_6
XFILLER_25_349 VSS VSS VDD VDD sky130_fd_sc_hd__decap_12
XFILLER_1_93 VSS VSS VDD VDD sky130_fd_sc_hd__decap_12
Xhold12 _58_/Y VSS VSS VDD VDD _72_/D sky130_fd_sc_hd__dlygate4sd3_1
XFILLER_4_209 VSS VSS VDD VDD sky130_fd_sc_hd__decap_12
XFILLER_15_393 VSS VSS VDD VDD sky130_fd_sc_hd__decap_12
XFILLER_6_27 VSS VSS VDD VDD sky130_fd_sc_hd__fill_1
XFILLER_21_385 VSS VSS VDD VDD sky130_fd_sc_hd__decap_6
XFILLER_15_69 VSS VSS VDD VDD sky130_fd_sc_hd__decap_12
XFILLER_24_190 VSS VSS VDD VDD sky130_fd_sc_hd__decap_6
XPHY_EDGE_ROW_19_Right_19 VSS VSS VDD VDD sky130_fd_sc_hd__decap_3
XFILLER_12_363 VSS VSS VDD VDD sky130_fd_sc_hd__fill_1
XFILLER_8_389 VSS VSS VDD VDD sky130_fd_sc_hd__decap_12
XFILLER_8_345 VSS VSS VDD VDD sky130_fd_sc_hd__decap_12
XFILLER_8_301 VSS VSS VDD VDD sky130_fd_sc_hd__decap_6
XTAP_TAPCELL_ROW_17_185 VSS VDD sky130_fd_sc_hd__tapvpwrvgnd_1
XPHY_EDGE_ROW_15_Left_43 VSS VSS VDD VDD sky130_fd_sc_hd__decap_3
XFILLER_7_81 VSS VSS VDD VDD sky130_fd_sc_hd__decap_12
XFILLER_21_193 VSS VSS VDD VDD sky130_fd_sc_hd__decap_12
XFILLER_13_149 VSS VSS VDD VDD sky130_fd_sc_hd__decap_12
XFILLER_13_105 VSS VSS VDD VDD sky130_fd_sc_hd__decap_6
XTAP_TAPCELL_ROW_8_120 VSS VDD sky130_fd_sc_hd__tapvpwrvgnd_1
XFILLER_3_39 VSS VSS VDD VDD sky130_fd_sc_hd__decap_12
XFILLER_5_337 VSS VSS VDD VDD sky130_fd_sc_hd__decap_12
XTAP_TAPCELL_ROW_14_166 VSS VDD sky130_fd_sc_hd__tapvpwrvgnd_1
XFILLER_8_197 VSS VSS VDD VDD sky130_fd_sc_hd__decap_12
XFILLER_8_153 VSS VSS VDD VDD sky130_fd_sc_hd__decap_12
XFILLER_12_15 VSS VSS VDD VDD sky130_fd_sc_hd__decap_12
XPHY_EDGE_ROW_0_Left_28 VSS VSS VDD VDD sky130_fd_sc_hd__decap_3
XFILLER_2_307 VSS VSS VDD VDD sky130_fd_sc_hd__fill_1
XTAP_TAPCELL_ROW_5_101 VSS VDD sky130_fd_sc_hd__tapvpwrvgnd_1
X_61_ _61_/A VSS VSS VDD VDD _73_/D sky130_fd_sc_hd__buf_1
XFILLER_1_373 VSS VSS VDD VDD sky130_fd_sc_hd__decap_12
XFILLER_5_167 VSS VSS VDD VDD sky130_fd_sc_hd__fill_1
XTAP_TAPCELL_ROW_25_239 VSS VDD sky130_fd_sc_hd__tapvpwrvgnd_1
XFILLER_23_244 VSS VSS VDD VDD sky130_fd_sc_hd__decap_12
XFILLER_23_69 VSS VSS VDD VDD sky130_fd_sc_hd__decap_12
XFILLER_14_277 VSS VSS VDD VDD sky130_fd_sc_hd__decap_12
XFILLER_14_233 VSS VSS VDD VDD sky130_fd_sc_hd__decap_12
XFILLER_9_27 VSS VSS VDD VDD sky130_fd_sc_hd__decap_12
XFILLER_0_29 VSS VSS VDD VDD sky130_fd_sc_hd__decap_12
X_44_ _77_/Q _76_/Q VSS VSS VDD VDD _46_/C sky130_fd_sc_hd__nand2_1
XFILLER_9_281 VSS VSS VDD VDD sky130_fd_sc_hd__decap_12
XTAP_TAPCELL_ROW_0_61 VSS VDD sky130_fd_sc_hd__tapvpwrvgnd_1
XFILLER_1_181 VSS VSS VDD VDD sky130_fd_sc_hd__decap_12
XFILLER_11_225 VSS VSS VDD VDD sky130_fd_sc_hd__decap_12
XFILLER_1_3 VSS VSS VDD VDD sky130_fd_sc_hd__decap_12
XPHY_EDGE_ROW_3_Left_31 VSS VSS VDD VDD sky130_fd_sc_hd__decap_3
XFILLER_6_251 VSS VSS VDD VDD sky130_fd_sc_hd__fill_1
XFILLER_20_15 VSS VSS VDD VDD sky130_fd_sc_hd__decap_12
XFILLER_0_405 VSS VSS VDD VDD sky130_fd_sc_hd__fill_2
XFILLER_22_309 VSS VSS VDD VDD sky130_fd_sc_hd__decap_12
XFILLER_19_111 VSS VSS VDD VDD sky130_fd_sc_hd__fill_1
XFILLER_15_361 VSS VSS VDD VDD sky130_fd_sc_hd__decap_12
XFILLER_15_15 VSS VSS VDD VDD sky130_fd_sc_hd__decap_12
XFILLER_8_357 VSS VSS VDD VDD sky130_fd_sc_hd__decap_6
XFILLER_22_139 VSS VSS VDD VDD sky130_fd_sc_hd__fill_1
XTAP_TAPCELL_ROW_17_186 VSS VDD sky130_fd_sc_hd__tapvpwrvgnd_1
XFILLER_7_93 VSS VSS VDD VDD sky130_fd_sc_hd__decap_12
XFILLER_26_401 VSS VSS VDD VDD sky130_fd_sc_hd__decap_6
XFILLER_26_36 VSS VSS VDD VDD sky130_fd_sc_hd__fill_2
XFILLER_21_161 VSS VSS VDD VDD sky130_fd_sc_hd__decap_6
XTAP_TAPCELL_ROW_8_121 VSS VDD sky130_fd_sc_hd__tapvpwrvgnd_1
XFILLER_5_305 VSS VSS VDD VDD sky130_fd_sc_hd__decap_12
XFILLER_5_349 VSS VSS VDD VDD sky130_fd_sc_hd__decap_12
XFILLER_27_209 VSS VSS VDD VDD sky130_fd_sc_hd__decap_12
XTAP_TAPCELL_ROW_14_167 VSS VDD sky130_fd_sc_hd__tapvpwrvgnd_1
XFILLER_8_165 VSS VSS VDD VDD sky130_fd_sc_hd__decap_12
XFILLER_8_121 VSS VSS VDD VDD sky130_fd_sc_hd__decap_12
XFILLER_26_253 VSS VSS VDD VDD sky130_fd_sc_hd__decap_8
XFILLER_18_209 VSS VSS VDD VDD sky130_fd_sc_hd__decap_12
XFILLER_12_27 VSS VSS VDD VDD sky130_fd_sc_hd__fill_1
XFILLER_10_109 VSS VSS VDD VDD sky130_fd_sc_hd__decap_12
XTAP_TAPCELL_ROW_5_102 VSS VDD sky130_fd_sc_hd__tapvpwrvgnd_1
X_60_ _68_/A _60_/B VSS VSS VDD VDD _61_/A sky130_fd_sc_hd__and2_1
XFILLER_1_385 VSS VSS VDD VDD sky130_fd_sc_hd__decap_6
XFILLER_5_113 VSS VSS VDD VDD sky130_fd_sc_hd__decap_12
XFILLER_23_256 VSS VSS VDD VDD sky130_fd_sc_hd__decap_12
XFILLER_23_223 VSS VSS VDD VDD sky130_fd_sc_hd__fill_1
XFILLER_23_15 VSS VSS VDD VDD sky130_fd_sc_hd__decap_12
XFILLER_4_83 VSS VSS VDD VDD sky130_fd_sc_hd__fill_1
XFILLER_14_289 VSS VSS VDD VDD sky130_fd_sc_hd__decap_12
XFILLER_14_245 VSS VSS VDD VDD sky130_fd_sc_hd__decap_6
XFILLER_13_81 VSS VSS VDD VDD sky130_fd_sc_hd__decap_12
XFILLER_9_39 VSS VSS VDD VDD sky130_fd_sc_hd__decap_12
X_43_ _43_/A VSS VSS VDD VDD _77_/D sky130_fd_sc_hd__buf_4
XFILLER_9_293 VSS VSS VDD VDD sky130_fd_sc_hd__decap_12
XTAP_TAPCELL_ROW_0_62 VSS VDD sky130_fd_sc_hd__tapvpwrvgnd_1
XFILLER_1_193 VSS VSS VDD VDD sky130_fd_sc_hd__decap_12
XTAP_TAPCELL_ROW_21_210 VSS VDD sky130_fd_sc_hd__tapvpwrvgnd_1
XFILLER_18_15 VSS VSS VDD VDD sky130_fd_sc_hd__decap_12
XFILLER_11_237 VSS VSS VDD VDD sky130_fd_sc_hd__decap_12
XFILLER_27_3 VSS VSS VDD VDD sky130_fd_sc_hd__decap_12
XFILLER_19_337 VSS VSS VDD VDD sky130_fd_sc_hd__decap_12
XFILLER_20_27 VSS VSS VDD VDD sky130_fd_sc_hd__fill_1
XFILLER_1_51 VSS VSS VDD VDD sky130_fd_sc_hd__decap_4
XFILLER_19_167 VSS VSS VDD VDD sky130_fd_sc_hd__fill_1
XFILLER_16_307 VSS VSS VDD VDD sky130_fd_sc_hd__fill_1
XFILLER_6_29 VSS VSS VDD VDD sky130_fd_sc_hd__decap_12
XFILLER_15_373 VSS VSS VDD VDD sky130_fd_sc_hd__decap_12
XFILLER_15_27 VSS VSS VDD VDD sky130_fd_sc_hd__decap_12
XFILLER_12_365 VSS VSS VDD VDD sky130_fd_sc_hd__decap_12
XFILLER_12_321 VSS VSS VDD VDD sky130_fd_sc_hd__decap_12
XFILLER_0_225 VSS VSS VDD VDD sky130_fd_sc_hd__decap_12
XPHY_EDGE_ROW_1_Right_1 VSS VSS VDD VDD sky130_fd_sc_hd__decap_3
XFILLER_21_81 VSS VSS VDD VDD sky130_fd_sc_hd__decap_12
XTAP_TAPCELL_ROW_17_187 VSS VDD sky130_fd_sc_hd__tapvpwrvgnd_1
XFILLER_15_181 VSS VSS VDD VDD sky130_fd_sc_hd__decap_12
XFILLER_26_15 VSS VSS VDD VDD sky130_fd_sc_hd__decap_12
XFILLER_7_391 VSS VSS VDD VDD sky130_fd_sc_hd__fill_1
XFILLER_5_317 VSS VSS VDD VDD sky130_fd_sc_hd__decap_12
XFILLER_12_195 VSS VSS VDD VDD sky130_fd_sc_hd__fill_1
XTAP_TAPCELL_ROW_8_122 VSS VDD sky130_fd_sc_hd__tapvpwrvgnd_1
XFILLER_8_177 VSS VSS VDD VDD sky130_fd_sc_hd__decap_12
XFILLER_8_133 VSS VSS VDD VDD sky130_fd_sc_hd__decap_6
XTAP_TAPCELL_ROW_3_84 VSS VDD sky130_fd_sc_hd__tapvpwrvgnd_1
XFILLER_23_405 VSS VSS VDD VDD sky130_fd_sc_hd__fill_2
XFILLER_2_309 VSS VSS VDD VDD sky130_fd_sc_hd__decap_12
XTAP_TAPCELL_ROW_5_103 VSS VDD sky130_fd_sc_hd__tapvpwrvgnd_1
XFILLER_26_276 VSS VSS VDD VDD sky130_fd_sc_hd__decap_3
XFILLER_26_232 VSS VSS VDD VDD sky130_fd_sc_hd__decap_3
XFILLER_5_125 VSS VSS VDD VDD sky130_fd_sc_hd__decap_12
XFILLER_5_169 VSS VSS VDD VDD sky130_fd_sc_hd__decap_12
XTAP_TAPCELL_ROW_27_260 VSS VDD sky130_fd_sc_hd__tapvpwrvgnd_1
XFILLER_23_268 VSS VSS VDD VDD sky130_fd_sc_hd__decap_12
XFILLER_23_27 VSS VSS VDD VDD sky130_fd_sc_hd__decap_12
XFILLER_2_139 VSS VSS VDD VDD sky130_fd_sc_hd__fill_1
X_42_ _40_/Y _41_/X _68_/A VSS VSS VDD VDD _43_/A sky130_fd_sc_hd__a21boi_1
XFILLER_13_93 VSS VSS VDD VDD sky130_fd_sc_hd__decap_12
XFILLER_9_261 VSS VSS VDD VDD sky130_fd_sc_hd__decap_12
XFILLER_6_401 VSS VSS VDD VDD sky130_fd_sc_hd__decap_6
XTAP_TAPCELL_ROW_0_63 VSS VDD sky130_fd_sc_hd__tapvpwrvgnd_1
XFILLER_1_161 VSS VSS VDD VDD sky130_fd_sc_hd__decap_6
XTAP_TAPCELL_ROW_21_211 VSS VDD sky130_fd_sc_hd__tapvpwrvgnd_1
XFILLER_18_27 VSS VSS VDD VDD sky130_fd_sc_hd__fill_1
XFILLER_11_249 VSS VSS VDD VDD sky130_fd_sc_hd__decap_12
XFILLER_11_205 VSS VSS VDD VDD sky130_fd_sc_hd__decap_12
XFILLER_27_393 VSS VSS VDD VDD sky130_fd_sc_hd__fill_2
XFILLER_19_349 VSS VSS VDD VDD sky130_fd_sc_hd__decap_12
XFILLER_19_305 VSS VSS VDD VDD sky130_fd_sc_hd__decap_12
XFILLER_6_253 VSS VSS VDD VDD sky130_fd_sc_hd__decap_12
XFILLER_24_363 VSS VSS VDD VDD sky130_fd_sc_hd__fill_1
XFILLER_19_113 VSS VSS VDD VDD sky130_fd_sc_hd__decap_12
XFILLER_10_83 VSS VSS VDD VDD sky130_fd_sc_hd__fill_1
XFILLER_3_223 VSS VSS VDD VDD sky130_fd_sc_hd__fill_1
XFILLER_27_190 VSS VSS VDD VDD sky130_fd_sc_hd__decap_6
XFILLER_19_81 VSS VSS VDD VDD sky130_fd_sc_hd__decap_12
XFILLER_15_385 VSS VSS VDD VDD sky130_fd_sc_hd__decap_6
XFILLER_15_39 VSS VSS VDD VDD sky130_fd_sc_hd__decap_12
XFILLER_0_237 VSS VSS VDD VDD sky130_fd_sc_hd__decap_12
XFILLER_21_93 VSS VSS VDD VDD sky130_fd_sc_hd__decap_12
XTAP_TAPCELL_ROW_17_188 VSS VDD sky130_fd_sc_hd__tapvpwrvgnd_1
XFILLER_15_193 VSS VSS VDD VDD sky130_fd_sc_hd__decap_12
XFILLER_12_377 VSS VSS VDD VDD sky130_fd_sc_hd__decap_12
XFILLER_12_333 VSS VSS VDD VDD sky130_fd_sc_hd__decap_12
XFILLER_26_27 VSS VSS VDD VDD sky130_fd_sc_hd__fill_1
XPHY_EDGE_ROW_24_Right_24 VSS VSS VDD VDD sky130_fd_sc_hd__decap_3
XPHY_EDGE_ROW_15_Right_15 VSS VSS VDD VDD sky130_fd_sc_hd__decap_3
XFILLER_7_51 VSS VSS VDD VDD sky130_fd_sc_hd__decap_4
XFILLER_12_141 VSS VSS VDD VDD sky130_fd_sc_hd__decap_12
XTAP_TAPCELL_ROW_8_123 VSS VDD sky130_fd_sc_hd__tapvpwrvgnd_1
XFILLER_8_189 VSS VSS VDD VDD sky130_fd_sc_hd__decap_6
XTAP_TAPCELL_ROW_3_85 VSS VDD sky130_fd_sc_hd__tapvpwrvgnd_1
XFILLER_5_329 VSS VSS VDD VDD sky130_fd_sc_hd__decap_6
XPHY_EDGE_ROW_19_Left_47 VSS VSS VDD VDD sky130_fd_sc_hd__decap_3
XFILLER_12_29 VSS VSS VDD VDD sky130_fd_sc_hd__decap_12
XFILLER_5_137 VSS VSS VDD VDD sky130_fd_sc_hd__decap_12
XTAP_TAPCELL_ROW_5_104 VSS VDD sky130_fd_sc_hd__tapvpwrvgnd_1
XTAP_TAPCELL_ROW_27_261 VSS VDD sky130_fd_sc_hd__tapvpwrvgnd_1
XFILLER_27_70 VSS VSS VDD VDD sky130_fd_sc_hd__fill_1
XFILLER_4_41 VSS VSS VDD VDD sky130_fd_sc_hd__decap_12
XFILLER_4_85 VSS VSS VDD VDD sky130_fd_sc_hd__decap_12
XFILLER_23_225 VSS VSS VDD VDD sky130_fd_sc_hd__decap_12
XFILLER_23_39 VSS VSS VDD VDD sky130_fd_sc_hd__decap_12
X_41_ _77_/Q _41_/B _57_/B VSS VSS VDD VDD _41_/X sky130_fd_sc_hd__or3_1
XTAP_TAPCELL_ROW_24_231 VSS VDD sky130_fd_sc_hd__tapvpwrvgnd_1
XTAP_TAPCELL_ROW_0_64 VSS VDD sky130_fd_sc_hd__tapvpwrvgnd_1
XFILLER_11_217 VSS VSS VDD VDD sky130_fd_sc_hd__decap_6
XFILLER_9_273 VSS VSS VDD VDD sky130_fd_sc_hd__decap_6
XTAP_TAPCELL_ROW_21_212 VSS VDD sky130_fd_sc_hd__tapvpwrvgnd_1
XFILLER_19_317 VSS VSS VDD VDD sky130_fd_sc_hd__decap_12
XFILLER_3_405 VSS VSS VDD VDD sky130_fd_sc_hd__fill_2
XFILLER_20_29 VSS VSS VDD VDD sky130_fd_sc_hd__decap_12
XFILLER_6_265 VSS VSS VDD VDD sky130_fd_sc_hd__decap_12
XFILLER_6_221 VSS VSS VDD VDD sky130_fd_sc_hd__decap_12
XFILLER_16_309 VSS VSS VDD VDD sky130_fd_sc_hd__decap_12
XPHY_EDGE_ROW_7_Left_35 VSS VSS VDD VDD sky130_fd_sc_hd__decap_3
XFILLER_19_169 VSS VSS VDD VDD sky130_fd_sc_hd__decap_12
XFILLER_19_125 VSS VSS VDD VDD sky130_fd_sc_hd__decap_12
XFILLER_19_93 VSS VSS VDD VDD sky130_fd_sc_hd__decap_12
XFILLER_3_279 VSS VSS VDD VDD sky130_fd_sc_hd__fill_1
XFILLER_0_249 VSS VSS VDD VDD sky130_fd_sc_hd__decap_3
XFILLER_16_139 VSS VSS VDD VDD sky130_fd_sc_hd__fill_1
XFILLER_12_389 VSS VSS VDD VDD sky130_fd_sc_hd__decap_12
XFILLER_12_345 VSS VSS VDD VDD sky130_fd_sc_hd__decap_12
XFILLER_12_301 VSS VSS VDD VDD sky130_fd_sc_hd__decap_6
XFILLER_22_109 VSS VSS VDD VDD sky130_fd_sc_hd__decap_12
XFILLER_15_161 VSS VSS VDD VDD sky130_fd_sc_hd__decap_6
XFILLER_7_393 VSS VSS VDD VDD sky130_fd_sc_hd__decap_12
XFILLER_16_83 VSS VSS VDD VDD sky130_fd_sc_hd__fill_1
XFILLER_12_153 VSS VSS VDD VDD sky130_fd_sc_hd__decap_12
XTAP_TAPCELL_ROW_8_124 VSS VDD sky130_fd_sc_hd__tapvpwrvgnd_1
XFILLER_12_197 VSS VSS VDD VDD sky130_fd_sc_hd__decap_12
XTAP_TAPCELL_ROW_3_86 VSS VDD sky130_fd_sc_hd__tapvpwrvgnd_1
XFILLER_4_363 VSS VSS VDD VDD sky130_fd_sc_hd__fill_1
XFILLER_5_105 VSS VSS VDD VDD sky130_fd_sc_hd__decap_6
XFILLER_5_149 VSS VSS VDD VDD sky130_fd_sc_hd__decap_12
XTAP_TAPCELL_ROW_27_262 VSS VDD sky130_fd_sc_hd__tapvpwrvgnd_1
XPHY_EDGE_ROW_20_Left_48 VSS VSS VDD VDD sky130_fd_sc_hd__decap_3
XFILLER_17_223 VSS VSS VDD VDD sky130_fd_sc_hd__fill_1
XFILLER_23_237 VSS VSS VDD VDD sky130_fd_sc_hd__fill_1
XFILLER_23_215 VSS VSS VDD VDD sky130_fd_sc_hd__decap_8
XFILLER_4_53 VSS VSS VDD VDD sky130_fd_sc_hd__decap_12
XFILLER_4_97 VSS VSS VDD VDD sky130_fd_sc_hd__decap_12
X_40_ _41_/B _57_/B _77_/Q VSS VSS VDD VDD _40_/Y sky130_fd_sc_hd__o21ai_0
XTAP_TAPCELL_ROW_24_232 VSS VDD sky130_fd_sc_hd__tapvpwrvgnd_1
XFILLER_13_51 VSS VSS VDD VDD sky130_fd_sc_hd__decap_4
XTAP_TAPCELL_ROW_0_65 VSS VDD sky130_fd_sc_hd__tapvpwrvgnd_1
XFILLER_18_29 VSS VSS VDD VDD sky130_fd_sc_hd__decap_12
XFILLER_13_281 VSS VSS VDD VDD sky130_fd_sc_hd__decap_12
XTAP_TAPCELL_ROW_21_213 VSS VDD sky130_fd_sc_hd__tapvpwrvgnd_1
XFILLER_19_329 VSS VSS VDD VDD sky130_fd_sc_hd__decap_6
XFILLER_24_83 VSS VSS VDD VDD sky130_fd_sc_hd__fill_1
XPHY_EDGE_ROW_23_Left_51 VSS VSS VDD VDD sky130_fd_sc_hd__decap_3
XFILLER_10_251 VSS VSS VDD VDD sky130_fd_sc_hd__fill_1
XFILLER_6_277 VSS VSS VDD VDD sky130_fd_sc_hd__decap_12
XFILLER_6_233 VSS VSS VDD VDD sky130_fd_sc_hd__decap_12
XFILLER_24_365 VSS VSS VDD VDD sky130_fd_sc_hd__decap_12
XFILLER_24_321 VSS VSS VDD VDD sky130_fd_sc_hd__decap_12
XFILLER_19_137 VSS VSS VDD VDD sky130_fd_sc_hd__decap_12
XFILLER_10_85 VSS VSS VDD VDD sky130_fd_sc_hd__decap_12
XFILLER_10_41 VSS VSS VDD VDD sky130_fd_sc_hd__decap_12
XFILLER_3_225 VSS VSS VDD VDD sky130_fd_sc_hd__decap_12
XFILLER_25_129 VSS VSS VDD VDD sky130_fd_sc_hd__decap_12
XFILLER_25_3 VSS VSS VDD VDD sky130_fd_sc_hd__decap_12
XFILLER_21_335 VSS VSS VDD VDD sky130_fd_sc_hd__fill_1
XFILLER_21_51 VSS VSS VDD VDD sky130_fd_sc_hd__decap_4
XFILLER_12_357 VSS VSS VDD VDD sky130_fd_sc_hd__decap_6
XFILLER_7_361 VSS VSS VDD VDD sky130_fd_sc_hd__decap_12
XFILLER_17_405 VSS VSS VDD VDD sky130_fd_sc_hd__fill_2
XTAP_TAPCELL_ROW_8_125 VSS VDD sky130_fd_sc_hd__tapvpwrvgnd_1
XPHY_EDGE_ROW_5_Right_5 VSS VSS VDD VDD sky130_fd_sc_hd__decap_3
XFILLER_12_165 VSS VSS VDD VDD sky130_fd_sc_hd__decap_12
XFILLER_12_121 VSS VSS VDD VDD sky130_fd_sc_hd__decap_12
XTAP_TAPCELL_ROW_3_87 VSS VDD sky130_fd_sc_hd__tapvpwrvgnd_1
XFILLER_26_268 VSS VSS VDD VDD sky130_fd_sc_hd__decap_8
XFILLER_26_246 VSS VSS VDD VDD sky130_fd_sc_hd__decap_6
XTAP_TAPCELL_ROW_13_160 VSS VDD sky130_fd_sc_hd__tapvpwrvgnd_1
XTAP_TAPCELL_ROW_27_263 VSS VDD sky130_fd_sc_hd__tapvpwrvgnd_1
XFILLER_27_83 VSS VSS VDD VDD sky130_fd_sc_hd__fill_1
XTAP_TAPCELL_ROW_27_252 VSS VDD sky130_fd_sc_hd__tapvpwrvgnd_1
XFILLER_17_279 VSS VSS VDD VDD sky130_fd_sc_hd__fill_1
XFILLER_23_205 VSS VSS VDD VDD sky130_fd_sc_hd__decap_4
XFILLER_2_109 VSS VSS VDD VDD sky130_fd_sc_hd__decap_12
XFILLER_4_65 VSS VSS VDD VDD sky130_fd_sc_hd__decap_12
XTAP_TAPCELL_ROW_24_233 VSS VDD sky130_fd_sc_hd__tapvpwrvgnd_1
XFILLER_13_293 VSS VSS VDD VDD sky130_fd_sc_hd__decap_12
XTAP_TAPCELL_ROW_0_66 VSS VDD sky130_fd_sc_hd__tapvpwrvgnd_1
XTAP_TAPCELL_ROW_21_214 VSS VDD sky130_fd_sc_hd__tapvpwrvgnd_1
XFILLER_27_363 VSS VSS VDD VDD sky130_fd_sc_hd__fill_1
XFILLER_18_363 VSS VSS VDD VDD sky130_fd_sc_hd__fill_1
XFILLER_6_289 VSS VSS VDD VDD sky130_fd_sc_hd__decap_12
XFILLER_6_245 VSS VSS VDD VDD sky130_fd_sc_hd__decap_6
XFILLER_1_55 VSS VSS VDD VDD sky130_fd_sc_hd__fill_1
XFILLER_24_377 VSS VSS VDD VDD sky130_fd_sc_hd__decap_12
XFILLER_24_333 VSS VSS VDD VDD sky130_fd_sc_hd__decap_12
XFILLER_19_149 VSS VSS VDD VDD sky130_fd_sc_hd__decap_12
XFILLER_19_105 VSS VSS VDD VDD sky130_fd_sc_hd__decap_6
XFILLER_19_51 VSS VSS VDD VDD sky130_fd_sc_hd__decap_4
XFILLER_10_97 VSS VSS VDD VDD sky130_fd_sc_hd__decap_12
XFILLER_10_53 VSS VSS VDD VDD sky130_fd_sc_hd__decap_12
XFILLER_3_237 VSS VSS VDD VDD sky130_fd_sc_hd__decap_12
XFILLER_18_3 VSS VSS VDD VDD sky130_fd_sc_hd__decap_12
XFILLER_24_141 VSS VSS VDD VDD sky130_fd_sc_hd__decap_12
XFILLER_8_307 VSS VSS VDD VDD sky130_fd_sc_hd__fill_1
XFILLER_11_391 VSS VSS VDD VDD sky130_fd_sc_hd__fill_1
XFILLER_7_373 VSS VSS VDD VDD sky130_fd_sc_hd__decap_12
Xclkbuf_1_1__f_clock_i clkbuf_0_clock_i/X VSS VSS VDD VDD _77_/CLK sky130_fd_sc_hd__clkbuf_16
XFILLER_21_111 VSS VSS VDD VDD sky130_fd_sc_hd__fill_1
XTAP_TAPCELL_ROW_16_180 VSS VDD sky130_fd_sc_hd__tapvpwrvgnd_1
XPHY_EDGE_ROW_20_Right_20 VSS VSS VDD VDD sky130_fd_sc_hd__decap_3
XFILLER_16_85 VSS VSS VDD VDD sky130_fd_sc_hd__decap_12
XFILLER_16_41 VSS VSS VDD VDD sky130_fd_sc_hd__decap_12
XFILLER_12_177 VSS VSS VDD VDD sky130_fd_sc_hd__decap_12
XFILLER_12_133 VSS VSS VDD VDD sky130_fd_sc_hd__decap_6
XPHY_EDGE_ROW_11_Right_11 VSS VSS VDD VDD sky130_fd_sc_hd__decap_3
XTAP_TAPCELL_ROW_3_88 VSS VDD sky130_fd_sc_hd__tapvpwrvgnd_1
XFILLER_4_321 VSS VSS VDD VDD sky130_fd_sc_hd__decap_12
XFILLER_4_365 VSS VSS VDD VDD sky130_fd_sc_hd__decap_12
XFILLER_7_181 VSS VSS VDD VDD sky130_fd_sc_hd__decap_12
XTAP_TAPCELL_ROW_27_264 VSS VDD sky130_fd_sc_hd__tapvpwrvgnd_1
XTAP_TAPCELL_ROW_27_253 VSS VDD sky130_fd_sc_hd__tapvpwrvgnd_1
XFILLER_17_225 VSS VSS VDD VDD sky130_fd_sc_hd__decap_12
XFILLER_1_335 VSS VSS VDD VDD sky130_fd_sc_hd__fill_1
XFILLER_4_77 VSS VSS VDD VDD sky130_fd_sc_hd__decap_6
XFILLER_4_195 VSS VSS VDD VDD sky130_fd_sc_hd__fill_1
XTAP_TAPCELL_ROW_24_234 VSS VDD sky130_fd_sc_hd__tapvpwrvgnd_1
XFILLER_10_401 VSS VSS VDD VDD sky130_fd_sc_hd__decap_6
XFILLER_20_209 VSS VSS VDD VDD sky130_fd_sc_hd__decap_12
XFILLER_13_261 VSS VSS VDD VDD sky130_fd_sc_hd__decap_12
XTAP_TAPCELL_ROW_0_67 VSS VDD sky130_fd_sc_hd__tapvpwrvgnd_1
XTAP_TAPCELL_ROW_0_56 VSS VDD sky130_fd_sc_hd__tapvpwrvgnd_1
XTAP_TAPCELL_ROW_21_215 VSS VDD sky130_fd_sc_hd__tapvpwrvgnd_1
XFILLER_24_85 VSS VSS VDD VDD sky130_fd_sc_hd__decap_12
XFILLER_24_41 VSS VSS VDD VDD sky130_fd_sc_hd__decap_12
XFILLER_10_253 VSS VSS VDD VDD sky130_fd_sc_hd__decap_12
XFILLER_27_183 VSS VSS VDD VDD sky130_fd_sc_hd__fill_2
XFILLER_24_389 VSS VSS VDD VDD sky130_fd_sc_hd__decap_12
XFILLER_24_345 VSS VSS VDD VDD sky130_fd_sc_hd__decap_12
XFILLER_10_65 VSS VSS VDD VDD sky130_fd_sc_hd__decap_12
XFILLER_3_205 VSS VSS VDD VDD sky130_fd_sc_hd__decap_12
XFILLER_3_249 VSS VSS VDD VDD sky130_fd_sc_hd__decap_12
XFILLER_25_109 VSS VSS VDD VDD sky130_fd_sc_hd__decap_3
XFILLER_21_337 VSS VSS VDD VDD sky130_fd_sc_hd__decap_12
XFILLER_24_197 VSS VSS VDD VDD sky130_fd_sc_hd__decap_12
XFILLER_24_153 VSS VSS VDD VDD sky130_fd_sc_hd__decap_12
XFILLER_16_109 VSS VSS VDD VDD sky130_fd_sc_hd__decap_12
XFILLER_7_55 VSS VSS VDD VDD sky130_fd_sc_hd__fill_1
XFILLER_21_167 VSS VSS VDD VDD sky130_fd_sc_hd__fill_1
XTAP_TAPCELL_ROW_16_181 VSS VDD sky130_fd_sc_hd__tapvpwrvgnd_1
XFILLER_7_385 VSS VSS VDD VDD sky130_fd_sc_hd__decap_6
XFILLER_16_97 VSS VSS VDD VDD sky130_fd_sc_hd__decap_12
XFILLER_16_53 VSS VSS VDD VDD sky130_fd_sc_hd__decap_12
XFILLER_12_189 VSS VSS VDD VDD sky130_fd_sc_hd__decap_6
XTAP_TAPCELL_ROW_3_89 VSS VDD sky130_fd_sc_hd__tapvpwrvgnd_1
XFILLER_4_333 VSS VSS VDD VDD sky130_fd_sc_hd__decap_12
XFILLER_4_377 VSS VSS VDD VDD sky130_fd_sc_hd__decap_12
XFILLER_7_193 VSS VSS VDD VDD sky130_fd_sc_hd__decap_12
XFILLER_27_41 VSS VSS VDD VDD sky130_fd_sc_hd__decap_12
XFILLER_17_237 VSS VSS VDD VDD sky130_fd_sc_hd__decap_12
XTAP_TAPCELL_ROW_27_265 VSS VDD sky130_fd_sc_hd__tapvpwrvgnd_1
XTAP_TAPCELL_ROW_27_254 VSS VDD sky130_fd_sc_hd__tapvpwrvgnd_1
XFILLER_27_85 VSS VSS VDD VDD sky130_fd_sc_hd__decap_12
XFILLER_25_281 VSS VSS VDD VDD sky130_fd_sc_hd__decap_3
XFILLER_4_141 VSS VSS VDD VDD sky130_fd_sc_hd__decap_12
XTAP_TAPCELL_ROW_24_235 VSS VDD sky130_fd_sc_hd__tapvpwrvgnd_1
XFILLER_22_251 VSS VSS VDD VDD sky130_fd_sc_hd__fill_1
XFILLER_13_273 VSS VSS VDD VDD sky130_fd_sc_hd__decap_6
XFILLER_8_3 VSS VSS VDD VDD sky130_fd_sc_hd__decap_12
XFILLER_1_111 VSS VSS VDD VDD sky130_fd_sc_hd__fill_1
XTAP_TAPCELL_ROW_0_57 VSS VDD sky130_fd_sc_hd__tapvpwrvgnd_1
XTAP_TAPCELL_ROW_0_68 VSS VDD sky130_fd_sc_hd__tapvpwrvgnd_1
XTAP_TAPCELL_ROW_21_216 VSS VDD sky130_fd_sc_hd__tapvpwrvgnd_1
XFILLER_27_365 VSS VSS VDD VDD sky130_fd_sc_hd__decap_12
XFILLER_27_321 VSS VSS VDD VDD sky130_fd_sc_hd__decap_12
XFILLER_24_97 VSS VSS VDD VDD sky130_fd_sc_hd__decap_12
XFILLER_24_53 VSS VSS VDD VDD sky130_fd_sc_hd__decap_12
XFILLER_10_265 VSS VSS VDD VDD sky130_fd_sc_hd__decap_12
XFILLER_10_221 VSS VSS VDD VDD sky130_fd_sc_hd__decap_12
XFILLER_18_365 VSS VSS VDD VDD sky130_fd_sc_hd__decap_12
XFILLER_18_321 VSS VSS VDD VDD sky130_fd_sc_hd__decap_12
XFILLER_1_57 VSS VSS VDD VDD sky130_fd_sc_hd__decap_12
XFILLER_24_357 VSS VSS VDD VDD sky130_fd_sc_hd__decap_6
XFILLER_10_77 VSS VSS VDD VDD sky130_fd_sc_hd__decap_6
Xinput1 enable_i VSS VSS VDD VDD _66_/A sky130_fd_sc_hd__buf_2
XFILLER_3_217 VSS VSS VDD VDD sky130_fd_sc_hd__decap_6
XPHY_EDGE_ROW_27_Left_55 VSS VSS VDD VDD sky130_fd_sc_hd__decap_3
XFILLER_15_335 VSS VSS VDD VDD sky130_fd_sc_hd__fill_1
XPHY_EDGE_ROW_11_Left_39 VSS VSS VDD VDD sky130_fd_sc_hd__decap_3
XFILLER_24_121 VSS VSS VDD VDD sky130_fd_sc_hd__decap_12
XFILLER_21_349 VSS VSS VDD VDD sky130_fd_sc_hd__decap_12
XFILLER_21_305 VSS VSS VDD VDD sky130_fd_sc_hd__decap_12
XFILLER_18_195 VSS VSS VDD VDD sky130_fd_sc_hd__fill_1
XFILLER_0_209 VSS VSS VDD VDD sky130_fd_sc_hd__decap_12
XFILLER_24_165 VSS VSS VDD VDD sky130_fd_sc_hd__decap_12
XFILLER_8_309 VSS VSS VDD VDD sky130_fd_sc_hd__decap_12
XFILLER_23_3 VSS VSS VDD VDD sky130_fd_sc_hd__decap_12
XFILLER_21_113 VSS VSS VDD VDD sky130_fd_sc_hd__decap_12
XFILLER_11_393 VSS VSS VDD VDD sky130_fd_sc_hd__decap_12
XFILLER_16_65 VSS VSS VDD VDD sky130_fd_sc_hd__decap_12
XFILLER_8_139 VSS VSS VDD VDD sky130_fd_sc_hd__fill_1
XFILLER_4_301 VSS VSS VDD VDD sky130_fd_sc_hd__decap_6
XPHY_EDGE_ROW_9_Right_9 VSS VSS VDD VDD sky130_fd_sc_hd__decap_3
XFILLER_4_345 VSS VSS VDD VDD sky130_fd_sc_hd__decap_12
XFILLER_4_389 VSS VSS VDD VDD sky130_fd_sc_hd__decap_12
XFILLER_7_161 VSS VSS VDD VDD sky130_fd_sc_hd__decap_6
XFILLER_26_227 VSS VSS VDD VDD sky130_fd_sc_hd__fill_1
XPHY_EDGE_ROW_14_Left_42 VSS VSS VDD VDD sky130_fd_sc_hd__decap_3
XFILLER_1_337 VSS VSS VDD VDD sky130_fd_sc_hd__decap_12
XTAP_TAPCELL_ROW_27_255 VSS VDD sky130_fd_sc_hd__tapvpwrvgnd_1
XFILLER_27_97 VSS VSS VDD VDD sky130_fd_sc_hd__decap_12
XFILLER_27_75 VSS VSS VDD VDD sky130_fd_sc_hd__decap_8
XFILLER_27_53 VSS VSS VDD VDD sky130_fd_sc_hd__decap_3
XFILLER_17_249 VSS VSS VDD VDD sky130_fd_sc_hd__decap_12
XFILLER_17_205 VSS VSS VDD VDD sky130_fd_sc_hd__decap_12
XTAP_TAPCELL_ROW_10_133 VSS VDD sky130_fd_sc_hd__tapvpwrvgnd_1
XFILLER_4_153 VSS VSS VDD VDD sky130_fd_sc_hd__decap_12
XFILLER_4_197 VSS VSS VDD VDD sky130_fd_sc_hd__decap_12
XTAP_TAPCELL_ROW_24_236 VSS VDD sky130_fd_sc_hd__tapvpwrvgnd_1
XFILLER_13_55 VSS VSS VDD VDD sky130_fd_sc_hd__fill_1
XFILLER_1_167 VSS VSS VDD VDD sky130_fd_sc_hd__fill_1
XTAP_TAPCELL_ROW_0_58 VSS VDD sky130_fd_sc_hd__tapvpwrvgnd_1
XTAP_TAPCELL_ROW_0_69 VSS VDD sky130_fd_sc_hd__tapvpwrvgnd_1
XFILLER_9_223 VSS VSS VDD VDD sky130_fd_sc_hd__fill_1
XFILLER_27_399 VSS VSS VDD VDD sky130_fd_sc_hd__decap_8
XFILLER_27_377 VSS VSS VDD VDD sky130_fd_sc_hd__decap_12
XFILLER_27_333 VSS VSS VDD VDD sky130_fd_sc_hd__decap_3
XFILLER_24_65 VSS VSS VDD VDD sky130_fd_sc_hd__decap_12
XFILLER_10_277 VSS VSS VDD VDD sky130_fd_sc_hd__decap_12
XFILLER_10_233 VSS VSS VDD VDD sky130_fd_sc_hd__decap_12
XFILLER_18_377 VSS VSS VDD VDD sky130_fd_sc_hd__decap_12
XFILLER_18_333 VSS VSS VDD VDD sky130_fd_sc_hd__decap_12
XFILLER_1_69 VSS VSS VDD VDD sky130_fd_sc_hd__decap_12
Xinput2 reset_n_i VSS VSS VDD VDD _68_/A sky130_fd_sc_hd__buf_2
XFILLER_5_281 VSS VSS VDD VDD sky130_fd_sc_hd__decap_12
XFILLER_27_141 VSS VSS VDD VDD sky130_fd_sc_hd__decap_12
XFILLER_23_391 VSS VSS VDD VDD sky130_fd_sc_hd__fill_1
XPHY_EDGE_ROW_2_Left_30 VSS VSS VDD VDD sky130_fd_sc_hd__decap_3
XFILLER_2_251 VSS VSS VDD VDD sky130_fd_sc_hd__fill_1
XFILLER_21_317 VSS VSS VDD VDD sky130_fd_sc_hd__decap_12
XFILLER_18_141 VSS VSS VDD VDD sky130_fd_sc_hd__decap_12
XFILLER_24_177 VSS VSS VDD VDD sky130_fd_sc_hd__decap_6
XFILLER_24_133 VSS VSS VDD VDD sky130_fd_sc_hd__decap_6
XFILLER_21_55 VSS VSS VDD VDD sky130_fd_sc_hd__fill_1
XFILLER_16_3 VSS VSS VDD VDD sky130_fd_sc_hd__decap_12
XFILLER_15_111 VSS VSS VDD VDD sky130_fd_sc_hd__fill_1
XFILLER_11_361 VSS VSS VDD VDD sky130_fd_sc_hd__decap_12
XFILLER_7_57 VSS VSS VDD VDD sky130_fd_sc_hd__decap_12
XFILLER_21_169 VSS VSS VDD VDD sky130_fd_sc_hd__decap_12
XFILLER_21_125 VSS VSS VDD VDD sky130_fd_sc_hd__decap_12
XFILLER_16_77 VSS VSS VDD VDD sky130_fd_sc_hd__decap_6
XFILLER_4_357 VSS VSS VDD VDD sky130_fd_sc_hd__decap_6
XFILLER_22_401 VSS VSS VDD VDD sky130_fd_sc_hd__decap_6
XTAP_TAPCELL_ROW_27_256 VSS VDD sky130_fd_sc_hd__tapvpwrvgnd_1
XFILLER_27_21 VSS VSS VDD VDD sky130_fd_sc_hd__decap_6
XFILLER_17_217 VSS VSS VDD VDD sky130_fd_sc_hd__decap_6
XTAP_TAPCELL_ROW_10_134 VSS VDD sky130_fd_sc_hd__tapvpwrvgnd_1
XFILLER_9_405 VSS VSS VDD VDD sky130_fd_sc_hd__fill_2
XFILLER_1_349 VSS VSS VDD VDD sky130_fd_sc_hd__decap_12
XFILLER_1_305 VSS VSS VDD VDD sky130_fd_sc_hd__decap_12
XFILLER_4_121 VSS VSS VDD VDD sky130_fd_sc_hd__decap_12
XFILLER_4_165 VSS VSS VDD VDD sky130_fd_sc_hd__decap_12
Xclkbuf_1_0__f_clock_i clkbuf_0_clock_i/X VSS VSS VDD VDD _76_/CLK sky130_fd_sc_hd__clkbuf_16
XFILLER_0_393 VSS VSS VDD VDD sky130_fd_sc_hd__decap_12
XTAP_TAPCELL_ROW_24_237 VSS VDD sky130_fd_sc_hd__tapvpwrvgnd_1
XFILLER_22_253 VSS VSS VDD VDD sky130_fd_sc_hd__decap_12
XFILLER_14_209 VSS VSS VDD VDD sky130_fd_sc_hd__decap_12
XTAP_TAPCELL_ROW_0_59 VSS VDD sky130_fd_sc_hd__tapvpwrvgnd_1
XFILLER_1_113 VSS VSS VDD VDD sky130_fd_sc_hd__decap_12
XFILLER_9_279 VSS VSS VDD VDD sky130_fd_sc_hd__fill_1
XFILLER_27_389 VSS VSS VDD VDD sky130_fd_sc_hd__decap_3
XFILLER_27_345 VSS VSS VDD VDD sky130_fd_sc_hd__decap_12
XFILLER_24_77 VSS VSS VDD VDD sky130_fd_sc_hd__decap_6
XFILLER_18_389 VSS VSS VDD VDD sky130_fd_sc_hd__decap_12
XFILLER_18_345 VSS VSS VDD VDD sky130_fd_sc_hd__decap_12
XFILLER_18_301 VSS VSS VDD VDD sky130_fd_sc_hd__decap_6
XFILLER_10_289 VSS VSS VDD VDD sky130_fd_sc_hd__decap_12
XFILLER_10_245 VSS VSS VDD VDD sky130_fd_sc_hd__decap_6
XFILLER_1_15 VSS VSS VDD VDD sky130_fd_sc_hd__decap_12
XPHY_EDGE_ROW_27_Right_27 VSS VSS VDD VDD sky130_fd_sc_hd__decap_3
XPHY_EDGE_ROW_18_Right_18 VSS VSS VDD VDD sky130_fd_sc_hd__decap_3
XFILLER_5_293 VSS VSS VDD VDD sky130_fd_sc_hd__decap_12
XFILLER_27_197 VSS VSS VDD VDD sky130_fd_sc_hd__decap_12
XFILLER_27_153 VSS VSS VDD VDD sky130_fd_sc_hd__decap_12
XFILLER_19_55 VSS VSS VDD VDD sky130_fd_sc_hd__fill_1
XFILLER_15_337 VSS VSS VDD VDD sky130_fd_sc_hd__decap_12
XFILLER_21_329 VSS VSS VDD VDD sky130_fd_sc_hd__decap_6
XFILLER_18_197 VSS VSS VDD VDD sky130_fd_sc_hd__decap_12
XFILLER_18_153 VSS VSS VDD VDD sky130_fd_sc_hd__decap_12
XFILLER_12_307 VSS VSS VDD VDD sky130_fd_sc_hd__fill_1
XFILLER_15_167 VSS VSS VDD VDD sky130_fd_sc_hd__fill_1
XFILLER_11_373 VSS VSS VDD VDD sky130_fd_sc_hd__decap_12
XFILLER_7_69 VSS VSS VDD VDD sky130_fd_sc_hd__decap_12
XFILLER_21_137 VSS VSS VDD VDD sky130_fd_sc_hd__decap_12
XTAP_TAPCELL_ROW_8_119 VSS VDD sky130_fd_sc_hd__tapvpwrvgnd_1
XPHY_EDGE_ROW_0_Right_0 VSS VSS VDD VDD sky130_fd_sc_hd__decap_3
XFILLER_19_281 VSS VSS VDD VDD sky130_fd_sc_hd__decap_12
XTAP_TAPCELL_ROW_13_154 VSS VDD sky130_fd_sc_hd__tapvpwrvgnd_1
XFILLER_11_181 VSS VSS VDD VDD sky130_fd_sc_hd__decap_12
XFILLER_3_391 VSS VSS VDD VDD sky130_fd_sc_hd__fill_1
XTAP_TAPCELL_ROW_27_257 VSS VDD sky130_fd_sc_hd__tapvpwrvgnd_1
XFILLER_27_66 VSS VSS VDD VDD sky130_fd_sc_hd__decap_4
XTAP_TAPCELL_ROW_10_135 VSS VDD sky130_fd_sc_hd__tapvpwrvgnd_1
XFILLER_1_317 VSS VSS VDD VDD sky130_fd_sc_hd__decap_12
XFILLER_16_251 VSS VSS VDD VDD sky130_fd_sc_hd__fill_1
XFILLER_0_361 VSS VSS VDD VDD sky130_fd_sc_hd__decap_3
XFILLER_4_15 VSS VSS VDD VDD sky130_fd_sc_hd__decap_12
XTAP_TAPCELL_ROW_4_91 VSS VDD sky130_fd_sc_hd__tapvpwrvgnd_1
XFILLER_4_133 VSS VSS VDD VDD sky130_fd_sc_hd__decap_6
XFILLER_4_177 VSS VSS VDD VDD sky130_fd_sc_hd__decap_12
XFILLER_22_265 VSS VSS VDD VDD sky130_fd_sc_hd__decap_12
XFILLER_22_221 VSS VSS VDD VDD sky130_fd_sc_hd__decap_12
XFILLER_13_57 VSS VSS VDD VDD sky130_fd_sc_hd__decap_12
XFILLER_1_125 VSS VSS VDD VDD sky130_fd_sc_hd__decap_12
XFILLER_9_225 VSS VSS VDD VDD sky130_fd_sc_hd__decap_12
XFILLER_1_169 VSS VSS VDD VDD sky130_fd_sc_hd__decap_12
XFILLER_27_357 VSS VSS VDD VDD sky130_fd_sc_hd__decap_6
XFILLER_18_357 VSS VSS VDD VDD sky130_fd_sc_hd__decap_6
XFILLER_1_27 VSS VSS VDD VDD sky130_fd_sc_hd__decap_12
XFILLER_2_401 VSS VSS VDD VDD sky130_fd_sc_hd__decap_6
XFILLER_6_3 VSS VSS VDD VDD sky130_fd_sc_hd__decap_12
X_77_ _77_/CLK _77_/D VSS VSS VDD VDD _77_/Q sky130_fd_sc_hd__dfxtp_1
XTAP_TAPCELL_ROW_1_70 VSS VDD sky130_fd_sc_hd__tapvpwrvgnd_1
XFILLER_5_261 VSS VSS VDD VDD sky130_fd_sc_hd__decap_12
XFILLER_27_165 VSS VSS VDD VDD sky130_fd_sc_hd__decap_3
XFILLER_23_393 VSS VSS VDD VDD sky130_fd_sc_hd__decap_12
XFILLER_15_349 VSS VSS VDD VDD sky130_fd_sc_hd__decap_12
XFILLER_15_305 VSS VSS VDD VDD sky130_fd_sc_hd__decap_12
XFILLER_18_165 VSS VSS VDD VDD sky130_fd_sc_hd__decap_12
XFILLER_18_121 VSS VSS VDD VDD sky130_fd_sc_hd__decap_12
XFILLER_2_253 VSS VSS VDD VDD sky130_fd_sc_hd__decap_12
XFILLER_21_57 VSS VSS VDD VDD sky130_fd_sc_hd__decap_12
XFILLER_20_363 VSS VSS VDD VDD sky130_fd_sc_hd__fill_1
XFILLER_15_113 VSS VSS VDD VDD sky130_fd_sc_hd__decap_12
XFILLER_11_385 VSS VSS VDD VDD sky130_fd_sc_hd__decap_6
XFILLER_7_15 VSS VSS VDD VDD sky130_fd_sc_hd__decap_12
XFILLER_21_149 VSS VSS VDD VDD sky130_fd_sc_hd__decap_12
XFILLER_21_105 VSS VSS VDD VDD sky130_fd_sc_hd__decap_6
XFILLER_8_109 VSS VSS VDD VDD sky130_fd_sc_hd__decap_12
XFILLER_26_219 VSS VSS VDD VDD sky130_fd_sc_hd__decap_8
XFILLER_21_3 VSS VSS VDD VDD sky130_fd_sc_hd__decap_12
XFILLER_19_293 VSS VSS VDD VDD sky130_fd_sc_hd__decap_12
XTAP_TAPCELL_ROW_13_155 VSS VDD sky130_fd_sc_hd__tapvpwrvgnd_1
XFILLER_11_193 VSS VSS VDD VDD sky130_fd_sc_hd__decap_12
XTAP_TAPCELL_ROW_27_258 VSS VDD sky130_fd_sc_hd__tapvpwrvgnd_1
XFILLER_1_329 VSS VSS VDD VDD sky130_fd_sc_hd__decap_6
XTAP_TAPCELL_ROW_10_136 VSS VDD sky130_fd_sc_hd__tapvpwrvgnd_1
XFILLER_4_27 VSS VSS VDD VDD sky130_fd_sc_hd__fill_1
XFILLER_4_189 VSS VSS VDD VDD sky130_fd_sc_hd__decap_6
XFILLER_22_277 VSS VSS VDD VDD sky130_fd_sc_hd__decap_12
XFILLER_22_233 VSS VSS VDD VDD sky130_fd_sc_hd__decap_12
XPHY_EDGE_ROW_18_Left_46 VSS VSS VDD VDD sky130_fd_sc_hd__decap_3
XFILLER_13_69 VSS VSS VDD VDD sky130_fd_sc_hd__decap_12
XTAP_TAPCELL_ROW_4_92 VSS VDD sky130_fd_sc_hd__tapvpwrvgnd_1
XFILLER_9_237 VSS VSS VDD VDD sky130_fd_sc_hd__decap_12
XFILLER_1_137 VSS VSS VDD VDD sky130_fd_sc_hd__decap_12
XFILLER_0_181 VSS VSS VDD VDD sky130_fd_sc_hd__decap_12
XFILLER_5_81 VSS VSS VDD VDD sky130_fd_sc_hd__decap_12
X_76_ _76_/CLK _76_/D VSS VSS VDD VDD _76_/Q sky130_fd_sc_hd__dfxtp_1
XTAP_TAPCELL_ROW_1_71 VSS VDD sky130_fd_sc_hd__tapvpwrvgnd_1
XFILLER_1_39 VSS VSS VDD VDD sky130_fd_sc_hd__decap_12
XFILLER_5_273 VSS VSS VDD VDD sky130_fd_sc_hd__decap_6
XFILLER_27_177 VSS VSS VDD VDD sky130_fd_sc_hd__fill_2
XFILLER_19_57 VSS VSS VDD VDD sky130_fd_sc_hd__decap_12
XFILLER_17_391 VSS VSS VDD VDD sky130_fd_sc_hd__fill_1
XFILLER_15_317 VSS VSS VDD VDD sky130_fd_sc_hd__decap_12
XFILLER_10_15 VSS VSS VDD VDD sky130_fd_sc_hd__decap_12
XFILLER_23_361 VSS VSS VDD VDD sky130_fd_sc_hd__decap_12
XFILLER_18_177 VSS VSS VDD VDD sky130_fd_sc_hd__decap_12
XFILLER_18_133 VSS VSS VDD VDD sky130_fd_sc_hd__decap_6
XFILLER_2_221 VSS VSS VDD VDD sky130_fd_sc_hd__decap_12
XFILLER_2_265 VSS VSS VDD VDD sky130_fd_sc_hd__decap_12
X_59_ _66_/A _73_/Q VSS VSS VDD VDD _60_/B sky130_fd_sc_hd__xor2_1
XFILLER_12_309 VSS VSS VDD VDD sky130_fd_sc_hd__decap_12
XFILLER_21_69 VSS VSS VDD VDD sky130_fd_sc_hd__decap_12
XFILLER_15_169 VSS VSS VDD VDD sky130_fd_sc_hd__decap_12
XFILLER_15_125 VSS VSS VDD VDD sky130_fd_sc_hd__decap_12
XFILLER_7_335 VSS VSS VDD VDD sky130_fd_sc_hd__fill_1
XPHY_EDGE_ROW_6_Left_34 VSS VSS VDD VDD sky130_fd_sc_hd__decap_3
XFILLER_7_27 VSS VSS VDD VDD sky130_fd_sc_hd__decap_12
XTAP_TAPCELL_ROW_16_175 VSS VDD sky130_fd_sc_hd__tapvpwrvgnd_1
XFILLER_12_139 VSS VSS VDD VDD sky130_fd_sc_hd__fill_1
XFILLER_16_401 VSS VSS VDD VDD sky130_fd_sc_hd__decap_6
XTAP_TAPCELL_ROW_13_156 VSS VDD sky130_fd_sc_hd__tapvpwrvgnd_1
XFILLER_11_161 VSS VSS VDD VDD sky130_fd_sc_hd__decap_6
XFILLER_3_393 VSS VSS VDD VDD sky130_fd_sc_hd__decap_12
XFILLER_27_57 VSS VSS VDD VDD sky130_fd_sc_hd__decap_3
XFILLER_19_261 VSS VSS VDD VDD sky130_fd_sc_hd__decap_12
XTAP_TAPCELL_ROW_27_259 VSS VDD sky130_fd_sc_hd__tapvpwrvgnd_1
XFILLER_16_253 VSS VSS VDD VDD sky130_fd_sc_hd__decap_12
XTAP_TAPCELL_ROW_10_137 VSS VDD sky130_fd_sc_hd__tapvpwrvgnd_1
XFILLER_22_245 VSS VSS VDD VDD sky130_fd_sc_hd__decap_6
XFILLER_13_15 VSS VSS VDD VDD sky130_fd_sc_hd__decap_12
XTAP_TAPCELL_ROW_4_93 VSS VDD sky130_fd_sc_hd__tapvpwrvgnd_1
XFILLER_22_289 VSS VSS VDD VDD sky130_fd_sc_hd__decap_12
XFILLER_13_223 VSS VSS VDD VDD sky130_fd_sc_hd__fill_1
XFILLER_9_249 VSS VSS VDD VDD sky130_fd_sc_hd__decap_12
XFILLER_9_205 VSS VSS VDD VDD sky130_fd_sc_hd__decap_12
XFILLER_1_149 VSS VSS VDD VDD sky130_fd_sc_hd__decap_12
XFILLER_1_105 VSS VSS VDD VDD sky130_fd_sc_hd__decap_6
XFILLER_0_193 VSS VSS VDD VDD sky130_fd_sc_hd__decap_3
XFILLER_27_337 VSS VSS VDD VDD sky130_fd_sc_hd__decap_4
XFILLER_27_304 VSS VSS VDD VDD sky130_fd_sc_hd__decap_4
XFILLER_5_93 VSS VSS VDD VDD sky130_fd_sc_hd__decap_12
XTAP_TAPCELL_ROW_1_72 VSS VDD sky130_fd_sc_hd__tapvpwrvgnd_1
X_75_ _76_/CLK _75_/D VSS VSS VDD VDD _75_/Q sky130_fd_sc_hd__dfxtp_1
XFILLER_19_69 VSS VSS VDD VDD sky130_fd_sc_hd__decap_12
XFILLER_10_27 VSS VSS VDD VDD sky130_fd_sc_hd__fill_1
XPHY_EDGE_ROW_23_Right_23 VSS VSS VDD VDD sky130_fd_sc_hd__decap_3
XFILLER_23_373 VSS VSS VDD VDD sky130_fd_sc_hd__decap_12
XFILLER_15_329 VSS VSS VDD VDD sky130_fd_sc_hd__decap_6
XPHY_EDGE_ROW_14_Right_14 VSS VSS VDD VDD sky130_fd_sc_hd__decap_3
XFILLER_2_233 VSS VSS VDD VDD sky130_fd_sc_hd__decap_12
XFILLER_2_277 VSS VSS VDD VDD sky130_fd_sc_hd__decap_12
X_58_ _54_/Y _55_/Y _58_/S VSS VSS VDD VDD _58_/Y sky130_fd_sc_hd__mux2i_2
XPHY_EDGE_ROW_22_Left_50 VSS VSS VDD VDD sky130_fd_sc_hd__decap_3
XFILLER_18_189 VSS VSS VDD VDD sky130_fd_sc_hd__decap_6
XFILLER_2_83 VSS VSS VDD VDD sky130_fd_sc_hd__fill_1
XFILLER_23_181 VSS VSS VDD VDD sky130_fd_sc_hd__decap_12
XFILLER_21_15 VSS VSS VDD VDD sky130_fd_sc_hd__decap_12
XFILLER_20_365 VSS VSS VDD VDD sky130_fd_sc_hd__decap_12
XFILLER_20_321 VSS VSS VDD VDD sky130_fd_sc_hd__decap_12
XFILLER_15_137 VSS VSS VDD VDD sky130_fd_sc_hd__decap_12
XTAP_TAPCELL_ROW_16_176 VSS VDD sky130_fd_sc_hd__tapvpwrvgnd_1
XFILLER_11_81 VSS VSS VDD VDD sky130_fd_sc_hd__decap_12
XFILLER_7_39 VSS VSS VDD VDD sky130_fd_sc_hd__decap_12
XFILLER_20_195 VSS VSS VDD VDD sky130_fd_sc_hd__fill_1
XFILLER_16_15 VSS VSS VDD VDD sky130_fd_sc_hd__decap_12
XTAP_TAPCELL_ROW_13_157 VSS VDD sky130_fd_sc_hd__tapvpwrvgnd_1
XFILLER_3_361 VSS VSS VDD VDD sky130_fd_sc_hd__decap_12
XFILLER_7_111 VSS VSS VDD VDD sky130_fd_sc_hd__fill_1
XFILLER_19_273 VSS VSS VDD VDD sky130_fd_sc_hd__decap_6
XPHY_EDGE_ROW_4_Right_4 VSS VSS VDD VDD sky130_fd_sc_hd__decap_3
XFILLER_25_210 VSS VSS VDD VDD sky130_fd_sc_hd__fill_1
XFILLER_13_405 VSS VSS VDD VDD sky130_fd_sc_hd__fill_2
XTAP_TAPCELL_ROW_10_138 VSS VDD sky130_fd_sc_hd__tapvpwrvgnd_1
XFILLER_4_29 VSS VSS VDD VDD sky130_fd_sc_hd__decap_12
XFILLER_16_265 VSS VSS VDD VDD sky130_fd_sc_hd__decap_12
XFILLER_16_221 VSS VSS VDD VDD sky130_fd_sc_hd__decap_12
XTAP_TAPCELL_ROW_4_94 VSS VDD sky130_fd_sc_hd__tapvpwrvgnd_1
XFILLER_13_27 VSS VSS VDD VDD sky130_fd_sc_hd__decap_12
XTAP_TAPCELL_ROW_23_230 VSS VDD sky130_fd_sc_hd__tapvpwrvgnd_1
XFILLER_13_279 VSS VSS VDD VDD sky130_fd_sc_hd__fill_1
XFILLER_9_217 VSS VSS VDD VDD sky130_fd_sc_hd__decap_6
XFILLER_24_15 VSS VSS VDD VDD sky130_fd_sc_hd__decap_12
XFILLER_6_209 VSS VSS VDD VDD sky130_fd_sc_hd__decap_12
X_74_ _76_/CLK _74_/D VSS VSS VDD VDD _74_/Q sky130_fd_sc_hd__dfxtp_1
XFILLER_17_393 VSS VSS VDD VDD sky130_fd_sc_hd__decap_12
XTAP_TAPCELL_ROW_1_73 VSS VDD sky130_fd_sc_hd__tapvpwrvgnd_1
XFILLER_27_113 VSS VSS VDD VDD sky130_fd_sc_hd__decap_12
XFILLER_23_385 VSS VSS VDD VDD sky130_fd_sc_hd__decap_6
XFILLER_19_15 VSS VSS VDD VDD sky130_fd_sc_hd__decap_12
XFILLER_2_245 VSS VSS VDD VDD sky130_fd_sc_hd__decap_6
XFILLER_2_289 VSS VSS VDD VDD sky130_fd_sc_hd__decap_12
XFILLER_4_3 VSS VSS VDD VDD sky130_fd_sc_hd__decap_12
XFILLER_14_363 VSS VSS VDD VDD sky130_fd_sc_hd__fill_1
X_57_ _57_/A _57_/B _57_/C VSS VSS VDD VDD _58_/S sky130_fd_sc_hd__nor3_1
XFILLER_21_27 VSS VSS VDD VDD sky130_fd_sc_hd__decap_12
XFILLER_20_377 VSS VSS VDD VDD sky130_fd_sc_hd__decap_12
XFILLER_20_333 VSS VSS VDD VDD sky130_fd_sc_hd__decap_12
XTAP_TAPCELL_ROW_19_196 VSS VDD sky130_fd_sc_hd__tapvpwrvgnd_1
XFILLER_15_105 VSS VSS VDD VDD sky130_fd_sc_hd__decap_6
XFILLER_23_193 VSS VSS VDD VDD sky130_fd_sc_hd__decap_12
XFILLER_15_149 VSS VSS VDD VDD sky130_fd_sc_hd__decap_12
XFILLER_11_93 VSS VSS VDD VDD sky130_fd_sc_hd__decap_12
XFILLER_7_337 VSS VSS VDD VDD sky130_fd_sc_hd__decap_12
XFILLER_20_141 VSS VSS VDD VDD sky130_fd_sc_hd__decap_12
XTAP_TAPCELL_ROW_16_177 VSS VDD sky130_fd_sc_hd__tapvpwrvgnd_1
XFILLER_16_27 VSS VSS VDD VDD sky130_fd_sc_hd__fill_1
XTAP_TAPCELL_ROW_13_158 VSS VDD sky130_fd_sc_hd__tapvpwrvgnd_1
XFILLER_4_307 VSS VSS VDD VDD sky130_fd_sc_hd__fill_1
XTAP_TAPCELL_ROW_7_112 VSS VDD sky130_fd_sc_hd__tapvpwrvgnd_1
XFILLER_8_83 VSS VSS VDD VDD sky130_fd_sc_hd__fill_1
XFILLER_3_373 VSS VSS VDD VDD sky130_fd_sc_hd__decap_12
XFILLER_7_167 VSS VSS VDD VDD sky130_fd_sc_hd__fill_1
XFILLER_27_15 VSS VSS VDD VDD sky130_fd_sc_hd__fill_2
XTAP_TAPCELL_ROW_10_139 VSS VDD sky130_fd_sc_hd__tapvpwrvgnd_1
XFILLER_0_321 VSS VSS VDD VDD sky130_fd_sc_hd__decap_12
XTAP_TAPCELL_ROW_26_250 VSS VDD sky130_fd_sc_hd__tapvpwrvgnd_1
XFILLER_17_81 VSS VSS VDD VDD sky130_fd_sc_hd__decap_12
XFILLER_16_277 VSS VSS VDD VDD sky130_fd_sc_hd__decap_12
XFILLER_16_233 VSS VSS VDD VDD sky130_fd_sc_hd__decap_12
XFILLER_0_365 VSS VSS VDD VDD sky130_fd_sc_hd__decap_12
XFILLER_3_181 VSS VSS VDD VDD sky130_fd_sc_hd__decap_12
XTAP_TAPCELL_ROW_4_95 VSS VDD sky130_fd_sc_hd__tapvpwrvgnd_1
XFILLER_13_39 VSS VSS VDD VDD sky130_fd_sc_hd__decap_12
XFILLER_13_225 VSS VSS VDD VDD sky130_fd_sc_hd__decap_12
XFILLER_24_27 VSS VSS VDD VDD sky130_fd_sc_hd__fill_1
XFILLER_8_251 VSS VSS VDD VDD sky130_fd_sc_hd__fill_1
XFILLER_5_51 VSS VSS VDD VDD sky130_fd_sc_hd__decap_4
X_73_ _76_/CLK _73_/D VSS VSS VDD VDD _73_/Q sky130_fd_sc_hd__dfxtp_1
XFILLER_24_309 VSS VSS VDD VDD sky130_fd_sc_hd__decap_12
XFILLER_17_361 VSS VSS VDD VDD sky130_fd_sc_hd__decap_12
XTAP_TAPCELL_ROW_1_74 VSS VDD sky130_fd_sc_hd__tapvpwrvgnd_1
XFILLER_27_169 VSS VSS VDD VDD sky130_fd_sc_hd__decap_8
XFILLER_19_27 VSS VSS VDD VDD sky130_fd_sc_hd__decap_12
XFILLER_10_29 VSS VSS VDD VDD sky130_fd_sc_hd__decap_12
XFILLER_25_81 VSS VSS VDD VDD sky130_fd_sc_hd__decap_8
X_56_ _71_/Q VSS VSS VDD VDD _57_/A sky130_fd_sc_hd__inv_1
XFILLER_24_139 VSS VSS VDD VDD sky130_fd_sc_hd__fill_1
XFILLER_21_39 VSS VSS VDD VDD sky130_fd_sc_hd__decap_12
XFILLER_20_389 VSS VSS VDD VDD sky130_fd_sc_hd__decap_12
XFILLER_20_345 VSS VSS VDD VDD sky130_fd_sc_hd__decap_12
XFILLER_20_301 VSS VSS VDD VDD sky130_fd_sc_hd__decap_6
XTAP_TAPCELL_ROW_19_197 VSS VDD sky130_fd_sc_hd__tapvpwrvgnd_1
XFILLER_2_41 VSS VSS VDD VDD sky130_fd_sc_hd__decap_12
XFILLER_2_85 VSS VSS VDD VDD sky130_fd_sc_hd__decap_12
XFILLER_23_161 VSS VSS VDD VDD sky130_fd_sc_hd__decap_6
XFILLER_7_349 VSS VSS VDD VDD sky130_fd_sc_hd__decap_12
XFILLER_7_305 VSS VSS VDD VDD sky130_fd_sc_hd__decap_12
X_39_ _76_/Q VSS VSS VDD VDD _41_/B sky130_fd_sc_hd__inv_1
XTAP_TAPCELL_ROW_16_178 VSS VDD sky130_fd_sc_hd__tapvpwrvgnd_1
XFILLER_20_197 VSS VSS VDD VDD sky130_fd_sc_hd__decap_12
XFILLER_20_153 VSS VSS VDD VDD sky130_fd_sc_hd__decap_12
XFILLER_12_109 VSS VSS VDD VDD sky130_fd_sc_hd__decap_12
XTAP_TAPCELL_ROW_7_113 VSS VDD sky130_fd_sc_hd__tapvpwrvgnd_1
XTAP_TAPCELL_ROW_13_159 VSS VDD sky130_fd_sc_hd__tapvpwrvgnd_1
XFILLER_3_385 VSS VSS VDD VDD sky130_fd_sc_hd__decap_6
XFILLER_7_113 VSS VSS VDD VDD sky130_fd_sc_hd__decap_12
XFILLER_27_27 VSS VSS VDD VDD sky130_fd_sc_hd__fill_1
XFILLER_25_289 VSS VSS VDD VDD sky130_fd_sc_hd__decap_3
XFILLER_25_245 VSS VSS VDD VDD sky130_fd_sc_hd__decap_12
XFILLER_25_223 VSS VSS VDD VDD sky130_fd_sc_hd__fill_1
XTAP_TAPCELL_ROW_26_251 VSS VDD sky130_fd_sc_hd__tapvpwrvgnd_1
XFILLER_17_93 VSS VSS VDD VDD sky130_fd_sc_hd__decap_12
XFILLER_16_289 VSS VSS VDD VDD sky130_fd_sc_hd__decap_12
XFILLER_16_245 VSS VSS VDD VDD sky130_fd_sc_hd__decap_6
XFILLER_0_333 VSS VSS VDD VDD sky130_fd_sc_hd__decap_3
XFILLER_0_377 VSS VSS VDD VDD sky130_fd_sc_hd__decap_12
XTAP_TAPCELL_ROW_4_96 VSS VDD sky130_fd_sc_hd__tapvpwrvgnd_1
XFILLER_12_3 VSS VSS VDD VDD sky130_fd_sc_hd__decap_12
XFILLER_3_193 VSS VSS VDD VDD sky130_fd_sc_hd__decap_12
XFILLER_21_281 VSS VSS VDD VDD sky130_fd_sc_hd__decap_12
XFILLER_13_237 VSS VSS VDD VDD sky130_fd_sc_hd__decap_12
XFILLER_0_141 VSS VSS VDD VDD sky130_fd_sc_hd__decap_12
XFILLER_18_307 VSS VSS VDD VDD sky130_fd_sc_hd__fill_1
X_72_ _77_/CLK _72_/D VSS VSS VDD VDD _72_/Q sky130_fd_sc_hd__dfxtp_1
XFILLER_17_373 VSS VSS VDD VDD sky130_fd_sc_hd__decap_12
XFILLER_14_83 VSS VSS VDD VDD sky130_fd_sc_hd__fill_1
XTAP_TAPCELL_ROW_1_75 VSS VDD sky130_fd_sc_hd__tapvpwrvgnd_1
XFILLER_27_137 VSS VSS VDD VDD sky130_fd_sc_hd__decap_3
XFILLER_19_39 VSS VSS VDD VDD sky130_fd_sc_hd__decap_12
XFILLER_14_365 VSS VSS VDD VDD sky130_fd_sc_hd__decap_12
XFILLER_14_321 VSS VSS VDD VDD sky130_fd_sc_hd__decap_12
X_55_ _72_/Q _68_/A VSS VSS VDD VDD _55_/Y sky130_fd_sc_hd__nand2b_1
XFILLER_20_357 VSS VSS VDD VDD sky130_fd_sc_hd__decap_6
XTAP_TAPCELL_ROW_19_198 VSS VDD sky130_fd_sc_hd__tapvpwrvgnd_1
XFILLER_17_181 VSS VSS VDD VDD sky130_fd_sc_hd__decap_12
XPHY_EDGE_ROW_10_Right_10 VSS VSS VDD VDD sky130_fd_sc_hd__decap_3
XFILLER_9_391 VSS VSS VDD VDD sky130_fd_sc_hd__fill_1
XFILLER_2_53 VSS VSS VDD VDD sky130_fd_sc_hd__decap_12
XFILLER_2_97 VSS VSS VDD VDD sky130_fd_sc_hd__decap_12
XFILLER_11_335 VSS VSS VDD VDD sky130_fd_sc_hd__fill_1
XFILLER_11_51 VSS VSS VDD VDD sky130_fd_sc_hd__decap_4
XFILLER_7_317 VSS VSS VDD VDD sky130_fd_sc_hd__decap_12
XPHY_EDGE_ROW_26_Left_54 VSS VSS VDD VDD sky130_fd_sc_hd__decap_3
XTAP_TAPCELL_ROW_16_179 VSS VDD sky130_fd_sc_hd__tapvpwrvgnd_1
XFILLER_14_195 VSS VSS VDD VDD sky130_fd_sc_hd__fill_1
XPHY_EDGE_ROW_10_Left_38 VSS VSS VDD VDD sky130_fd_sc_hd__decap_3
XFILLER_25_405 VSS VSS VDD VDD sky130_fd_sc_hd__fill_2
X_38_ _38_/A VSS VSS VDD VDD _76_/D sky130_fd_sc_hd__buf_2
XFILLER_20_165 VSS VSS VDD VDD sky130_fd_sc_hd__decap_12
XFILLER_20_121 VSS VSS VDD VDD sky130_fd_sc_hd__decap_12
XFILLER_16_29 VSS VSS VDD VDD sky130_fd_sc_hd__decap_12
XFILLER_4_309 VSS VSS VDD VDD sky130_fd_sc_hd__decap_12
XTAP_TAPCELL_ROW_7_114 VSS VDD sky130_fd_sc_hd__tapvpwrvgnd_1
XFILLER_22_83 VSS VSS VDD VDD sky130_fd_sc_hd__fill_1
XFILLER_14_7 VSS VSS VDD VDD sky130_fd_sc_hd__decap_12
XFILLER_7_125 VSS VSS VDD VDD sky130_fd_sc_hd__decap_12
XFILLER_7_169 VSS VSS VDD VDD sky130_fd_sc_hd__decap_12
XFILLER_25_268 VSS VSS VDD VDD sky130_fd_sc_hd__decap_12
XFILLER_8_85 VSS VSS VDD VDD sky130_fd_sc_hd__decap_12
XFILLER_8_41 VSS VSS VDD VDD sky130_fd_sc_hd__decap_12
XFILLER_8_401 VSS VSS VDD VDD sky130_fd_sc_hd__decap_6
XFILLER_0_389 VSS VSS VDD VDD sky130_fd_sc_hd__decap_3
XFILLER_4_139 VSS VSS VDD VDD sky130_fd_sc_hd__fill_1
XPHY_EDGE_ROW_8_Right_8 VSS VSS VDD VDD sky130_fd_sc_hd__decap_3
XFILLER_3_161 VSS VSS VDD VDD sky130_fd_sc_hd__decap_6
XTAP_TAPCELL_ROW_4_97 VSS VDD sky130_fd_sc_hd__tapvpwrvgnd_1
XFILLER_21_293 VSS VSS VDD VDD sky130_fd_sc_hd__decap_12
XFILLER_13_249 VSS VSS VDD VDD sky130_fd_sc_hd__decap_12
XFILLER_13_205 VSS VSS VDD VDD sky130_fd_sc_hd__decap_12
XPHY_EDGE_ROW_13_Left_41 VSS VSS VDD VDD sky130_fd_sc_hd__decap_3
XFILLER_8_253 VSS VSS VDD VDD sky130_fd_sc_hd__decap_12
XFILLER_0_197 VSS VSS VDD VDD sky130_fd_sc_hd__decap_12
XFILLER_0_153 VSS VSS VDD VDD sky130_fd_sc_hd__decap_12
XFILLER_24_29 VSS VSS VDD VDD sky130_fd_sc_hd__decap_12
XTAP_TAPCELL_ROW_20_203 VSS VDD sky130_fd_sc_hd__tapvpwrvgnd_1
XFILLER_26_363 VSS VSS VDD VDD sky130_fd_sc_hd__fill_1
X_71_ _77_/CLK _71_/D VSS VSS VDD VDD _71_/Q sky130_fd_sc_hd__dfxtp_1
XTAP_TAPCELL_ROW_1_76 VSS VDD sky130_fd_sc_hd__tapvpwrvgnd_1
XFILLER_5_223 VSS VSS VDD VDD sky130_fd_sc_hd__fill_1
XFILLER_17_385 VSS VSS VDD VDD sky130_fd_sc_hd__decap_6
XFILLER_25_61 VSS VSS VDD VDD sky130_fd_sc_hd__fill_1
XFILLER_14_377 VSS VSS VDD VDD sky130_fd_sc_hd__decap_12
XFILLER_14_333 VSS VSS VDD VDD sky130_fd_sc_hd__decap_12
X_54_ _54_/A _68_/A VSS VSS VDD VDD _54_/Y sky130_fd_sc_hd__nand2_1
XTAP_TAPCELL_ROW_19_199 VSS VDD sky130_fd_sc_hd__tapvpwrvgnd_1
XFILLER_17_193 VSS VSS VDD VDD sky130_fd_sc_hd__decap_12
XFILLER_1_281 VSS VSS VDD VDD sky130_fd_sc_hd__decap_12
XFILLER_2_65 VSS VSS VDD VDD sky130_fd_sc_hd__decap_12
XFILLER_7_329 VSS VSS VDD VDD sky130_fd_sc_hd__decap_6
XFILLER_14_141 VSS VSS VDD VDD sky130_fd_sc_hd__decap_12
X_37_ _68_/A _37_/B VSS VSS VDD VDD _38_/A sky130_fd_sc_hd__and2_1
XFILLER_20_177 VSS VSS VDD VDD sky130_fd_sc_hd__decap_12
XFILLER_20_133 VSS VSS VDD VDD sky130_fd_sc_hd__decap_6
XTAP_TAPCELL_ROW_7_115 VSS VDD sky130_fd_sc_hd__tapvpwrvgnd_1
XFILLER_11_111 VSS VSS VDD VDD sky130_fd_sc_hd__fill_1
XFILLER_7_137 VSS VSS VDD VDD sky130_fd_sc_hd__decap_12
XFILLER_27_29 VSS VSS VDD VDD sky130_fd_sc_hd__decap_12
XTAP_TAPCELL_ROW_12_150 VSS VDD sky130_fd_sc_hd__tapvpwrvgnd_1
XFILLER_8_97 VSS VSS VDD VDD sky130_fd_sc_hd__decap_12
XFILLER_8_53 VSS VSS VDD VDD sky130_fd_sc_hd__decap_12
XFILLER_17_51 VSS VSS VDD VDD sky130_fd_sc_hd__decap_4
XFILLER_21_261 VSS VSS VDD VDD sky130_fd_sc_hd__decap_12
XFILLER_13_217 VSS VSS VDD VDD sky130_fd_sc_hd__decap_6
XFILLER_8_265 VSS VSS VDD VDD sky130_fd_sc_hd__decap_12
XFILLER_8_221 VSS VSS VDD VDD sky130_fd_sc_hd__decap_12
XFILLER_0_165 VSS VSS VDD VDD sky130_fd_sc_hd__decap_3
XFILLER_5_405 VSS VSS VDD VDD sky130_fd_sc_hd__fill_2
XFILLER_27_309 VSS VSS VDD VDD sky130_fd_sc_hd__decap_12
XTAP_TAPCELL_ROW_20_204 VSS VDD sky130_fd_sc_hd__tapvpwrvgnd_1
XFILLER_10_209 VSS VSS VDD VDD sky130_fd_sc_hd__decap_12
XFILLER_18_309 VSS VSS VDD VDD sky130_fd_sc_hd__decap_12
XFILLER_14_85 VSS VSS VDD VDD sky130_fd_sc_hd__decap_12
XFILLER_14_41 VSS VSS VDD VDD sky130_fd_sc_hd__decap_12
XFILLER_5_279 VSS VSS VDD VDD sky130_fd_sc_hd__fill_1
X_70_ _77_/CLK _70_/D VSS VSS VDD VDD _70_/Q sky130_fd_sc_hd__dfxtp_1
XFILLER_18_139 VSS VSS VDD VDD sky130_fd_sc_hd__fill_1
XFILLER_25_40 VSS VSS VDD VDD sky130_fd_sc_hd__decap_12
X_53_ _53_/A VSS VSS VDD VDD _71_/D sky130_fd_sc_hd__buf_4
XFILLER_24_109 VSS VSS VDD VDD sky130_fd_sc_hd__decap_12
XFILLER_17_161 VSS VSS VDD VDD sky130_fd_sc_hd__decap_6
XFILLER_14_389 VSS VSS VDD VDD sky130_fd_sc_hd__decap_12
XFILLER_14_345 VSS VSS VDD VDD sky130_fd_sc_hd__decap_12
XFILLER_14_301 VSS VSS VDD VDD sky130_fd_sc_hd__decap_6
XFILLER_1_293 VSS VSS VDD VDD sky130_fd_sc_hd__decap_12
XFILLER_2_77 VSS VSS VDD VDD sky130_fd_sc_hd__decap_6
XFILLER_11_337 VSS VSS VDD VDD sky130_fd_sc_hd__decap_12
XFILLER_9_393 VSS VSS VDD VDD sky130_fd_sc_hd__decap_12
XFILLER_14_197 VSS VSS VDD VDD sky130_fd_sc_hd__decap_12
XFILLER_14_153 VSS VSS VDD VDD sky130_fd_sc_hd__decap_12
X_36_ _76_/Q _57_/B VSS VSS VDD VDD _37_/B sky130_fd_sc_hd__xnor2_1
XFILLER_20_189 VSS VSS VDD VDD sky130_fd_sc_hd__decap_6
XTAP_TAPCELL_ROW_15_170 VSS VDD sky130_fd_sc_hd__tapvpwrvgnd_1
XFILLER_6_363 VSS VSS VDD VDD sky130_fd_sc_hd__fill_1
XFILLER_22_85 VSS VSS VDD VDD sky130_fd_sc_hd__decap_12
XFILLER_22_41 VSS VSS VDD VDD sky130_fd_sc_hd__decap_12
XFILLER_11_167 VSS VSS VDD VDD sky130_fd_sc_hd__fill_1
XTAP_TAPCELL_ROW_7_116 VSS VDD sky130_fd_sc_hd__tapvpwrvgnd_1
XFILLER_7_105 VSS VSS VDD VDD sky130_fd_sc_hd__decap_6
XFILLER_7_149 VSS VSS VDD VDD sky130_fd_sc_hd__decap_12
XFILLER_19_223 VSS VSS VDD VDD sky130_fd_sc_hd__fill_1
XTAP_TAPCELL_ROW_12_151 VSS VDD sky130_fd_sc_hd__tapvpwrvgnd_1
XFILLER_8_65 VSS VSS VDD VDD sky130_fd_sc_hd__decap_12
XFILLER_25_215 VSS VSS VDD VDD sky130_fd_sc_hd__decap_8
XFILLER_15_281 VSS VSS VDD VDD sky130_fd_sc_hd__decap_12
XTAP_TAPCELL_ROW_23_224 VSS VDD sky130_fd_sc_hd__tapvpwrvgnd_1
XFILLER_21_273 VSS VSS VDD VDD sky130_fd_sc_hd__decap_6
XFILLER_12_251 VSS VSS VDD VDD sky130_fd_sc_hd__fill_1
XTAP_TAPCELL_ROW_20_205 VSS VDD sky130_fd_sc_hd__tapvpwrvgnd_1
XFILLER_10_3 VSS VSS VDD VDD sky130_fd_sc_hd__decap_12
XFILLER_8_277 VSS VSS VDD VDD sky130_fd_sc_hd__decap_12
XFILLER_8_233 VSS VSS VDD VDD sky130_fd_sc_hd__decap_12
XFILLER_5_55 VSS VSS VDD VDD sky130_fd_sc_hd__fill_1
XFILLER_26_365 VSS VSS VDD VDD sky130_fd_sc_hd__decap_12
XFILLER_26_321 VSS VSS VDD VDD sky130_fd_sc_hd__decap_12
XFILLER_14_97 VSS VSS VDD VDD sky130_fd_sc_hd__decap_12
XFILLER_14_53 VSS VSS VDD VDD sky130_fd_sc_hd__decap_12
XFILLER_5_225 VSS VSS VDD VDD sky130_fd_sc_hd__decap_12
XFILLER_27_129 VSS VSS VDD VDD sky130_fd_sc_hd__decap_8
XFILLER_23_335 VSS VSS VDD VDD sky130_fd_sc_hd__fill_1
X_52_ _50_/Y _51_/X _68_/A VSS VSS VDD VDD _53_/A sky130_fd_sc_hd__a21boi_1
XFILLER_25_52 VSS VSS VDD VDD sky130_fd_sc_hd__decap_4
XFILLER_14_357 VSS VSS VDD VDD sky130_fd_sc_hd__decap_6
XFILLER_1_261 VSS VSS VDD VDD sky130_fd_sc_hd__decap_12
XFILLER_9_361 VSS VSS VDD VDD sky130_fd_sc_hd__decap_12
XFILLER_19_405 VSS VSS VDD VDD sky130_fd_sc_hd__fill_2
XTAP_TAPCELL_ROW_18_190 VSS VDD sky130_fd_sc_hd__tapvpwrvgnd_1
XFILLER_14_121 VSS VSS VDD VDD sky130_fd_sc_hd__decap_12
XFILLER_11_349 VSS VSS VDD VDD sky130_fd_sc_hd__decap_12
XFILLER_11_305 VSS VSS VDD VDD sky130_fd_sc_hd__decap_12
X_35_ _75_/Q _66_/A _74_/Q _73_/Q VSS VSS VDD VDD _57_/B sky130_fd_sc_hd__nand4_4
XTAP_TAPCELL_ROW_15_171 VSS VDD sky130_fd_sc_hd__tapvpwrvgnd_1
XFILLER_14_165 VSS VSS VDD VDD sky130_fd_sc_hd__decap_12
XFILLER_22_53 VSS VSS VDD VDD sky130_fd_sc_hd__decap_12
XFILLER_11_113 VSS VSS VDD VDD sky130_fd_sc_hd__decap_12
XTAP_TAPCELL_ROW_7_117 VSS VDD sky130_fd_sc_hd__tapvpwrvgnd_1
XFILLER_22_97 VSS VSS VDD VDD sky130_fd_sc_hd__decap_12
XFILLER_19_279 VSS VSS VDD VDD sky130_fd_sc_hd__fill_1
XTAP_TAPCELL_ROW_12_152 VSS VDD sky130_fd_sc_hd__tapvpwrvgnd_1
XFILLER_8_77 VSS VSS VDD VDD sky130_fd_sc_hd__decap_6
XFILLER_0_337 VSS VSS VDD VDD sky130_fd_sc_hd__decap_12
XFILLER_4_109 VSS VSS VDD VDD sky130_fd_sc_hd__decap_12
XFILLER_15_293 VSS VSS VDD VDD sky130_fd_sc_hd__decap_12
XPHY_EDGE_ROW_26_Right_26 VSS VSS VDD VDD sky130_fd_sc_hd__decap_3
XTAP_TAPCELL_ROW_23_225 VSS VDD sky130_fd_sc_hd__tapvpwrvgnd_1
XPHY_EDGE_ROW_17_Right_17 VSS VSS VDD VDD sky130_fd_sc_hd__decap_3
XFILLER_8_289 VSS VSS VDD VDD sky130_fd_sc_hd__decap_12
XFILLER_8_245 VSS VSS VDD VDD sky130_fd_sc_hd__decap_6
XFILLER_26_377 VSS VSS VDD VDD sky130_fd_sc_hd__decap_12
XFILLER_26_333 VSS VSS VDD VDD sky130_fd_sc_hd__decap_12
XTAP_TAPCELL_ROW_20_206 VSS VDD sky130_fd_sc_hd__tapvpwrvgnd_1
XPHY_EDGE_ROW_17_Left_45 VSS VSS VDD VDD sky130_fd_sc_hd__decap_3
XFILLER_14_65 VSS VSS VDD VDD sky130_fd_sc_hd__decap_12
XFILLER_5_237 VSS VSS VDD VDD sky130_fd_sc_hd__decap_12
XFILLER_26_141 VSS VSS VDD VDD sky130_fd_sc_hd__decap_12
XFILLER_25_31 VSS VSS VDD VDD sky130_fd_sc_hd__fill_1
X_51_ _71_/Q _57_/B _57_/C VSS VSS VDD VDD _51_/X sky130_fd_sc_hd__or3_1
XFILLER_13_391 VSS VSS VDD VDD sky130_fd_sc_hd__fill_1
XFILLER_9_373 VSS VSS VDD VDD sky130_fd_sc_hd__decap_12
XFILLER_1_273 VSS VSS VDD VDD sky130_fd_sc_hd__decap_6
XFILLER_23_111 VSS VSS VDD VDD sky130_fd_sc_hd__fill_1
XTAP_TAPCELL_ROW_18_191 VSS VDD sky130_fd_sc_hd__tapvpwrvgnd_1
XFILLER_11_317 VSS VSS VDD VDD sky130_fd_sc_hd__decap_12
XFILLER_11_55 VSS VSS VDD VDD sky130_fd_sc_hd__fill_1
XFILLER_14_177 VSS VSS VDD VDD sky130_fd_sc_hd__decap_12
XFILLER_14_133 VSS VSS VDD VDD sky130_fd_sc_hd__decap_6
XFILLER_6_365 VSS VSS VDD VDD sky130_fd_sc_hd__decap_12
XFILLER_6_321 VSS VSS VDD VDD sky130_fd_sc_hd__decap_12
XTAP_TAPCELL_ROW_15_172 VSS VDD sky130_fd_sc_hd__tapvpwrvgnd_1
XFILLER_9_181 VSS VSS VDD VDD sky130_fd_sc_hd__decap_12
XTAP_TAPCELL_ROW_7_118 VSS VDD sky130_fd_sc_hd__tapvpwrvgnd_1
XFILLER_27_291 VSS VSS VDD VDD sky130_fd_sc_hd__decap_4
XFILLER_22_65 VSS VSS VDD VDD sky130_fd_sc_hd__decap_12
XFILLER_19_225 VSS VSS VDD VDD sky130_fd_sc_hd__decap_12
XTAP_TAPCELL_ROW_12_153 VSS VDD sky130_fd_sc_hd__tapvpwrvgnd_1
XFILLER_11_169 VSS VSS VDD VDD sky130_fd_sc_hd__decap_12
XFILLER_11_125 VSS VSS VDD VDD sky130_fd_sc_hd__decap_12
XFILLER_0_3 VSS VSS VDD VDD sky130_fd_sc_hd__decap_12
XFILLER_3_335 VSS VSS VDD VDD sky130_fd_sc_hd__fill_1
XPHY_EDGE_ROW_5_Left_33 VSS VSS VDD VDD sky130_fd_sc_hd__decap_3
XFILLER_25_206 VSS VSS VDD VDD sky130_fd_sc_hd__decap_4
XFILLER_6_195 VSS VSS VDD VDD sky130_fd_sc_hd__fill_1
XTAP_TAPCELL_ROW_26_245 VSS VDD sky130_fd_sc_hd__tapvpwrvgnd_1
XFILLER_12_401 VSS VSS VDD VDD sky130_fd_sc_hd__decap_6
XFILLER_0_349 VSS VSS VDD VDD sky130_fd_sc_hd__decap_12
XFILLER_0_305 VSS VSS VDD VDD sky130_fd_sc_hd__decap_3
XFILLER_22_209 VSS VSS VDD VDD sky130_fd_sc_hd__decap_12
XFILLER_15_261 VSS VSS VDD VDD sky130_fd_sc_hd__decap_12
XTAP_TAPCELL_ROW_23_226 VSS VDD sky130_fd_sc_hd__tapvpwrvgnd_1
XFILLER_0_113 VSS VSS VDD VDD sky130_fd_sc_hd__decap_12
XFILLER_12_253 VSS VSS VDD VDD sky130_fd_sc_hd__decap_12
XFILLER_5_57 VSS VSS VDD VDD sky130_fd_sc_hd__decap_12
XFILLER_26_389 VSS VSS VDD VDD sky130_fd_sc_hd__decap_12
XFILLER_26_345 VSS VSS VDD VDD sky130_fd_sc_hd__decap_12
XTAP_TAPCELL_ROW_20_207 VSS VDD sky130_fd_sc_hd__tapvpwrvgnd_1
XFILLER_14_77 VSS VSS VDD VDD sky130_fd_sc_hd__decap_6
XFILLER_5_205 VSS VSS VDD VDD sky130_fd_sc_hd__decap_12
XFILLER_5_249 VSS VSS VDD VDD sky130_fd_sc_hd__decap_12
XFILLER_27_109 VSS VSS VDD VDD sky130_fd_sc_hd__decap_3
XFILLER_23_337 VSS VSS VDD VDD sky130_fd_sc_hd__decap_12
XFILLER_26_197 VSS VSS VDD VDD sky130_fd_sc_hd__decap_8
XFILLER_26_153 VSS VSS VDD VDD sky130_fd_sc_hd__decap_12
XFILLER_26_131 VSS VSS VDD VDD sky130_fd_sc_hd__decap_8
XFILLER_25_98 VSS VSS VDD VDD sky130_fd_sc_hd__decap_8
XFILLER_18_109 VSS VSS VDD VDD sky130_fd_sc_hd__decap_12
X_50_ _57_/B _57_/C _71_/Q VSS VSS VDD VDD _50_/Y sky130_fd_sc_hd__o21ai_0
XFILLER_20_307 VSS VSS VDD VDD sky130_fd_sc_hd__fill_1
XFILLER_9_385 VSS VSS VDD VDD sky130_fd_sc_hd__decap_6
XFILLER_23_167 VSS VSS VDD VDD sky130_fd_sc_hd__fill_1
XTAP_TAPCELL_ROW_18_192 VSS VDD sky130_fd_sc_hd__tapvpwrvgnd_1
XFILLER_11_329 VSS VSS VDD VDD sky130_fd_sc_hd__decap_6
XFILLER_2_7 VSS VSS VDD VDD sky130_fd_sc_hd__decap_12
XFILLER_14_189 VSS VSS VDD VDD sky130_fd_sc_hd__decap_6
XFILLER_6_377 VSS VSS VDD VDD sky130_fd_sc_hd__decap_12
XFILLER_6_333 VSS VSS VDD VDD sky130_fd_sc_hd__decap_12
XTAP_TAPCELL_ROW_15_173 VSS VDD sky130_fd_sc_hd__tapvpwrvgnd_1
XFILLER_9_193 VSS VSS VDD VDD sky130_fd_sc_hd__decap_12
XFILLER_27_281 VSS VSS VDD VDD sky130_fd_sc_hd__fill_2
XFILLER_22_77 VSS VSS VDD VDD sky130_fd_sc_hd__decap_6
XFILLER_19_237 VSS VSS VDD VDD sky130_fd_sc_hd__decap_12
XFILLER_11_137 VSS VSS VDD VDD sky130_fd_sc_hd__decap_12
XFILLER_26_3 VSS VSS VDD VDD sky130_fd_sc_hd__decap_12
XFILLER_6_141 VSS VSS VDD VDD sky130_fd_sc_hd__decap_12
XTAP_TAPCELL_ROW_26_246 VSS VDD sky130_fd_sc_hd__tapvpwrvgnd_1
XFILLER_24_273 VSS VSS VDD VDD sky130_fd_sc_hd__fill_1
XFILLER_17_55 VSS VSS VDD VDD sky130_fd_sc_hd__fill_1
XFILLER_15_273 VSS VSS VDD VDD sky130_fd_sc_hd__decap_6
XFILLER_3_111 VSS VSS VDD VDD sky130_fd_sc_hd__fill_1
XTAP_TAPCELL_ROW_23_227 VSS VDD sky130_fd_sc_hd__tapvpwrvgnd_1
XPHY_EDGE_ROW_3_Right_3 VSS VSS VDD VDD sky130_fd_sc_hd__decap_3
XFILLER_12_265 VSS VSS VDD VDD sky130_fd_sc_hd__decap_12
XFILLER_12_221 VSS VSS VDD VDD sky130_fd_sc_hd__decap_12
XFILLER_0_169 VSS VSS VDD VDD sky130_fd_sc_hd__decap_12
XFILLER_0_125 VSS VSS VDD VDD sky130_fd_sc_hd__decap_12
XFILLER_5_69 VSS VSS VDD VDD sky130_fd_sc_hd__decap_12
XTAP_TAPCELL_ROW_20_208 VSS VDD sky130_fd_sc_hd__tapvpwrvgnd_1
XFILLER_26_357 VSS VSS VDD VDD sky130_fd_sc_hd__decap_6
XFILLER_17_335 VSS VSS VDD VDD sky130_fd_sc_hd__fill_1
XFILLER_5_217 VSS VSS VDD VDD sky130_fd_sc_hd__decap_6
XFILLER_23_305 VSS VSS VDD VDD sky130_fd_sc_hd__decap_12
XFILLER_26_165 VSS VSS VDD VDD sky130_fd_sc_hd__decap_12
XFILLER_23_349 VSS VSS VDD VDD sky130_fd_sc_hd__decap_12
XFILLER_2_209 VSS VSS VDD VDD sky130_fd_sc_hd__decap_12
XFILLER_13_393 VSS VSS VDD VDD sky130_fd_sc_hd__decap_12
XFILLER_23_113 VSS VSS VDD VDD sky130_fd_sc_hd__decap_12
XTAP_TAPCELL_ROW_18_193 VSS VDD sky130_fd_sc_hd__tapvpwrvgnd_1
XFILLER_11_57 VSS VSS VDD VDD sky130_fd_sc_hd__decap_12
XTAP_TAPCELL_ROW_2_80 VSS VDD sky130_fd_sc_hd__tapvpwrvgnd_1
XFILLER_10_363 VSS VSS VDD VDD sky130_fd_sc_hd__fill_1
XFILLER_6_389 VSS VSS VDD VDD sky130_fd_sc_hd__decap_12
XFILLER_6_345 VSS VSS VDD VDD sky130_fd_sc_hd__decap_12
XFILLER_6_301 VSS VSS VDD VDD sky130_fd_sc_hd__decap_6
XTAP_TAPCELL_ROW_15_174 VSS VDD sky130_fd_sc_hd__tapvpwrvgnd_1
XFILLER_9_161 VSS VSS VDD VDD sky130_fd_sc_hd__decap_6
XFILLER_19_205 VSS VSS VDD VDD sky130_fd_sc_hd__decap_12
XFILLER_11_149 VSS VSS VDD VDD sky130_fd_sc_hd__decap_12
XFILLER_11_105 VSS VSS VDD VDD sky130_fd_sc_hd__decap_6
XFILLER_3_337 VSS VSS VDD VDD sky130_fd_sc_hd__decap_12
XFILLER_19_249 VSS VSS VDD VDD sky130_fd_sc_hd__decap_12
XFILLER_19_3 VSS VSS VDD VDD sky130_fd_sc_hd__decap_12
XFILLER_6_153 VSS VSS VDD VDD sky130_fd_sc_hd__decap_12
XFILLER_6_197 VSS VSS VDD VDD sky130_fd_sc_hd__decap_12
XTAP_TAPCELL_ROW_26_247 VSS VDD sky130_fd_sc_hd__tapvpwrvgnd_1
XFILLER_24_296 VSS VSS VDD VDD sky130_fd_sc_hd__decap_12
XFILLER_3_167 VSS VSS VDD VDD sky130_fd_sc_hd__fill_1
XTAP_TAPCELL_ROW_23_228 VSS VDD sky130_fd_sc_hd__tapvpwrvgnd_1
XFILLER_0_81 VSS VSS VDD VDD sky130_fd_sc_hd__decap_3
XFILLER_12_277 VSS VSS VDD VDD sky130_fd_sc_hd__decap_12
XFILLER_12_233 VSS VSS VDD VDD sky130_fd_sc_hd__decap_12
XFILLER_0_137 VSS VSS VDD VDD sky130_fd_sc_hd__decap_3
XFILLER_5_15 VSS VSS VDD VDD sky130_fd_sc_hd__decap_12
XPHY_EDGE_ROW_22_Right_22 VSS VSS VDD VDD sky130_fd_sc_hd__decap_3
XTAP_TAPCELL_ROW_20_209 VSS VDD sky130_fd_sc_hd__tapvpwrvgnd_1
XPHY_EDGE_ROW_13_Right_13 VSS VSS VDD VDD sky130_fd_sc_hd__decap_3
XFILLER_7_281 VSS VSS VDD VDD sky130_fd_sc_hd__decap_12
XFILLER_25_391 VSS VSS VDD VDD sky130_fd_sc_hd__fill_1
XFILLER_4_251 VSS VSS VDD VDD sky130_fd_sc_hd__fill_1
XFILLER_23_317 VSS VSS VDD VDD sky130_fd_sc_hd__decap_12
XFILLER_26_177 VSS VSS VDD VDD sky130_fd_sc_hd__decap_3
XFILLER_25_89 VSS VSS VDD VDD sky130_fd_sc_hd__fill_2
XFILLER_17_111 VSS VSS VDD VDD sky130_fd_sc_hd__fill_1
XFILLER_2_27 VSS VSS VDD VDD sky130_fd_sc_hd__fill_1
XFILLER_23_169 VSS VSS VDD VDD sky130_fd_sc_hd__decap_12
XFILLER_23_125 VSS VSS VDD VDD sky130_fd_sc_hd__decap_12
XFILLER_20_309 VSS VSS VDD VDD sky130_fd_sc_hd__decap_12
XTAP_TAPCELL_ROW_18_194 VSS VDD sky130_fd_sc_hd__tapvpwrvgnd_1
XFILLER_13_361 VSS VSS VDD VDD sky130_fd_sc_hd__decap_12
XTAP_TAPCELL_ROW_2_81 VSS VDD sky130_fd_sc_hd__tapvpwrvgnd_1
XFILLER_11_69 VSS VSS VDD VDD sky130_fd_sc_hd__decap_12
XFILLER_20_139 VSS VSS VDD VDD sky130_fd_sc_hd__fill_1
XFILLER_6_357 VSS VSS VDD VDD sky130_fd_sc_hd__decap_6
XFILLER_24_401 VSS VSS VDD VDD sky130_fd_sc_hd__decap_6
XTAP_TAPCELL_ROW_6_110 VSS VDD sky130_fd_sc_hd__tapvpwrvgnd_1
XFILLER_3_81 VSS VSS VDD VDD sky130_fd_sc_hd__decap_12
XFILLER_3_305 VSS VSS VDD VDD sky130_fd_sc_hd__decap_12
XFILLER_3_349 VSS VSS VDD VDD sky130_fd_sc_hd__decap_12
XFILLER_19_217 VSS VSS VDD VDD sky130_fd_sc_hd__decap_6
XFILLER_8_15 VSS VSS VDD VDD sky130_fd_sc_hd__decap_12
XFILLER_6_121 VSS VSS VDD VDD sky130_fd_sc_hd__decap_12
XFILLER_6_165 VSS VSS VDD VDD sky130_fd_sc_hd__decap_12
XTAP_TAPCELL_ROW_26_248 VSS VDD sky130_fd_sc_hd__tapvpwrvgnd_1
XFILLER_24_253 VSS VSS VDD VDD sky130_fd_sc_hd__decap_8
XFILLER_17_57 VSS VSS VDD VDD sky130_fd_sc_hd__decap_12
XFILLER_16_209 VSS VSS VDD VDD sky130_fd_sc_hd__decap_12
XPHY_EDGE_ROW_9_Left_37 VSS VSS VDD VDD sky130_fd_sc_hd__decap_3
XFILLER_3_113 VSS VSS VDD VDD sky130_fd_sc_hd__decap_12
XTAP_TAPCELL_ROW_23_229 VSS VDD sky130_fd_sc_hd__tapvpwrvgnd_1
XFILLER_21_223 VSS VSS VDD VDD sky130_fd_sc_hd__fill_1
XFILLER_12_245 VSS VSS VDD VDD sky130_fd_sc_hd__decap_6
XFILLER_12_289 VSS VSS VDD VDD sky130_fd_sc_hd__decap_12
XFILLER_5_27 VSS VSS VDD VDD sky130_fd_sc_hd__decap_12
XFILLER_7_293 VSS VSS VDD VDD sky130_fd_sc_hd__decap_12
XFILLER_17_337 VSS VSS VDD VDD sky130_fd_sc_hd__decap_12
XFILLER_23_329 VSS VSS VDD VDD sky130_fd_sc_hd__decap_6
XFILLER_25_57 VSS VSS VDD VDD sky130_fd_sc_hd__decap_4
XFILLER_14_307 VSS VSS VDD VDD sky130_fd_sc_hd__fill_1
XFILLER_9_3 VSS VSS VDD VDD sky130_fd_sc_hd__decap_12
XFILLER_17_167 VSS VSS VDD VDD sky130_fd_sc_hd__fill_1
XFILLER_13_373 VSS VSS VDD VDD sky130_fd_sc_hd__decap_12
XTAP_TAPCELL_ROW_2_82 VSS VDD sky130_fd_sc_hd__tapvpwrvgnd_1
XFILLER_23_137 VSS VSS VDD VDD sky130_fd_sc_hd__decap_12
XTAP_TAPCELL_ROW_18_195 VSS VDD sky130_fd_sc_hd__tapvpwrvgnd_1
XFILLER_11_15 VSS VSS VDD VDD sky130_fd_sc_hd__decap_12
XFILLER_13_181 VSS VSS VDD VDD sky130_fd_sc_hd__decap_12
XFILLER_10_365 VSS VSS VDD VDD sky130_fd_sc_hd__decap_12
XFILLER_10_321 VSS VSS VDD VDD sky130_fd_sc_hd__decap_12
XTAP_TAPCELL_ROW_9_130 VSS VDD sky130_fd_sc_hd__tapvpwrvgnd_1
XFILLER_3_93 VSS VSS VDD VDD sky130_fd_sc_hd__decap_12
XFILLER_5_391 VSS VSS VDD VDD sky130_fd_sc_hd__fill_1
XFILLER_27_295 VSS VSS VDD VDD sky130_fd_sc_hd__fill_1
XFILLER_27_240 VSS VSS VDD VDD sky130_fd_sc_hd__decap_12
XFILLER_10_195 VSS VSS VDD VDD sky130_fd_sc_hd__fill_1
XFILLER_8_27 VSS VSS VDD VDD sky130_fd_sc_hd__fill_1
XTAP_TAPCELL_ROW_6_111 VSS VDD sky130_fd_sc_hd__tapvpwrvgnd_1
XFILLER_3_317 VSS VSS VDD VDD sky130_fd_sc_hd__decap_12
XFILLER_6_133 VSS VSS VDD VDD sky130_fd_sc_hd__decap_6
XFILLER_6_177 VSS VSS VDD VDD sky130_fd_sc_hd__decap_12
XPHY_EDGE_ROW_25_Left_53 VSS VSS VDD VDD sky130_fd_sc_hd__decap_3
XFILLER_21_405 VSS VSS VDD VDD sky130_fd_sc_hd__fill_2
XFILLER_18_251 VSS VSS VDD VDD sky130_fd_sc_hd__fill_1
XFILLER_0_309 VSS VSS VDD VDD sky130_fd_sc_hd__decap_12
XTAP_TAPCELL_ROW_26_249 VSS VDD sky130_fd_sc_hd__tapvpwrvgnd_1
XFILLER_24_265 VSS VSS VDD VDD sky130_fd_sc_hd__decap_8
XFILLER_17_69 VSS VSS VDD VDD sky130_fd_sc_hd__decap_12
XFILLER_3_125 VSS VSS VDD VDD sky130_fd_sc_hd__decap_12
XFILLER_3_169 VSS VSS VDD VDD sky130_fd_sc_hd__decap_12
XFILLER_24_3 VSS VSS VDD VDD sky130_fd_sc_hd__decap_12
XFILLER_21_279 VSS VSS VDD VDD sky130_fd_sc_hd__fill_1
XFILLER_9_81 VSS VSS VDD VDD sky130_fd_sc_hd__decap_12
XFILLER_4_401 VSS VSS VDD VDD sky130_fd_sc_hd__decap_6
XFILLER_5_39 VSS VSS VDD VDD sky130_fd_sc_hd__decap_12
XPHY_EDGE_ROW_12_Left_40 VSS VSS VDD VDD sky130_fd_sc_hd__decap_3
XPHY_EDGE_ROW_7_Right_7 VSS VSS VDD VDD sky130_fd_sc_hd__decap_3
XFILLER_7_261 VSS VSS VDD VDD sky130_fd_sc_hd__decap_12
XFILLER_25_393 VSS VSS VDD VDD sky130_fd_sc_hd__decap_12
XFILLER_17_349 VSS VSS VDD VDD sky130_fd_sc_hd__decap_12
XFILLER_17_305 VSS VSS VDD VDD sky130_fd_sc_hd__decap_12
XFILLER_4_253 VSS VSS VDD VDD sky130_fd_sc_hd__decap_12
XFILLER_25_69 VSS VSS VDD VDD sky130_fd_sc_hd__decap_12
XFILLER_22_363 VSS VSS VDD VDD sky130_fd_sc_hd__fill_1
XFILLER_1_223 VSS VSS VDD VDD sky130_fd_sc_hd__fill_1
XFILLER_17_113 VSS VSS VDD VDD sky130_fd_sc_hd__decap_12
XFILLER_13_385 VSS VSS VDD VDD sky130_fd_sc_hd__decap_6
XFILLER_2_29 VSS VSS VDD VDD sky130_fd_sc_hd__decap_12
XTAP_TAPCELL_ROW_2_83 VSS VDD sky130_fd_sc_hd__tapvpwrvgnd_1
XFILLER_23_149 VSS VSS VDD VDD sky130_fd_sc_hd__decap_12
XFILLER_23_105 VSS VSS VDD VDD sky130_fd_sc_hd__decap_6
XFILLER_11_27 VSS VSS VDD VDD sky130_fd_sc_hd__decap_12
XFILLER_10_377 VSS VSS VDD VDD sky130_fd_sc_hd__decap_12
XFILLER_10_333 VSS VSS VDD VDD sky130_fd_sc_hd__decap_12
XTAP_TAPCELL_ROW_9_131 VSS VDD sky130_fd_sc_hd__tapvpwrvgnd_1
XFILLER_13_193 VSS VSS VDD VDD sky130_fd_sc_hd__decap_12
XFILLER_22_15 VSS VSS VDD VDD sky130_fd_sc_hd__decap_12
XTAP_TAPCELL_ROW_12_147 VSS VDD sky130_fd_sc_hd__tapvpwrvgnd_1
XFILLER_10_141 VSS VSS VDD VDD sky130_fd_sc_hd__decap_12
XFILLER_3_329 VSS VSS VDD VDD sky130_fd_sc_hd__decap_6
XFILLER_6_189 VSS VSS VDD VDD sky130_fd_sc_hd__decap_6
XFILLER_17_15 VSS VSS VDD VDD sky130_fd_sc_hd__decap_12
XFILLER_3_137 VSS VSS VDD VDD sky130_fd_sc_hd__decap_12
XFILLER_21_225 VSS VSS VDD VDD sky130_fd_sc_hd__decap_12
XFILLER_17_3 VSS VSS VDD VDD sky130_fd_sc_hd__decap_12
XFILLER_9_93 VSS VSS VDD VDD sky130_fd_sc_hd__decap_12
XTAP_TAPCELL_ROW_22_220 VSS VDD sky130_fd_sc_hd__tapvpwrvgnd_1
XFILLER_19_391 VSS VSS VDD VDD sky130_fd_sc_hd__fill_1
XFILLER_7_273 VSS VSS VDD VDD sky130_fd_sc_hd__decap_6
XFILLER_25_361 VSS VSS VDD VDD sky130_fd_sc_hd__decap_12
XFILLER_17_317 VSS VSS VDD VDD sky130_fd_sc_hd__decap_12
XFILLER_14_27 VSS VSS VDD VDD sky130_fd_sc_hd__fill_1
XFILLER_1_405 VSS VSS VDD VDD sky130_fd_sc_hd__fill_2
XFILLER_4_221 VSS VSS VDD VDD sky130_fd_sc_hd__decap_12
XFILLER_4_265 VSS VSS VDD VDD sky130_fd_sc_hd__decap_12
XFILLER_25_15 VSS VSS VDD VDD sky130_fd_sc_hd__decap_12
XFILLER_14_309 VSS VSS VDD VDD sky130_fd_sc_hd__decap_12
XFILLER_6_83 VSS VSS VDD VDD sky130_fd_sc_hd__fill_1
XFILLER_17_169 VSS VSS VDD VDD sky130_fd_sc_hd__decap_12
XFILLER_17_125 VSS VSS VDD VDD sky130_fd_sc_hd__decap_12
XFILLER_15_81 VSS VSS VDD VDD sky130_fd_sc_hd__decap_12
XFILLER_9_335 VSS VSS VDD VDD sky130_fd_sc_hd__fill_1
XFILLER_1_279 VSS VSS VDD VDD sky130_fd_sc_hd__fill_1
XFILLER_2_19 VSS VSS VDD VDD sky130_fd_sc_hd__decap_8
XFILLER_11_39 VSS VSS VDD VDD sky130_fd_sc_hd__decap_12
XFILLER_18_401 VSS VSS VDD VDD sky130_fd_sc_hd__decap_6
XFILLER_14_139 VSS VSS VDD VDD sky130_fd_sc_hd__fill_1
XFILLER_10_389 VSS VSS VDD VDD sky130_fd_sc_hd__decap_12
XFILLER_10_345 VSS VSS VDD VDD sky130_fd_sc_hd__decap_12
XFILLER_10_301 VSS VSS VDD VDD sky130_fd_sc_hd__decap_6
XTAP_TAPCELL_ROW_9_132 VSS VDD sky130_fd_sc_hd__tapvpwrvgnd_1
XFILLER_20_109 VSS VSS VDD VDD sky130_fd_sc_hd__decap_12
XFILLER_13_161 VSS VSS VDD VDD sky130_fd_sc_hd__decap_6
XFILLER_3_51 VSS VSS VDD VDD sky130_fd_sc_hd__decap_4
XFILLER_5_393 VSS VSS VDD VDD sky130_fd_sc_hd__decap_12
XFILLER_27_286 VSS VSS VDD VDD sky130_fd_sc_hd__fill_1
XFILLER_27_253 VSS VSS VDD VDD sky130_fd_sc_hd__decap_12
XFILLER_27_231 VSS VSS VDD VDD sky130_fd_sc_hd__fill_1
XFILLER_22_27 VSS VSS VDD VDD sky130_fd_sc_hd__fill_1
XFILLER_18_253 VSS VSS VDD VDD sky130_fd_sc_hd__decap_12
XTAP_TAPCELL_ROW_12_148 VSS VDD sky130_fd_sc_hd__tapvpwrvgnd_1
XFILLER_10_197 VSS VSS VDD VDD sky130_fd_sc_hd__decap_12
XFILLER_10_153 VSS VSS VDD VDD sky130_fd_sc_hd__decap_12
XFILLER_8_29 VSS VSS VDD VDD sky130_fd_sc_hd__decap_12
XFILLER_2_363 VSS VSS VDD VDD sky130_fd_sc_hd__fill_1
XFILLER_24_234 VSS VSS VDD VDD sky130_fd_sc_hd__fill_2
XFILLER_17_27 VSS VSS VDD VDD sky130_fd_sc_hd__decap_12
XTAP_TAPCELL_ROW_25_240 VSS VDD sky130_fd_sc_hd__tapvpwrvgnd_1
XFILLER_23_81 VSS VSS VDD VDD sky130_fd_sc_hd__decap_12
XFILLER_15_223 VSS VSS VDD VDD sky130_fd_sc_hd__fill_1
XFILLER_3_105 VSS VSS VDD VDD sky130_fd_sc_hd__decap_6
XFILLER_3_149 VSS VSS VDD VDD sky130_fd_sc_hd__decap_12
XFILLER_21_237 VSS VSS VDD VDD sky130_fd_sc_hd__decap_12
XFILLER_0_85 VSS VSS VDD VDD sky130_fd_sc_hd__decap_12
XFILLER_0_41 VSS VSS VDD VDD sky130_fd_sc_hd__decap_12
XTAP_TAPCELL_ROW_22_221 VSS VDD sky130_fd_sc_hd__tapvpwrvgnd_1
XFILLER_11_281 VSS VSS VDD VDD sky130_fd_sc_hd__decap_12
XFILLER_17_329 VSS VSS VDD VDD sky130_fd_sc_hd__decap_6
XFILLER_25_373 VSS VSS VDD VDD sky130_fd_sc_hd__decap_12
XFILLER_4_233 VSS VSS VDD VDD sky130_fd_sc_hd__decap_12
XFILLER_4_277 VSS VSS VDD VDD sky130_fd_sc_hd__decap_12
XFILLER_25_27 VSS VSS VDD VDD sky130_fd_sc_hd__decap_4
XFILLER_22_365 VSS VSS VDD VDD sky130_fd_sc_hd__decap_12
XFILLER_22_321 VSS VSS VDD VDD sky130_fd_sc_hd__decap_12
XFILLER_17_137 VSS VSS VDD VDD sky130_fd_sc_hd__decap_12
XFILLER_15_93 VSS VSS VDD VDD sky130_fd_sc_hd__decap_12
XFILLER_1_225 VSS VSS VDD VDD sky130_fd_sc_hd__decap_12
XFILLER_22_195 VSS VSS VDD VDD sky130_fd_sc_hd__fill_1
XFILLER_10_357 VSS VSS VDD VDD sky130_fd_sc_hd__decap_6
XFILLER_7_3 VSS VSS VDD VDD sky130_fd_sc_hd__decap_12
XTAP_TAPCELL_ROW_15_168 VSS VDD sky130_fd_sc_hd__tapvpwrvgnd_1
XFILLER_9_111 VSS VSS VDD VDD sky130_fd_sc_hd__fill_1
XFILLER_5_361 VSS VSS VDD VDD sky130_fd_sc_hd__decap_12
XFILLER_27_265 VSS VSS VDD VDD sky130_fd_sc_hd__decap_12
XFILLER_27_221 VSS VSS VDD VDD sky130_fd_sc_hd__decap_3
XFILLER_18_265 VSS VSS VDD VDD sky130_fd_sc_hd__decap_12
XFILLER_18_221 VSS VSS VDD VDD sky130_fd_sc_hd__decap_12
XFILLER_15_405 VSS VSS VDD VDD sky130_fd_sc_hd__fill_2
XTAP_TAPCELL_ROW_12_149 VSS VDD sky130_fd_sc_hd__tapvpwrvgnd_1
XFILLER_12_83 VSS VSS VDD VDD sky130_fd_sc_hd__fill_1
XFILLER_10_165 VSS VSS VDD VDD sky130_fd_sc_hd__decap_12
XFILLER_10_121 VSS VSS VDD VDD sky130_fd_sc_hd__decap_12
XFILLER_17_39 VSS VSS VDD VDD sky130_fd_sc_hd__decap_12
XTAP_TAPCELL_ROW_25_241 VSS VDD sky130_fd_sc_hd__tapvpwrvgnd_1
XFILLER_15_279 VSS VSS VDD VDD sky130_fd_sc_hd__fill_1
XFILLER_23_93 VSS VSS VDD VDD sky130_fd_sc_hd__decap_12
XFILLER_21_249 VSS VSS VDD VDD sky130_fd_sc_hd__decap_12
XFILLER_21_205 VSS VSS VDD VDD sky130_fd_sc_hd__decap_12
XFILLER_9_51 VSS VSS VDD VDD sky130_fd_sc_hd__decap_4
XFILLER_0_97 VSS VSS VDD VDD sky130_fd_sc_hd__decap_12
XFILLER_0_53 VSS VSS VDD VDD sky130_fd_sc_hd__decap_3
XTAP_TAPCELL_ROW_22_222 VSS VDD sky130_fd_sc_hd__tapvpwrvgnd_1
XFILLER_8_209 VSS VSS VDD VDD sky130_fd_sc_hd__decap_12
XFILLER_0_109 VSS VSS VDD VDD sky130_fd_sc_hd__decap_3
XFILLER_11_293 VSS VSS VDD VDD sky130_fd_sc_hd__decap_12
XFILLER_22_3 VSS VSS VDD VDD sky130_fd_sc_hd__decap_12
XFILLER_19_393 VSS VSS VDD VDD sky130_fd_sc_hd__decap_12
XFILLER_14_29 VSS VSS VDD VDD sky130_fd_sc_hd__decap_12
XFILLER_25_385 VSS VSS VDD VDD sky130_fd_sc_hd__decap_6
XFILLER_20_83 VSS VSS VDD VDD sky130_fd_sc_hd__fill_1
XFILLER_4_245 VSS VSS VDD VDD sky130_fd_sc_hd__decap_6
XFILLER_4_289 VSS VSS VDD VDD sky130_fd_sc_hd__decap_12
XFILLER_16_363 VSS VSS VDD VDD sky130_fd_sc_hd__fill_1
XPHY_EDGE_ROW_16_Left_44 VSS VSS VDD VDD sky130_fd_sc_hd__decap_3
XFILLER_6_41 VSS VSS VDD VDD sky130_fd_sc_hd__decap_12
XFILLER_6_85 VSS VSS VDD VDD sky130_fd_sc_hd__decap_12
XFILLER_22_377 VSS VSS VDD VDD sky130_fd_sc_hd__decap_12
XFILLER_22_333 VSS VSS VDD VDD sky130_fd_sc_hd__decap_12
XFILLER_17_149 VSS VSS VDD VDD sky130_fd_sc_hd__decap_12
XFILLER_17_105 VSS VSS VDD VDD sky130_fd_sc_hd__decap_6
XFILLER_1_237 VSS VSS VDD VDD sky130_fd_sc_hd__decap_12
Xoutput3 _73_/Q VSS VSS VDD VDD counter_value_o[0] sky130_fd_sc_hd__buf_2
XFILLER_9_337 VSS VSS VDD VDD sky130_fd_sc_hd__decap_12
XFILLER_0_281 VSS VSS VDD VDD sky130_fd_sc_hd__decap_12
XFILLER_22_141 VSS VSS VDD VDD sky130_fd_sc_hd__decap_12
XFILLER_6_307 VSS VSS VDD VDD sky130_fd_sc_hd__fill_1
XPHY_EDGE_ROW_1_Left_29 VSS VSS VDD VDD sky130_fd_sc_hd__decap_3
XTAP_TAPCELL_ROW_15_169 VSS VDD sky130_fd_sc_hd__tapvpwrvgnd_1
XFILLER_9_167 VSS VSS VDD VDD sky130_fd_sc_hd__fill_1
XFILLER_5_373 VSS VSS VDD VDD sky130_fd_sc_hd__decap_12
XFILLER_22_29 VSS VSS VDD VDD sky130_fd_sc_hd__decap_12
XFILLER_27_277 VSS VSS VDD VDD sky130_fd_sc_hd__decap_3
XFILLER_10_177 VSS VSS VDD VDD sky130_fd_sc_hd__decap_12
XFILLER_10_133 VSS VSS VDD VDD sky130_fd_sc_hd__decap_6
XFILLER_2_321 VSS VSS VDD VDD sky130_fd_sc_hd__decap_12
XFILLER_2_365 VSS VSS VDD VDD sky130_fd_sc_hd__decap_12
XFILLER_18_277 VSS VSS VDD VDD sky130_fd_sc_hd__decap_12
XFILLER_18_233 VSS VSS VDD VDD sky130_fd_sc_hd__decap_12
XFILLER_5_181 VSS VSS VDD VDD sky130_fd_sc_hd__decap_12
X_69_ _69_/A VSS VSS VDD VDD _75_/D sky130_fd_sc_hd__buf_1
XFILLER_24_225 VSS VSS VDD VDD sky130_fd_sc_hd__decap_6
XFILLER_15_225 VSS VSS VDD VDD sky130_fd_sc_hd__decap_12
XTAP_TAPCELL_ROW_25_242 VSS VDD sky130_fd_sc_hd__tapvpwrvgnd_1
XFILLER_21_217 VSS VSS VDD VDD sky130_fd_sc_hd__decap_6
XFILLER_2_195 VSS VSS VDD VDD sky130_fd_sc_hd__fill_1
XPHY_EDGE_ROW_4_Left_32 VSS VSS VDD VDD sky130_fd_sc_hd__decap_3
XTAP_TAPCELL_ROW_22_223 VSS VDD sky130_fd_sc_hd__tapvpwrvgnd_1
XFILLER_18_83 VSS VSS VDD VDD sky130_fd_sc_hd__fill_1
XFILLER_11_261 VSS VSS VDD VDD sky130_fd_sc_hd__decap_12
XFILLER_26_309 VSS VSS VDD VDD sky130_fd_sc_hd__decap_12
XFILLER_19_361 VSS VSS VDD VDD sky130_fd_sc_hd__decap_12
XFILLER_15_3 VSS VSS VDD VDD sky130_fd_sc_hd__decap_12
XFILLER_14_19 VSS VSS VDD VDD sky130_fd_sc_hd__decap_8
XFILLER_6_53 VSS VSS VDD VDD sky130_fd_sc_hd__decap_12
XFILLER_6_97 VSS VSS VDD VDD sky130_fd_sc_hd__decap_12
XFILLER_26_139 VSS VSS VDD VDD sky130_fd_sc_hd__fill_1
XFILLER_22_389 VSS VSS VDD VDD sky130_fd_sc_hd__decap_12
XFILLER_22_345 VSS VSS VDD VDD sky130_fd_sc_hd__decap_12
XFILLER_22_301 VSS VSS VDD VDD sky130_fd_sc_hd__decap_6
XFILLER_1_249 VSS VSS VDD VDD sky130_fd_sc_hd__decap_12
XFILLER_1_205 VSS VSS VDD VDD sky130_fd_sc_hd__decap_12
Xoutput4 _74_/Q VSS VSS VDD VDD counter_value_o[1] sky130_fd_sc_hd__buf_2
XFILLER_25_194 VSS VSS VDD VDD sky130_fd_sc_hd__decap_12
XFILLER_15_51 VSS VSS VDD VDD sky130_fd_sc_hd__decap_4
XFILLER_9_349 VSS VSS VDD VDD sky130_fd_sc_hd__decap_12
XFILLER_9_305 VSS VSS VDD VDD sky130_fd_sc_hd__decap_12
XFILLER_0_293 VSS VSS VDD VDD sky130_fd_sc_hd__decap_12
XTAP_TAPCELL_ROW_18_189 VSS VDD sky130_fd_sc_hd__tapvpwrvgnd_1
XFILLER_14_109 VSS VSS VDD VDD sky130_fd_sc_hd__decap_12
XFILLER_22_197 VSS VSS VDD VDD sky130_fd_sc_hd__decap_12
XFILLER_22_153 VSS VSS VDD VDD sky130_fd_sc_hd__decap_12
XFILLER_9_113 VSS VSS VDD VDD sky130_fd_sc_hd__decap_12
XFILLER_5_385 VSS VSS VDD VDD sky130_fd_sc_hd__decap_6
XFILLER_12_85 VSS VSS VDD VDD sky130_fd_sc_hd__decap_12
XFILLER_12_41 VSS VSS VDD VDD sky130_fd_sc_hd__decap_12
XFILLER_10_189 VSS VSS VDD VDD sky130_fd_sc_hd__decap_6
XTAP_TAPCELL_ROW_6_105 VSS VDD sky130_fd_sc_hd__tapvpwrvgnd_1
XPHY_EDGE_ROW_25_Right_25 VSS VSS VDD VDD sky130_fd_sc_hd__decap_3
XFILLER_18_289 VSS VSS VDD VDD sky130_fd_sc_hd__decap_12
XFILLER_18_245 VSS VSS VDD VDD sky130_fd_sc_hd__decap_6
XPHY_EDGE_ROW_16_Right_16 VSS VSS VDD VDD sky130_fd_sc_hd__decap_3
XTAP_TAPCELL_ROW_11_140 VSS VDD sky130_fd_sc_hd__tapvpwrvgnd_1
XFILLER_2_333 VSS VSS VDD VDD sky130_fd_sc_hd__decap_12
XFILLER_2_377 VSS VSS VDD VDD sky130_fd_sc_hd__decap_12
XFILLER_5_193 VSS VSS VDD VDD sky130_fd_sc_hd__decap_12
X_68_ _68_/A _68_/B VSS VSS VDD VDD _69_/A sky130_fd_sc_hd__and2_1
XTAP_TAPCELL_ROW_25_243 VSS VDD sky130_fd_sc_hd__tapvpwrvgnd_1
XFILLER_23_281 VSS VSS VDD VDD sky130_fd_sc_hd__decap_12
XFILLER_23_51 VSS VSS VDD VDD sky130_fd_sc_hd__decap_4
XFILLER_15_237 VSS VSS VDD VDD sky130_fd_sc_hd__decap_12
XFILLER_2_141 VSS VSS VDD VDD sky130_fd_sc_hd__decap_12
XFILLER_20_251 VSS VSS VDD VDD sky130_fd_sc_hd__fill_1
XFILLER_19_373 VSS VSS VDD VDD sky130_fd_sc_hd__decap_12
XFILLER_11_273 VSS VSS VDD VDD sky130_fd_sc_hd__decap_6
XTAP_TAPCELL_ROW_5_98 VSS VDD sky130_fd_sc_hd__tapvpwrvgnd_1
XPHY_EDGE_ROW_2_Right_2 VSS VSS VDD VDD sky130_fd_sc_hd__decap_3
XFILLER_20_85 VSS VSS VDD VDD sky130_fd_sc_hd__decap_12
XFILLER_20_41 VSS VSS VDD VDD sky130_fd_sc_hd__decap_12
XFILLER_16_365 VSS VSS VDD VDD sky130_fd_sc_hd__decap_12
XFILLER_16_321 VSS VSS VDD VDD sky130_fd_sc_hd__decap_12
XFILLER_6_65 VSS VSS VDD VDD sky130_fd_sc_hd__decap_12
XFILLER_26_107 VSS VSS VDD VDD sky130_fd_sc_hd__decap_4
Xclkbuf_0_clock_i clock_i VSS VSS VDD VDD clkbuf_0_clock_i/X sky130_fd_sc_hd__clkbuf_16
XFILLER_22_357 VSS VSS VDD VDD sky130_fd_sc_hd__decap_6
XFILLER_19_181 VSS VSS VDD VDD sky130_fd_sc_hd__decap_12
XFILLER_1_217 VSS VSS VDD VDD sky130_fd_sc_hd__decap_6
Xoutput5 _75_/Q VSS VSS VDD VDD counter_value_o[2] sky130_fd_sc_hd__buf_2
XFILLER_13_335 VSS VSS VDD VDD sky130_fd_sc_hd__fill_1
XFILLER_9_317 VSS VSS VDD VDD sky130_fd_sc_hd__decap_12
XTAP_TAPCELL_ROW_2_77 VSS VDD sky130_fd_sc_hd__tapvpwrvgnd_1
XFILLER_16_195 VSS VSS VDD VDD sky130_fd_sc_hd__fill_1
XFILLER_22_165 VSS VSS VDD VDD sky130_fd_sc_hd__decap_12
XFILLER_22_121 VSS VSS VDD VDD sky130_fd_sc_hd__decap_12
XFILLER_6_309 VSS VSS VDD VDD sky130_fd_sc_hd__decap_12
XFILLER_9_169 VSS VSS VDD VDD sky130_fd_sc_hd__decap_12
XFILLER_9_125 VSS VSS VDD VDD sky130_fd_sc_hd__decap_12
XFILLER_3_55 VSS VSS VDD VDD sky130_fd_sc_hd__fill_1
XTAP_TAPCELL_ROW_6_106 VSS VDD sky130_fd_sc_hd__tapvpwrvgnd_1
XFILLER_26_290 VSS VSS VDD VDD sky130_fd_sc_hd__fill_2
XFILLER_12_97 VSS VSS VDD VDD sky130_fd_sc_hd__decap_12
XFILLER_12_53 VSS VSS VDD VDD sky130_fd_sc_hd__decap_12
XTAP_TAPCELL_ROW_11_141 VSS VDD sky130_fd_sc_hd__tapvpwrvgnd_1
XFILLER_2_301 VSS VSS VDD VDD sky130_fd_sc_hd__decap_6
XFILLER_2_345 VSS VSS VDD VDD sky130_fd_sc_hd__decap_12
XFILLER_2_389 VSS VSS VDD VDD sky130_fd_sc_hd__decap_12
XFILLER_5_3 VSS VSS VDD VDD sky130_fd_sc_hd__decap_12
XFILLER_6_139 VSS VSS VDD VDD sky130_fd_sc_hd__fill_1
X_67_ _75_/Q _67_/B VSS VSS VDD VDD _68_/B sky130_fd_sc_hd__xnor2_1
XFILLER_5_161 VSS VSS VDD VDD sky130_fd_sc_hd__decap_6
XTAP_TAPCELL_ROW_25_244 VSS VDD sky130_fd_sc_hd__tapvpwrvgnd_1
XFILLER_23_293 VSS VSS VDD VDD sky130_fd_sc_hd__decap_12
XFILLER_15_249 VSS VSS VDD VDD sky130_fd_sc_hd__decap_12
XFILLER_15_205 VSS VSS VDD VDD sky130_fd_sc_hd__decap_12
XFILLER_2_153 VSS VSS VDD VDD sky130_fd_sc_hd__decap_12
XFILLER_2_197 VSS VSS VDD VDD sky130_fd_sc_hd__decap_12
XFILLER_18_85 VSS VSS VDD VDD sky130_fd_sc_hd__decap_12
XFILLER_18_41 VSS VSS VDD VDD sky130_fd_sc_hd__decap_12
XFILLER_19_385 VSS VSS VDD VDD sky130_fd_sc_hd__decap_6
XTAP_TAPCELL_ROW_5_99 VSS VDD sky130_fd_sc_hd__tapvpwrvgnd_1
XFILLER_7_223 VSS VSS VDD VDD sky130_fd_sc_hd__fill_1
XFILLER_25_300 VSS VSS VDD VDD sky130_fd_sc_hd__decap_12
XFILLER_20_97 VSS VSS VDD VDD sky130_fd_sc_hd__decap_12
XFILLER_20_53 VSS VSS VDD VDD sky130_fd_sc_hd__decap_12
XFILLER_16_377 VSS VSS VDD VDD sky130_fd_sc_hd__decap_12
XFILLER_16_333 VSS VSS VDD VDD sky130_fd_sc_hd__decap_12
XFILLER_19_193 VSS VSS VDD VDD sky130_fd_sc_hd__decap_12
XFILLER_20_3 VSS VSS VDD VDD sky130_fd_sc_hd__decap_12
XFILLER_3_281 VSS VSS VDD VDD sky130_fd_sc_hd__decap_12
XFILLER_6_77 VSS VSS VDD VDD sky130_fd_sc_hd__decap_6
Xoutput6 _76_/Q VSS VSS VDD VDD counter_value_o[3] sky130_fd_sc_hd__buf_2
XFILLER_25_141 VSS VSS VDD VDD sky130_fd_sc_hd__decap_12
XFILLER_21_391 VSS VSS VDD VDD sky130_fd_sc_hd__fill_1
XFILLER_9_329 VSS VSS VDD VDD sky130_fd_sc_hd__decap_6
XTAP_TAPCELL_ROW_2_78 VSS VDD sky130_fd_sc_hd__tapvpwrvgnd_1
XFILLER_16_141 VSS VSS VDD VDD sky130_fd_sc_hd__decap_12
.ends

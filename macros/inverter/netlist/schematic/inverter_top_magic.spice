** sch_path: /foss/designs/sky130A-ams-chip-template/macros/inverter/schematic/xschem/inverter_top.sch
.subckt inverter_top VDD vin4 vout4 VSS vin3 vout3 vin2 vout2 vout1 vin1
*.PININFO vin4:I VDD:B VSS:B vout4:B vin3:I vin2:I vin1:I vout3:B vout2:B vout1:B
x1 VDD vin1 vout1 VSS inverter
x2 VDD vin2 vout2 VSS inverter
x3 VDD vin3 vout3 VSS inverter
x4 VDD vin4 vout4 VSS inverter
.ends

* expanding   symbol:  inverter.sym # of pins=4
** sym_path: /foss/designs/sky130A-ams-chip-template/macros/inverter/schematic/xschem/inverter.sym
** sch_path: /foss/designs/sky130A-ams-chip-template/macros/inverter/schematic/xschem/inverter.sch
.subckt inverter VDD vin vout VSS
*.PININFO vin:I VDD:B VSS:B vout:B
XMdummy1 VSS VSS VSS VSS sky130_fd_pr__nfet_01v8 L=1.0 W=2 nf=2 ad=0.29 as=0.58 pd=2.58 ps=5.16 nrd=0.145 nrs=0.145 sa=0 sb=0 sd=0
+ mult=1
XMdummy2 VDD VDD VDD VDD sky130_fd_pr__pfet_01v8_lvt L=1.0 W=4 nf=2 ad=0.58 as=1.16 pd=4.58 ps=9.16 nrd=0.0725 nrs=0.0725 sa=0
+ sb=0 sd=0 mult=1
XM1 vout vin VSS VSS sky130_fd_pr__nfet_01v8 L=1.0 W=20 nf=20 ad=2.9 as=3.19 pd=25.8 ps=28.38 nrd=0.0145 nrs=0.0145 sa=0 sb=0 sd=0
+ mult=1
XM2 vout vin VDD VDD sky130_fd_pr__pfet_01v8_lvt L=1.0 W=40 nf=20 ad=5.8 as=6.38 pd=45.8 ps=50.38 nrd=0.00725 nrs=0.00725 sa=0
+ sb=0 sd=0 mult=1
.ends

** sch_path: /foss/designs/sky130A-ams-chip-template/macros/inverter/schematic/xschem/inverter.sch
.subckt inverter VDD vin vout VSS
*.PININFO vin:I VDD:B VSS:B vout:B
Mdummy1 VSS VSS VSS VSS sky130_fd_pr__nfet_01v8 L=1.0u W=2u nf=2
Mdummy2 VDD VDD VDD VDD sky130_fd_pr__pfet_01v8_lvt L=1.0u W=4u nf=2
M1 vout vin VSS VSS sky130_fd_pr__nfet_01v8 L=1.0u W=20u nf=20
M2 vout vin VDD VDD sky130_fd_pr__pfet_01v8_lvt L=1.0u W=40u nf=20
.ends

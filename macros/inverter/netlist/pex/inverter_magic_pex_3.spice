* PEX produced on Fri Sep 18 02:44:35 PM CEST 2026 using /foss/tools/sak/sak-pex.sh with m=3 and s=1 (extresist threshold=10000 mOhm, minres=1000 mOhm, mindelay=1 ps)
* NGSPICE file created from inverter_pex.ext - technology: sky130A

.subckt inverter_pex VDD vin vout VSS
X0 vout vin VDD VDD sky130_fd_pr__pfet_01v8_lvt ad=0.3 pd=2.3 as=0.3 ps=2.3 w=2 l=1
X1 VDD vin vout VDD sky130_fd_pr__pfet_01v8_lvt ad=0.3 pd=2.3 as=0.3 ps=2.3 w=2 l=1
X2 vout vin VDD VDD sky130_fd_pr__pfet_01v8_lvt ad=0.3 pd=2.3 as=0.3 ps=2.3 w=2 l=1
X3 vout vin VSS.t3 VSS.t14 sky130_fd_pr__nfet_01v8 ad=0.15 pd=1.3 as=0.15 ps=1.3 w=1 l=1
X4 vout vin VSS.t3 VSS.t16 sky130_fd_pr__nfet_01v8 ad=0.15 pd=1.3 as=0.15 ps=1.3 w=1 l=1
X5 vout vin VSS.t3 VSS.t18 sky130_fd_pr__nfet_01v8 ad=0.15 pd=1.3 as=0.15 ps=1.3 w=1 l=1
X6 VSS.t3 VSS.t24 VSS.t3 VSS.t25 sky130_fd_pr__nfet_01v8 ad=0.15 pd=1.3 as=0 ps=0 w=1 l=1
X7 VDD vin vout VDD sky130_fd_pr__pfet_01v8_lvt ad=0.3 pd=2.3 as=0.3 ps=2.3 w=2 l=1
X8 VDD vin vout VDD sky130_fd_pr__pfet_01v8_lvt ad=0.3 pd=2.3 as=0.3 ps=2.3 w=2 l=1
X9 VSS.t3 vin vout VSS.t13 sky130_fd_pr__nfet_01v8 ad=0.15 pd=1.3 as=0.15 ps=1.3 w=1 l=1
X10 VSS.t3 vin vout VSS.t15 sky130_fd_pr__nfet_01v8 ad=0.15 pd=1.3 as=0.15 ps=1.3 w=1 l=1
X11 VSS.t3 VSS.t22 VSS.t3 VSS.t23 sky130_fd_pr__nfet_01v8 ad=0.3 pd=2.6 as=0 ps=0 w=1 l=1
X12 VSS.t3 vin vout VSS.t9 sky130_fd_pr__nfet_01v8 ad=0.15 pd=1.3 as=0.15 ps=1.3 w=1 l=1
X13 VDD vin vout VDD sky130_fd_pr__pfet_01v8_lvt ad=0.3 pd=2.3 as=0.3 ps=2.3 w=2 l=1
X14 vout vin VDD VDD sky130_fd_pr__pfet_01v8_lvt ad=0.3 pd=2.3 as=0.3 ps=2.3 w=2 l=1
X15 vout vin VSS.t3 VSS.t4 sky130_fd_pr__nfet_01v8 ad=0.15 pd=1.3 as=0.15 ps=1.3 w=1 l=1
X16 VDD vin vout VDD sky130_fd_pr__pfet_01v8_lvt ad=0.3 pd=2.3 as=0.3 ps=2.3 w=2 l=1
X17 vout vin VDD VDD sky130_fd_pr__pfet_01v8_lvt ad=0.3 pd=2.3 as=0.3 ps=2.3 w=2 l=1
X18 vout vin VSS.t1 VSS.t0 sky130_fd_pr__nfet_01v8 ad=0.15 pd=1.3 as=0.3 ps=2.6 w=1 l=1
X19 vout vin VSS.t3 VSS.t12 sky130_fd_pr__nfet_01v8 ad=0.15 pd=1.3 as=0.15 ps=1.3 w=1 l=1
X20 vout vin VSS.t3 VSS.t10 sky130_fd_pr__nfet_01v8 ad=0.15 pd=1.3 as=0.15 ps=1.3 w=1 l=1
X21 VSS.t3 vin vout VSS.t2 sky130_fd_pr__nfet_01v8 ad=0.15 pd=1.3 as=0.15 ps=1.3 w=1 l=1
X22 vout vin VDD VDD sky130_fd_pr__pfet_01v8_lvt ad=0.3 pd=2.3 as=0.3 ps=2.3 w=2 l=1
X23 VDD vin vout VDD sky130_fd_pr__pfet_01v8_lvt ad=0.3 pd=2.3 as=0.3 ps=2.3 w=2 l=1
X24 vout vin VDD VDD sky130_fd_pr__pfet_01v8_lvt ad=0.3 pd=2.3 as=0.3 ps=2.3 w=2 l=1
X25 VDD vin vout VDD sky130_fd_pr__pfet_01v8_lvt ad=0.6 pd=4.6 as=0.3 ps=2.3 w=2 l=1
X26 vout vin VDD VDD sky130_fd_pr__pfet_01v8_lvt ad=0.3 pd=2.3 as=0.6 ps=4.6 w=2 l=1
X27 VDD VDD VDD VDD sky130_fd_pr__pfet_01v8_lvt ad=0.3 pd=2.3 as=8.4 ps=64.4 w=2 l=1
X28 VSS.t3 vin vout VSS.t5 sky130_fd_pr__nfet_01v8 ad=0.15 pd=1.3 as=0.15 ps=1.3 w=1 l=1
X29 VSS.t3 vin vout VSS.t7 sky130_fd_pr__nfet_01v8 ad=0.15 pd=1.3 as=0.15 ps=1.3 w=1 l=1
X30 VSS.t3 vin vout VSS.t11 sky130_fd_pr__nfet_01v8 ad=0.15 pd=1.3 as=0.15 ps=1.3 w=1 l=1
X31 vout vin VDD VDD sky130_fd_pr__pfet_01v8_lvt ad=0.3 pd=2.3 as=0.3 ps=2.3 w=2 l=1
X32 vout vin VSS.t3 VSS.t6 sky130_fd_pr__nfet_01v8 ad=0.15 pd=1.3 as=0.15 ps=1.3 w=1 l=1
X33 vout vin VSS.t3 VSS.t8 sky130_fd_pr__nfet_01v8 ad=0.15 pd=1.3 as=0.15 ps=1.3 w=1 l=1
X34 vout vin VDD VDD sky130_fd_pr__pfet_01v8_lvt ad=0.3 pd=2.3 as=0.3 ps=2.3 w=2 l=1
X35 VDD VDD VDD VDD sky130_fd_pr__pfet_01v8_lvt ad=0.6 pd=4.6 as=0 ps=0 w=2 l=1
X36 VDD vin vout VDD sky130_fd_pr__pfet_01v8_lvt ad=0.3 pd=2.3 as=0.3 ps=2.3 w=2 l=1
X37 vout vin VDD VDD sky130_fd_pr__pfet_01v8_lvt ad=0.3 pd=2.3 as=0.3 ps=2.3 w=2 l=1
X38 VDD vin vout VDD sky130_fd_pr__pfet_01v8_lvt ad=0.3 pd=2.3 as=0.3 ps=2.3 w=2 l=1
X39 vout vin VSS.t3 VSS.t20 sky130_fd_pr__nfet_01v8 ad=0.15 pd=1.3 as=0.15 ps=1.3 w=1 l=1
X40 VDD vin vout VDD sky130_fd_pr__pfet_01v8_lvt ad=0.3 pd=2.3 as=0.3 ps=2.3 w=2 l=1
X41 VSS.t3 vin vout VSS.t17 sky130_fd_pr__nfet_01v8 ad=0.15 pd=1.3 as=0.15 ps=1.3 w=1 l=1
X42 VSS.t3 vin vout VSS.t19 sky130_fd_pr__nfet_01v8 ad=0.15 pd=1.3 as=0.15 ps=1.3 w=1 l=1
X43 VSS.t3 vin vout VSS.t21 sky130_fd_pr__nfet_01v8 ad=0.3 pd=2.6 as=0.15 ps=1.3 w=1 l=1
R0 VSS.n353 VSS.n352 585
R1 VSS.n324 VSS.n323 585
R2 VSS.n338 VSS.n337 585
R3 VSS.n339 VSS.n336 585
R4 VSS.n350 VSS.n328 585
R5 VSS.n340 VSS.n328 585
R6 VSS.n341 VSS.n335 585
R7 VSS.n56 VSS.n334 585
R8 VSS.n350 VSS.n325 585
R9 VSS.n342 VSS.n325 585
R10 VSS.n343 VSS.n333 585
R11 VSS.n344 VSS.n332 585
R12 VSS.n350 VSS.n330 585
R13 VSS.n345 VSS.n330 585
R14 VSS.n107 VSS.n331 585
R15 VSS.n348 VSS.n347 585
R16 VSS.n320 VSS.n319 585
R17 VSS.n321 VSS.n320 585
R18 VSS.n356 VSS.n355 585
R19 VSS.n355 VSS.n354 585
R20 VSS.n314 VSS.n313 585
R21 VSS.n313 VSS.n312 585
R22 VSS.n362 VSS.n361 585
R23 VSS.n363 VSS.n362 585
R24 VSS.n310 VSS.n309 585
R25 VSS.n311 VSS.n310 585
R26 VSS.n366 VSS.n365 585
R27 VSS.n365 VSS.n364 585
R28 VSS.n304 VSS.n303 585
R29 VSS.n303 VSS.n302 585
R30 VSS.n372 VSS.n371 585
R31 VSS.n373 VSS.n372 585
R32 VSS.n300 VSS.n299 585
R33 VSS.n301 VSS.n300 585
R34 VSS.n376 VSS.n375 585
R35 VSS.n375 VSS.n374 585
R36 VSS.n294 VSS.n293 585
R37 VSS.n293 VSS.n292 585
R38 VSS.n382 VSS.n381 585
R39 VSS.n383 VSS.n382 585
R40 VSS.n290 VSS.n289 585
R41 VSS.n291 VSS.n290 585
R42 VSS.n386 VSS.n385 585
R43 VSS.n385 VSS.n384 585
R44 VSS.n284 VSS.n283 585
R45 VSS.n283 VSS.n282 585
R46 VSS.n392 VSS.n391 585
R47 VSS.n393 VSS.n392 585
R48 VSS.n280 VSS.n279 585
R49 VSS.n281 VSS.n280 585
R50 VSS.n396 VSS.n395 585
R51 VSS.n395 VSS.n394 585
R52 VSS.n273 VSS.n272 585
R53 VSS.n272 VSS.n271 585
R54 VSS.n402 VSS.n401 585
R55 VSS.n403 VSS.n402 585
R56 VSS.n274 VSS.n269 585
R57 VSS.n270 VSS.n269 585
R58 VSS.n406 VSS.n405 585
R59 VSS.n405 VSS.n404 585
R60 VSS.n263 VSS.n262 585
R61 VSS.n262 VSS.n261 585
R62 VSS.n412 VSS.n411 585
R63 VSS.n413 VSS.n412 585
R64 VSS.n264 VSS.n259 585
R65 VSS.n260 VSS.n259 585
R66 VSS.n416 VSS.n415 585
R67 VSS.n415 VSS.n414 585
R68 VSS.n253 VSS.n252 585
R69 VSS.n252 VSS.n251 585
R70 VSS.n422 VSS.n421 585
R71 VSS.n423 VSS.n422 585
R72 VSS.n254 VSS.n250 585
R73 VSS.n88 VSS.n250 585
R74 VSS.n426 VSS.n425 585
R75 VSS.n425 VSS.n424 585
R76 VSS.n245 VSS.n244 585
R77 VSS.n244 VSS.n243 585
R78 VSS.n432 VSS.n431 585
R79 VSS.n433 VSS.n432 585
R80 VSS.n241 VSS.n240 585
R81 VSS.n242 VSS.n241 585
R82 VSS.n436 VSS.n435 585
R83 VSS.n435 VSS.n434 585
R84 VSS.n235 VSS.n234 585
R85 VSS.n234 VSS.n233 585
R86 VSS.n442 VSS.n441 585
R87 VSS.n443 VSS.n442 585
R88 VSS.n231 VSS.n230 585
R89 VSS.n232 VSS.n231 585
R90 VSS.n447 VSS.n445 585
R91 VSS.n445 VSS.n444 585
R92 VSS.n446 VSS.n225 585
R93 VSS.n225 VSS.n224 585
R94 VSS.n453 VSS.n452 585
R95 VSS.n454 VSS.n453 585
R96 VSS.n222 VSS.n221 585
R97 VSS.n223 VSS.n222 585
R98 VSS.n458 VSS.n456 585
R99 VSS.n456 VSS.n455 585
R100 VSS.n457 VSS.n216 585
R101 VSS.n216 VSS.n215 585
R102 VSS.n464 VSS.n463 585
R103 VSS.n465 VSS.n464 585
R104 VSS.n213 VSS.n212 585
R105 VSS.n214 VSS.n213 585
R106 VSS.n469 VSS.n467 585
R107 VSS.n467 VSS.n466 585
R108 VSS.n468 VSS.n207 585
R109 VSS.n207 VSS.n206 585
R110 VSS.n475 VSS.n474 585
R111 VSS.n476 VSS.n475 585
R112 VSS.n204 VSS.n203 585
R113 VSS.n205 VSS.n204 585
R114 VSS.n479 VSS.n478 585
R115 VSS.n478 VSS.n477 585
R116 VSS.n198 VSS.n197 585
R117 VSS.n197 VSS.n196 585
R118 VSS.n485 VSS.n484 585
R119 VSS.n486 VSS.n485 585
R120 VSS.n194 VSS.n193 585
R121 VSS.n195 VSS.n194 585
R122 VSS.n489 VSS.n488 585
R123 VSS.n488 VSS.n487 585
R124 VSS.n188 VSS.n187 585
R125 VSS.n187 VSS.n186 585
R126 VSS.n495 VSS.n494 585
R127 VSS.n496 VSS.n495 585
R128 VSS.n184 VSS.n183 585
R129 VSS.n185 VSS.n184 585
R130 VSS.n499 VSS.n498 585
R131 VSS.n498 VSS.n497 585
R132 VSS.n177 VSS.n176 585
R133 VSS.n176 VSS.n175 585
R134 VSS.n505 VSS.n504 585
R135 VSS.n506 VSS.n505 585
R136 VSS.n178 VSS.n173 585
R137 VSS.n174 VSS.n173 585
R138 VSS.n509 VSS.n508 585
R139 VSS.n508 VSS.n507 585
R140 VSS.n167 VSS.n166 585
R141 VSS.n166 VSS.n165 585
R142 VSS.n515 VSS.n514 585
R143 VSS.n516 VSS.n515 585
R144 VSS.n168 VSS.n164 585
R145 VSS.n75 VSS.n164 585
R146 VSS.n519 VSS.n518 585
R147 VSS.n518 VSS.n517 585
R148 VSS.n159 VSS.n158 585
R149 VSS.n158 VSS.n157 585
R150 VSS.n525 VSS.n524 585
R151 VSS.n526 VSS.n525 585
R152 VSS.n155 VSS.n154 585
R153 VSS.n156 VSS.n155 585
R154 VSS.n529 VSS.n528 585
R155 VSS.n528 VSS.n527 585
R156 VSS.n149 VSS.n148 585
R157 VSS.n148 VSS.n147 585
R158 VSS.n535 VSS.n534 585
R159 VSS.n536 VSS.n535 585
R160 VSS.n145 VSS.n144 585
R161 VSS.n146 VSS.n145 585
R162 VSS.n539 VSS.n538 585
R163 VSS.n538 VSS.n537 585
R164 VSS.n139 VSS.n138 585
R165 VSS.n138 VSS.n137 585
R166 VSS.n545 VSS.n544 585
R167 VSS.n546 VSS.n545 585
R168 VSS.n135 VSS.n134 585
R169 VSS.n136 VSS.n135 585
R170 VSS.n550 VSS.n548 585
R171 VSS.n548 VSS.n547 585
R172 VSS.n549 VSS.n129 585
R173 VSS.n129 VSS.n128 585
R174 VSS.n556 VSS.n555 585
R175 VSS.n557 VSS.n556 585
R176 VSS.n126 VSS.n125 585
R177 VSS.n127 VSS.n126 585
R178 VSS.n561 VSS.n559 585
R179 VSS.n559 VSS.n558 585
R180 VSS.n560 VSS.n117 585
R181 VSS.n117 VSS.n116 585
R182 VSS.n595 VSS.n594 585
R183 VSS.n596 VSS.n595 585
R184 VSS.n119 VSS.n118 585
R185 VSS.n118 VSS.n114 585
R186 VSS.n587 VSS.n115 585
R187 VSS.n597 VSS.n115 585
R188 VSS.n588 VSS.n113 585
R189 VSS.n598 VSS.n113 585
R190 VSS.n586 VSS.n112 585
R191 VSS.n586 VSS.n62 585
R192 VSS.n585 VSS.n63 585
R193 VSS.n583 VSS.n582 585
R194 VSS.n566 VSS.n565 585
R195 VSS.n581 VSS.n568 585
R196 VSS.n580 VSS.n569 585
R197 VSS.n579 VSS.n571 585
R198 VSS.n573 VSS.n572 585
R199 VSS.n578 VSS.n577 585
R200 VSS.n576 VSS.n110 585
R201 VSS.n604 VSS.n111 585
R202 VSS.n603 VSS.n602 585
R203 VSS.n600 VSS.n599 585
R204 VSS.n589 VSS.n588 585
R205 VSS.n590 VSS.n589 585
R206 VSS.n587 VSS.n564 585
R207 VSS.n591 VSS.n564 585
R208 VSS.n121 VSS.n119 585
R209 VSS.n11 VSS.n121 585
R210 VSS.n594 VSS.n593 585
R211 VSS.n593 VSS.n592 585
R212 VSS.n560 VSS.n120 585
R213 VSS.n122 VSS.n120 585
R214 VSS.n562 VSS.n561 585
R215 VSS.n563 VSS.n562 585
R216 VSS.n125 VSS.n124 585
R217 VSS.n124 VSS.n123 585
R218 VSS.n555 VSS.n554 585
R219 VSS.n554 VSS.n553 585
R220 VSS.n549 VSS.n130 585
R221 VSS.n131 VSS.n130 585
R222 VSS.n551 VSS.n550 585
R223 VSS.n552 VSS.n551 585
R224 VSS.n134 VSS.n133 585
R225 VSS.n133 VSS.n132 585
R226 VSS.n544 VSS.n543 585
R227 VSS.n543 VSS.n542 585
R228 VSS.n140 VSS.n139 585
R229 VSS.n141 VSS.n140 585
R230 VSS.n540 VSS.n539 585
R231 VSS.n541 VSS.n540 585
R232 VSS.n144 VSS.n143 585
R233 VSS.n143 VSS.n142 585
R234 VSS.n534 VSS.n533 585
R235 VSS.n533 VSS.n532 585
R236 VSS.n150 VSS.n149 585
R237 VSS.n151 VSS.n150 585
R238 VSS.n530 VSS.n529 585
R239 VSS.n531 VSS.n530 585
R240 VSS.n154 VSS.n153 585
R241 VSS.n153 VSS.n152 585
R242 VSS.n524 VSS.n523 585
R243 VSS.n523 VSS.n522 585
R244 VSS.n160 VSS.n159 585
R245 VSS.n161 VSS.n160 585
R246 VSS.n520 VSS.n519 585
R247 VSS.n521 VSS.n520 585
R248 VSS.n168 VSS.n163 585
R249 VSS.n163 VSS.n162 585
R250 VSS.n514 VSS.n513 585
R251 VSS.n513 VSS.n512 585
R252 VSS.n169 VSS.n167 585
R253 VSS.n170 VSS.n169 585
R254 VSS.n510 VSS.n509 585
R255 VSS.n511 VSS.n510 585
R256 VSS.n178 VSS.n172 585
R257 VSS.n172 VSS.n171 585
R258 VSS.n504 VSS.n503 585
R259 VSS.n503 VSS.n502 585
R260 VSS.n179 VSS.n177 585
R261 VSS.n180 VSS.n179 585
R262 VSS.n500 VSS.n499 585
R263 VSS.n501 VSS.n500 585
R264 VSS.n183 VSS.n182 585
R265 VSS.n182 VSS.n181 585
R266 VSS.n494 VSS.n493 585
R267 VSS.n493 VSS.n492 585
R268 VSS.n189 VSS.n188 585
R269 VSS.n190 VSS.n189 585
R270 VSS.n490 VSS.n489 585
R271 VSS.n491 VSS.n490 585
R272 VSS.n193 VSS.n192 585
R273 VSS.n192 VSS.n191 585
R274 VSS.n484 VSS.n483 585
R275 VSS.n483 VSS.n482 585
R276 VSS.n199 VSS.n198 585
R277 VSS.n200 VSS.n199 585
R278 VSS.n480 VSS.n479 585
R279 VSS.n481 VSS.n480 585
R280 VSS.n203 VSS.n202 585
R281 VSS.n202 VSS.n201 585
R282 VSS.n474 VSS.n473 585
R283 VSS.n473 VSS.n472 585
R284 VSS.n468 VSS.n208 585
R285 VSS.n209 VSS.n208 585
R286 VSS.n470 VSS.n469 585
R287 VSS.n471 VSS.n470 585
R288 VSS.n212 VSS.n211 585
R289 VSS.n211 VSS.n210 585
R290 VSS.n463 VSS.n462 585
R291 VSS.n462 VSS.n461 585
R292 VSS.n457 VSS.n217 585
R293 VSS.n218 VSS.n217 585
R294 VSS.n459 VSS.n458 585
R295 VSS.n460 VSS.n459 585
R296 VSS.n221 VSS.n220 585
R297 VSS.n220 VSS.n219 585
R298 VSS.n452 VSS.n451 585
R299 VSS.n451 VSS.n450 585
R300 VSS.n446 VSS.n226 585
R301 VSS.n227 VSS.n226 585
R302 VSS.n448 VSS.n447 585
R303 VSS.n449 VSS.n448 585
R304 VSS.n230 VSS.n229 585
R305 VSS.n229 VSS.n228 585
R306 VSS.n441 VSS.n440 585
R307 VSS.n440 VSS.n439 585
R308 VSS.n236 VSS.n235 585
R309 VSS.n237 VSS.n236 585
R310 VSS.n437 VSS.n436 585
R311 VSS.n438 VSS.n437 585
R312 VSS.n240 VSS.n239 585
R313 VSS.n239 VSS.n238 585
R314 VSS.n431 VSS.n430 585
R315 VSS.n430 VSS.n429 585
R316 VSS.n246 VSS.n245 585
R317 VSS.n247 VSS.n246 585
R318 VSS.n427 VSS.n426 585
R319 VSS.n428 VSS.n427 585
R320 VSS.n254 VSS.n249 585
R321 VSS.n249 VSS.n248 585
R322 VSS.n421 VSS.n420 585
R323 VSS.n420 VSS.n419 585
R324 VSS.n255 VSS.n253 585
R325 VSS.n256 VSS.n255 585
R326 VSS.n417 VSS.n416 585
R327 VSS.n418 VSS.n417 585
R328 VSS.n264 VSS.n258 585
R329 VSS.n258 VSS.n257 585
R330 VSS.n411 VSS.n410 585
R331 VSS.n410 VSS.n409 585
R332 VSS.n265 VSS.n263 585
R333 VSS.n266 VSS.n265 585
R334 VSS.n407 VSS.n406 585
R335 VSS.n408 VSS.n407 585
R336 VSS.n274 VSS.n268 585
R337 VSS.n268 VSS.n267 585
R338 VSS.n401 VSS.n400 585
R339 VSS.n400 VSS.n399 585
R340 VSS.n275 VSS.n273 585
R341 VSS.n276 VSS.n275 585
R342 VSS.n397 VSS.n396 585
R343 VSS.n398 VSS.n397 585
R344 VSS.n279 VSS.n278 585
R345 VSS.n278 VSS.n277 585
R346 VSS.n391 VSS.n390 585
R347 VSS.n390 VSS.n389 585
R348 VSS.n285 VSS.n284 585
R349 VSS.n286 VSS.n285 585
R350 VSS.n387 VSS.n386 585
R351 VSS.n388 VSS.n387 585
R352 VSS.n289 VSS.n288 585
R353 VSS.n288 VSS.n287 585
R354 VSS.n381 VSS.n380 585
R355 VSS.n380 VSS.n379 585
R356 VSS.n295 VSS.n294 585
R357 VSS.n296 VSS.n295 585
R358 VSS.n377 VSS.n376 585
R359 VSS.n378 VSS.n377 585
R360 VSS.n299 VSS.n298 585
R361 VSS.n298 VSS.n297 585
R362 VSS.n371 VSS.n370 585
R363 VSS.n370 VSS.n369 585
R364 VSS.n305 VSS.n304 585
R365 VSS.n306 VSS.n305 585
R366 VSS.n367 VSS.n366 585
R367 VSS.n368 VSS.n367 585
R368 VSS.n309 VSS.n308 585
R369 VSS.n308 VSS.n307 585
R370 VSS.n361 VSS.n360 585
R371 VSS.n360 VSS.n359 585
R372 VSS.n315 VSS.n314 585
R373 VSS.n316 VSS.n315 585
R374 VSS.n357 VSS.n356 585
R375 VSS.n358 VSS.n357 585
R376 VSS.n319 VSS.n318 585
R377 VSS.n318 VSS.n317 585
R378 VSS.n348 VSS.n318 580.811
R379 VSS.n352 VSS.n320 580.811
R380 VSS.n600 VSS.n113 580.811
R381 VSS.n589 VSS.n586 580.811
R382 VSS.n588 VSS.n112 253.964
R383 VSS.n350 VSS.n319 253.964
R384 VSS.n589 VSS.n564 244.553
R385 VSS.n564 VSS.n121 244.553
R386 VSS.n593 VSS.n121 244.553
R387 VSS.n593 VSS.n120 244.553
R388 VSS.n562 VSS.n120 244.553
R389 VSS.n562 VSS.n124 244.553
R390 VSS.n554 VSS.n124 244.553
R391 VSS.n554 VSS.n130 244.553
R392 VSS.n551 VSS.n130 244.553
R393 VSS.n551 VSS.n133 244.553
R394 VSS.n543 VSS.n133 244.553
R395 VSS.n543 VSS.n140 244.553
R396 VSS.n540 VSS.n140 244.553
R397 VSS.n540 VSS.n143 244.553
R398 VSS.n533 VSS.n143 244.553
R399 VSS.n533 VSS.n150 244.553
R400 VSS.n530 VSS.n150 244.553
R401 VSS.n530 VSS.n153 244.553
R402 VSS.n523 VSS.n153 244.553
R403 VSS.n523 VSS.n160 244.553
R404 VSS.n520 VSS.n160 244.553
R405 VSS.n520 VSS.n163 244.553
R406 VSS.n513 VSS.n163 244.553
R407 VSS.n513 VSS.n169 244.553
R408 VSS.n510 VSS.n169 244.553
R409 VSS.n510 VSS.n172 244.553
R410 VSS.n503 VSS.n172 244.553
R411 VSS.n503 VSS.n179 244.553
R412 VSS.n500 VSS.n179 244.553
R413 VSS.n500 VSS.n182 244.553
R414 VSS.n493 VSS.n182 244.553
R415 VSS.n493 VSS.n189 244.553
R416 VSS.n490 VSS.n189 244.553
R417 VSS.n490 VSS.n192 244.553
R418 VSS.n483 VSS.n192 244.553
R419 VSS.n483 VSS.n199 244.553
R420 VSS.n480 VSS.n199 244.553
R421 VSS.n480 VSS.n202 244.553
R422 VSS.n473 VSS.n202 244.553
R423 VSS.n473 VSS.n208 244.553
R424 VSS.n470 VSS.n208 244.553
R425 VSS.n470 VSS.n211 244.553
R426 VSS.n462 VSS.n211 244.553
R427 VSS.n462 VSS.n217 244.553
R428 VSS.n459 VSS.n217 244.553
R429 VSS.n459 VSS.n220 244.553
R430 VSS.n451 VSS.n220 244.553
R431 VSS.n451 VSS.n226 244.553
R432 VSS.n448 VSS.n226 244.553
R433 VSS.n448 VSS.n229 244.553
R434 VSS.n440 VSS.n229 244.553
R435 VSS.n440 VSS.n236 244.553
R436 VSS.n437 VSS.n236 244.553
R437 VSS.n437 VSS.n239 244.553
R438 VSS.n430 VSS.n239 244.553
R439 VSS.n430 VSS.n246 244.553
R440 VSS.n427 VSS.n246 244.553
R441 VSS.n427 VSS.n249 244.553
R442 VSS.n420 VSS.n249 244.553
R443 VSS.n420 VSS.n255 244.553
R444 VSS.n417 VSS.n255 244.553
R445 VSS.n417 VSS.n258 244.553
R446 VSS.n410 VSS.n258 244.553
R447 VSS.n410 VSS.n265 244.553
R448 VSS.n407 VSS.n265 244.553
R449 VSS.n407 VSS.n268 244.553
R450 VSS.n400 VSS.n268 244.553
R451 VSS.n400 VSS.n275 244.553
R452 VSS.n397 VSS.n275 244.553
R453 VSS.n397 VSS.n278 244.553
R454 VSS.n390 VSS.n278 244.553
R455 VSS.n390 VSS.n285 244.553
R456 VSS.n387 VSS.n285 244.553
R457 VSS.n387 VSS.n288 244.553
R458 VSS.n380 VSS.n288 244.553
R459 VSS.n380 VSS.n295 244.553
R460 VSS.n377 VSS.n295 244.553
R461 VSS.n377 VSS.n298 244.553
R462 VSS.n370 VSS.n298 244.553
R463 VSS.n370 VSS.n305 244.553
R464 VSS.n367 VSS.n305 244.553
R465 VSS.n367 VSS.n308 244.553
R466 VSS.n360 VSS.n308 244.553
R467 VSS.n360 VSS.n315 244.553
R468 VSS.n357 VSS.n315 244.553
R469 VSS.n357 VSS.n318 244.553
R470 VSS.n337 VSS.n324 244.553
R471 VSS.n336 VSS.n328 244.553
R472 VSS.n335 VSS.n328 244.553
R473 VSS.n334 VSS.n325 244.553
R474 VSS.n333 VSS.n325 244.553
R475 VSS.n332 VSS.n330 244.553
R476 VSS.n331 VSS.n330 244.553
R477 VSS.n115 VSS.n113 244.553
R478 VSS.n118 VSS.n115 244.553
R479 VSS.n595 VSS.n118 244.553
R480 VSS.n595 VSS.n117 244.553
R481 VSS.n559 VSS.n117 244.553
R482 VSS.n559 VSS.n126 244.553
R483 VSS.n556 VSS.n126 244.553
R484 VSS.n556 VSS.n129 244.553
R485 VSS.n548 VSS.n129 244.553
R486 VSS.n548 VSS.n135 244.553
R487 VSS.n545 VSS.n135 244.553
R488 VSS.n545 VSS.n138 244.553
R489 VSS.n538 VSS.n138 244.553
R490 VSS.n538 VSS.n145 244.553
R491 VSS.n535 VSS.n145 244.553
R492 VSS.n535 VSS.n148 244.553
R493 VSS.n528 VSS.n148 244.553
R494 VSS.n528 VSS.n155 244.553
R495 VSS.n525 VSS.n155 244.553
R496 VSS.n525 VSS.n158 244.553
R497 VSS.n518 VSS.n158 244.553
R498 VSS.n518 VSS.n164 244.553
R499 VSS.n515 VSS.n164 244.553
R500 VSS.n515 VSS.n166 244.553
R501 VSS.n508 VSS.n166 244.553
R502 VSS.n508 VSS.n173 244.553
R503 VSS.n505 VSS.n173 244.553
R504 VSS.n505 VSS.n176 244.553
R505 VSS.n498 VSS.n176 244.553
R506 VSS.n498 VSS.n184 244.553
R507 VSS.n495 VSS.n184 244.553
R508 VSS.n495 VSS.n187 244.553
R509 VSS.n488 VSS.n187 244.553
R510 VSS.n488 VSS.n194 244.553
R511 VSS.n485 VSS.n194 244.553
R512 VSS.n485 VSS.n197 244.553
R513 VSS.n478 VSS.n197 244.553
R514 VSS.n478 VSS.n204 244.553
R515 VSS.n475 VSS.n204 244.553
R516 VSS.n475 VSS.n207 244.553
R517 VSS.n467 VSS.n207 244.553
R518 VSS.n467 VSS.n213 244.553
R519 VSS.n464 VSS.n213 244.553
R520 VSS.n464 VSS.n216 244.553
R521 VSS.n456 VSS.n216 244.553
R522 VSS.n456 VSS.n222 244.553
R523 VSS.n453 VSS.n222 244.553
R524 VSS.n453 VSS.n225 244.553
R525 VSS.n445 VSS.n225 244.553
R526 VSS.n445 VSS.n231 244.553
R527 VSS.n442 VSS.n231 244.553
R528 VSS.n442 VSS.n234 244.553
R529 VSS.n435 VSS.n234 244.553
R530 VSS.n435 VSS.n241 244.553
R531 VSS.n432 VSS.n241 244.553
R532 VSS.n432 VSS.n244 244.553
R533 VSS.n425 VSS.n244 244.553
R534 VSS.n425 VSS.n250 244.553
R535 VSS.n422 VSS.n250 244.553
R536 VSS.n422 VSS.n252 244.553
R537 VSS.n415 VSS.n252 244.553
R538 VSS.n415 VSS.n259 244.553
R539 VSS.n412 VSS.n259 244.553
R540 VSS.n412 VSS.n262 244.553
R541 VSS.n405 VSS.n262 244.553
R542 VSS.n405 VSS.n269 244.553
R543 VSS.n402 VSS.n269 244.553
R544 VSS.n402 VSS.n272 244.553
R545 VSS.n395 VSS.n272 244.553
R546 VSS.n395 VSS.n280 244.553
R547 VSS.n392 VSS.n280 244.553
R548 VSS.n392 VSS.n283 244.553
R549 VSS.n385 VSS.n283 244.553
R550 VSS.n385 VSS.n290 244.553
R551 VSS.n382 VSS.n290 244.553
R552 VSS.n382 VSS.n293 244.553
R553 VSS.n375 VSS.n293 244.553
R554 VSS.n375 VSS.n300 244.553
R555 VSS.n372 VSS.n300 244.553
R556 VSS.n372 VSS.n303 244.553
R557 VSS.n365 VSS.n303 244.553
R558 VSS.n365 VSS.n310 244.553
R559 VSS.n362 VSS.n310 244.553
R560 VSS.n362 VSS.n313 244.553
R561 VSS.n355 VSS.n313 244.553
R562 VSS.n355 VSS.n320 244.553
R563 VSS.n602 VSS.n111 244.553
R564 VSS.n577 VSS.n576 244.553
R565 VSS.n573 VSS.n571 244.553
R566 VSS.n569 VSS.n568 244.553
R567 VSS.n583 VSS.n565 244.553
R568 VSS.n586 VSS.n585 244.553
R569 VSS.n351 VSS.n350 241.933
R570 VSS.n350 VSS.n327 241.933
R571 VSS.n350 VSS.n326 241.933
R572 VSS.n350 VSS.n329 241.933
R573 VSS.n350 VSS.n349 241.933
R574 VSS.n584 VSS.n112 241.933
R575 VSS.n567 VSS.n112 241.933
R576 VSS.n570 VSS.n112 241.933
R577 VSS.n574 VSS.n112 241.933
R578 VSS.n575 VSS.n112 241.933
R579 VSS.n601 VSS.n112 241.933
R580 VSS.n588 VSS.n587 220.306
R581 VSS.n587 VSS.n119 220.306
R582 VSS.n594 VSS.n119 220.306
R583 VSS.n561 VSS.n560 220.306
R584 VSS.n561 VSS.n125 220.306
R585 VSS.n555 VSS.n125 220.306
R586 VSS.n550 VSS.n549 220.306
R587 VSS.n550 VSS.n134 220.306
R588 VSS.n544 VSS.n139 220.306
R589 VSS.n539 VSS.n139 220.306
R590 VSS.n539 VSS.n144 220.306
R591 VSS.n534 VSS.n149 220.306
R592 VSS.n529 VSS.n149 220.306
R593 VSS.n529 VSS.n154 220.306
R594 VSS.n524 VSS.n159 220.306
R595 VSS.n519 VSS.n159 220.306
R596 VSS.n514 VSS.n168 220.306
R597 VSS.n514 VSS.n167 220.306
R598 VSS.n509 VSS.n167 220.306
R599 VSS.n504 VSS.n178 220.306
R600 VSS.n504 VSS.n177 220.306
R601 VSS.n499 VSS.n183 220.306
R602 VSS.n494 VSS.n183 220.306
R603 VSS.n494 VSS.n188 220.306
R604 VSS.n489 VSS.n193 220.306
R605 VSS.n484 VSS.n193 220.306
R606 VSS.n484 VSS.n198 220.306
R607 VSS.n479 VSS.n203 220.306
R608 VSS.n474 VSS.n203 220.306
R609 VSS.n469 VSS.n468 220.306
R610 VSS.n469 VSS.n212 220.306
R611 VSS.n463 VSS.n212 220.306
R612 VSS.n458 VSS.n457 220.306
R613 VSS.n458 VSS.n221 220.306
R614 VSS.n452 VSS.n221 220.306
R615 VSS.n447 VSS.n446 220.306
R616 VSS.n447 VSS.n230 220.306
R617 VSS.n441 VSS.n235 220.306
R618 VSS.n436 VSS.n235 220.306
R619 VSS.n436 VSS.n240 220.306
R620 VSS.n431 VSS.n245 220.306
R621 VSS.n426 VSS.n245 220.306
R622 VSS.n421 VSS.n254 220.306
R623 VSS.n421 VSS.n253 220.306
R624 VSS.n416 VSS.n253 220.306
R625 VSS.n411 VSS.n264 220.306
R626 VSS.n411 VSS.n263 220.306
R627 VSS.n406 VSS.n263 220.306
R628 VSS.n401 VSS.n274 220.306
R629 VSS.n401 VSS.n273 220.306
R630 VSS.n396 VSS.n279 220.306
R631 VSS.n391 VSS.n279 220.306
R632 VSS.n391 VSS.n284 220.306
R633 VSS.n386 VSS.n289 220.306
R634 VSS.n381 VSS.n289 220.306
R635 VSS.n381 VSS.n294 220.306
R636 VSS.n376 VSS.n294 220.306
R637 VSS.n376 VSS.n299 220.306
R638 VSS.n371 VSS.n304 220.306
R639 VSS.n366 VSS.n304 220.306
R640 VSS.n366 VSS.n309 220.306
R641 VSS.n361 VSS.n314 220.306
R642 VSS.n356 VSS.n314 220.306
R643 VSS.n356 VSS.n319 220.306
R644 VSS.t9 VSS.n177 214.186
R645 VSS.n446 VSS.t14 214.186
R646 VSS.t4 VSS.n134 201.947
R647 VSS.n274 VSS.t19 201.947
R648 VSS.n524 VSS.t6 189.708
R649 VSS.n426 VSS.t17 189.708
R650 VSS.n479 VSS.t11 177.47
R651 VSS.n474 VSS.t12 177.47
R652 VSS.n519 VSS.t7 165.23
R653 VSS.n431 VSS.t16 165.23
R654 VSS.n594 VSS.t0 152.99
R655 VSS.n549 VSS.t2 152.99
R656 VSS.t20 VSS.n273 152.99
R657 VSS.n386 VSS.t21 152.99
R658 VSS.t23 VSS.n299 152.99
R659 VSS.n361 VSS.t25 152.99
R660 VSS.n178 VSS.t8 140.751
R661 VSS.t15 VSS.n230 140.751
R662 VSS.t10 VSS.n188 128.512
R663 VSS.n457 VSS.t13 128.512
R664 VSS.t5 VSS.n144 116.273
R665 VSS.n264 VSS.t18 116.273
R666 VSS.n534 VSS.t5 104.034
R667 VSS.n416 VSS.t18 104.034
R668 VSS.n351 VSS.n324 101.138
R669 VSS.n336 VSS.n327 101.138
R670 VSS.n334 VSS.n326 101.138
R671 VSS.n332 VSS.n329 101.138
R672 VSS.n349 VSS.n331 101.138
R673 VSS.n585 VSS.n584 101.138
R674 VSS.n567 VSS.n565 101.138
R675 VSS.n570 VSS.n569 101.138
R676 VSS.n574 VSS.n573 101.138
R677 VSS.n576 VSS.n575 101.138
R678 VSS.n602 VSS.n601 101.138
R679 VSS.n352 VSS.n351 101.138
R680 VSS.n337 VSS.n327 101.138
R681 VSS.n335 VSS.n326 101.138
R682 VSS.n333 VSS.n329 101.138
R683 VSS.n349 VSS.n348 101.138
R684 VSS.n601 VSS.n600 101.138
R685 VSS.n575 VSS.n111 101.138
R686 VSS.n577 VSS.n574 101.138
R687 VSS.n571 VSS.n570 101.138
R688 VSS.n568 VSS.n567 101.138
R689 VSS.n584 VSS.n583 101.138
R690 VSS.n489 VSS.t10 91.7947
R691 VSS.n463 VSS.t13 91.7947
R692 VSS.n509 VSS.t8 79.5554
R693 VSS.n441 VSS.t15 79.5554
R694 VSS.n560 VSS.t0 67.3162
R695 VSS.n555 VSS.t2 67.3162
R696 VSS.n396 VSS.t20 67.3162
R697 VSS.t21 VSS.n284 67.3162
R698 VSS.n371 VSS.t23 67.3162
R699 VSS.t25 VSS.n309 67.3162
R700 VSS.n168 VSS.t7 55.077
R701 VSS.t16 VSS.n240 55.077
R702 VSS.t11 VSS.n198 42.8378
R703 VSS.n468 VSS.t12 42.8378
R704 VSS.n353 VSS.n67 6.2306
R705 VSS.n599 VSS.n598 37.7384
R706 VSS.n590 VSS.n62 37.7384
R707 VSS.n347 VSS.n317 37.7384
R708 VSS.t6 VSS.n154 30.5986
R709 VSS.n254 VSS.t17 30.5986
R710 VSS.n544 VSS.t4 18.3593
R711 VSS.n406 VSS.t19 18.3593
R712 VSS.n353 VSS.n323 15.8902
R713 VSS.n339 VSS.n338 15.8902
R714 VSS.n340 VSS.n55 4.28558
R715 VSS.n341 VSS.n340 15.8902
R716 VSS.n57 VSS.n56 4.28558
R717 VSS.n342 VSS.n56 15.8902
R718 VSS.n343 VSS.n58 4.28558
R719 VSS.n344 VSS.n343 15.8902
R720 VSS.n345 VSS.n107 15.8902
R721 VSS.n347 VSS.n10 4.28558
R722 VSS.n598 VSS.n597 15.8902
R723 VSS.n94 VSS.n114 4.28558
R724 VSS.n596 VSS.n114 15.8902
R725 VSS.n68 VSS.n116 4.28558
R726 VSS.n558 VSS.n116 15.8902
R727 VSS.n69 VSS.n127 4.28558
R728 VSS.n557 VSS.n127 15.8902
R729 VSS.n70 VSS.n128 4.28558
R730 VSS.n547 VSS.n128 15.8902
R731 VSS.n95 VSS.n136 4.28558
R732 VSS.n546 VSS.n136 15.8902
R733 VSS.n71 VSS.n137 4.28558
R734 VSS.n537 VSS.n137 15.8902
R735 VSS.n72 VSS.n146 4.28558
R736 VSS.n536 VSS.n146 15.8902
R737 VSS.n536 VSS.n147 15.8902
R738 VSS.n96 VSS.n147 4.28558
R739 VSS.n527 VSS.n156 15.8902
R740 VSS.n526 VSS.n73 4.28558
R741 VSS.n526 VSS.n157 15.8902
R742 VSS.n517 VSS.n74 4.28558
R743 VSS.n517 VSS.n75 15.8902
R744 VSS.n516 VSS.n75 15.8902
R745 VSS.n516 VSS.n106 4.28558
R746 VSS.n507 VSS.n165 15.8902
R747 VSS.n507 VSS.n174 15.8902
R748 VSS.n506 VSS.n76 4.28558
R749 VSS.n506 VSS.n175 15.8902
R750 VSS.n497 VSS.n77 4.28558
R751 VSS.n497 VSS.n185 15.8902
R752 VSS.n496 VSS.n103 4.28558
R753 VSS.n496 VSS.n186 15.8902
R754 VSS.n487 VSS.n186 15.8902
R755 VSS.n78 VSS.n195 4.28558
R756 VSS.n486 VSS.n195 15.8902
R757 VSS.n79 VSS.n196 4.28558
R758 VSS.n477 VSS.n196 15.8902
R759 VSS.n80 VSS.n205 4.28558
R760 VSS.n476 VSS.n205 15.8902
R761 VSS.n81 VSS.n206 4.28558
R762 VSS.n466 VSS.n206 15.8902
R763 VSS.n82 VSS.n214 4.28558
R764 VSS.n465 VSS.n214 15.8902
R765 VSS.n83 VSS.n215 4.28558
R766 VSS.n455 VSS.n215 15.8902
R767 VSS.n104 VSS.n223 4.28558
R768 VSS.n454 VSS.n223 15.8902
R769 VSS.n84 VSS.n224 4.28558
R770 VSS.n444 VSS.n224 15.8902
R771 VSS.n85 VSS.n232 4.28558
R772 VSS.n443 VSS.n232 15.8902
R773 VSS.n443 VSS.n233 15.8902
R774 VSS.n105 VSS.n233 4.28558
R775 VSS.n434 VSS.n242 15.8902
R776 VSS.n433 VSS.n86 4.28558
R777 VSS.n433 VSS.n243 15.8902
R778 VSS.n424 VSS.n87 4.28558
R779 VSS.n424 VSS.n88 15.8902
R780 VSS.n423 VSS.n88 15.8902
R781 VSS.n423 VSS.n102 4.28558
R782 VSS.n414 VSS.n251 15.8902
R783 VSS.n414 VSS.n260 15.8902
R784 VSS.n413 VSS.n89 4.28558
R785 VSS.n413 VSS.n261 15.8902
R786 VSS.n404 VSS.n90 4.28558
R787 VSS.n404 VSS.n270 15.8902
R788 VSS.n403 VSS.n97 4.28558
R789 VSS.n403 VSS.n271 15.8902
R790 VSS.n394 VSS.n91 4.28558
R791 VSS.n394 VSS.n281 15.8902
R792 VSS.n393 VSS.n92 4.28558
R793 VSS.n393 VSS.n282 15.8902
R794 VSS.n384 VSS.n93 4.28558
R795 VSS.n384 VSS.n291 15.8902
R796 VSS.n383 VSS.n98 4.28558
R797 VSS.n383 VSS.n292 15.8902
R798 VSS.n99 VSS.n292 4.28558
R799 VSS.n374 VSS.n301 15.8902
R800 VSS.n373 VSS.n66 4.28558
R801 VSS.n373 VSS.n302 15.8902
R802 VSS.n100 VSS.n302 4.28558
R803 VSS.n364 VSS.n311 15.8902
R804 VSS.n363 VSS.n65 4.28558
R805 VSS.n363 VSS.n312 15.8902
R806 VSS.n101 VSS.n312 4.28558
R807 VSS.n354 VSS.n321 15.8902
R808 VSS.n604 VSS.n603 15.8902
R809 VSS.n108 VSS.n110 4.28558
R810 VSS.n578 VSS.n110 15.8902
R811 VSS.n578 VSS.n572 15.8902
R812 VSS.n579 VSS.n59 4.28558
R813 VSS.n580 VSS.n579 15.8902
R814 VSS.n581 VSS.n60 4.28558
R815 VSS.n581 VSS.n566 15.8902
R816 VSS.n582 VSS.n61 4.28558
R817 VSS.n582 VSS.n63 15.8902
R818 VSS.n64 VSS.n62 4.28558
R819 VSS.n591 VSS.n590 15.8902
R820 VSS.n12 VSS.n11 4.28558
R821 VSS.n592 VSS.n11 15.8902
R822 VSS.n13 VSS.n122 4.28558
R823 VSS.n563 VSS.n122 15.8902
R824 VSS.n14 VSS.n123 4.28558
R825 VSS.n553 VSS.n123 15.8902
R826 VSS.n15 VSS.n131 4.28558
R827 VSS.n552 VSS.n131 15.8902
R828 VSS.n16 VSS.n132 4.28558
R829 VSS.n542 VSS.n132 15.8902
R830 VSS.n17 VSS.n141 4.28558
R831 VSS.n541 VSS.n141 15.8902
R832 VSS.n18 VSS.n142 4.28558
R833 VSS.n532 VSS.n142 15.8902
R834 VSS.n19 VSS.n151 4.28558
R835 VSS.n531 VSS.n151 15.8902
R836 VSS.n20 VSS.n152 4.28558
R837 VSS.n522 VSS.n152 15.8902
R838 VSS.n21 VSS.n161 4.28558
R839 VSS.n521 VSS.n161 15.8902
R840 VSS.n22 VSS.n162 4.28558
R841 VSS.n512 VSS.n162 15.8902
R842 VSS.n23 VSS.n170 4.28558
R843 VSS.n511 VSS.n170 15.8902
R844 VSS.n24 VSS.n171 4.28558
R845 VSS.n502 VSS.n171 15.8902
R846 VSS.n25 VSS.n180 4.28558
R847 VSS.n501 VSS.n180 15.8902
R848 VSS.n26 VSS.n181 4.28558
R849 VSS.n492 VSS.n181 15.8902
R850 VSS.n27 VSS.n190 4.28558
R851 VSS.n491 VSS.n190 15.8902
R852 VSS.n28 VSS.n191 4.28558
R853 VSS.n482 VSS.n191 15.8902
R854 VSS.n29 VSS.n200 4.28558
R855 VSS.n481 VSS.n200 15.8902
R856 VSS.n30 VSS.n201 4.28558
R857 VSS.n472 VSS.n201 15.8902
R858 VSS.n31 VSS.n209 4.28558
R859 VSS.n471 VSS.n209 15.8902
R860 VSS.n32 VSS.n210 4.28558
R861 VSS.n461 VSS.n210 15.8902
R862 VSS.n33 VSS.n218 4.28558
R863 VSS.n460 VSS.n218 15.8902
R864 VSS.n34 VSS.n219 4.28558
R865 VSS.n450 VSS.n219 15.8902
R866 VSS.n35 VSS.n227 4.28558
R867 VSS.n449 VSS.n227 15.8902
R868 VSS.n36 VSS.n228 4.28558
R869 VSS.n439 VSS.n228 15.8902
R870 VSS.n37 VSS.n237 4.28558
R871 VSS.n438 VSS.n237 15.8902
R872 VSS.n38 VSS.n238 4.28558
R873 VSS.n429 VSS.n238 15.8902
R874 VSS.n39 VSS.n247 4.28558
R875 VSS.n428 VSS.n247 15.8902
R876 VSS.n40 VSS.n248 4.28558
R877 VSS.n419 VSS.n248 15.8902
R878 VSS.n41 VSS.n256 4.28558
R879 VSS.n418 VSS.n256 15.8902
R880 VSS.n42 VSS.n257 4.28558
R881 VSS.n409 VSS.n257 15.8902
R882 VSS.n43 VSS.n266 4.28558
R883 VSS.n408 VSS.n266 15.8902
R884 VSS.n44 VSS.n267 4.28558
R885 VSS.n399 VSS.n267 15.8902
R886 VSS.n45 VSS.n276 4.28558
R887 VSS.n398 VSS.n276 15.8902
R888 VSS.n46 VSS.n277 4.28558
R889 VSS.n389 VSS.n277 15.8902
R890 VSS.n47 VSS.n286 4.28558
R891 VSS.n388 VSS.n286 15.8902
R892 VSS.n48 VSS.n287 4.28558
R893 VSS.n379 VSS.n287 15.8902
R894 VSS.n49 VSS.n296 4.28558
R895 VSS.n378 VSS.n296 15.8902
R896 VSS.n50 VSS.n297 4.28558
R897 VSS.n369 VSS.n297 15.8902
R898 VSS.n51 VSS.n306 4.28558
R899 VSS.n368 VSS.n306 15.8902
R900 VSS.n52 VSS.n307 4.28558
R901 VSS.n359 VSS.n307 15.8902
R902 VSS.n53 VSS.n316 4.28558
R903 VSS.n358 VSS.n316 15.8902
R904 VSS.n54 VSS.n317 4.28558
R905 VSS.t24 VSS.t22 53.7478
R906 VSS.n67 VSS.n321 6.2306
R907 VSS.n354 VSS.n101 4.28558
R908 VSS.n101 VSS.t3 2.50871
R909 VSS.t3 VSS.n65 2.50871
R910 VSS.n65 VSS.n311 4.28558
R911 VSS.n364 VSS.n100 4.28558
R912 VSS.n100 VSS.t3 2.50871
R913 VSS.t3 VSS.n66 2.50871
R914 VSS.n66 VSS.n301 4.28558
R915 VSS.n374 VSS.n99 4.28558
R916 VSS.n99 VSS.t3 2.50871
R917 VSS.t3 VSS.n98 2.50871
R918 VSS.n98 VSS.n291 4.28558
R919 VSS.n93 VSS.t3 2.50871
R920 VSS.n282 VSS.n93 4.28558
R921 VSS.t3 VSS.n92 2.50871
R922 VSS.n92 VSS.n281 4.28558
R923 VSS.n91 VSS.t3 2.50871
R924 VSS.n271 VSS.n91 4.28558
R925 VSS.t3 VSS.n97 2.50871
R926 VSS.n97 VSS.n270 4.28558
R927 VSS.n90 VSS.t3 2.50871
R928 VSS.n261 VSS.n90 4.28558
R929 VSS.t3 VSS.n89 2.50871
R930 VSS.n89 VSS.n260 4.28558
R931 VSS.n414 VSS.t3 9.3005
R932 VSS.n102 VSS.n251 4.28558
R933 VSS.t3 VSS.n102 2.50871
R934 VSS.t3 VSS.n88 9.3005
R935 VSS.n87 VSS.t3 2.50871
R936 VSS.n243 VSS.n87 4.28558
R937 VSS.t3 VSS.n86 2.50871
R938 VSS.n86 VSS.n242 4.28558
R939 VSS.n434 VSS.n105 4.28558
R940 VSS.n105 VSS.t3 2.50871
R941 VSS.t3 VSS.n443 9.3005
R942 VSS.t3 VSS.n85 2.50871
R943 VSS.n444 VSS.n85 4.28558
R944 VSS.n84 VSS.t3 2.50871
R945 VSS.n84 VSS.n454 4.28558
R946 VSS.t3 VSS.n104 2.50871
R947 VSS.n455 VSS.n104 4.28558
R948 VSS.n83 VSS.t3 2.50871
R949 VSS.n83 VSS.n465 4.28558
R950 VSS.t3 VSS.n82 2.50871
R951 VSS.n466 VSS.n82 4.28558
R952 VSS.n81 VSS.t3 2.50871
R953 VSS.n81 VSS.n476 4.28558
R954 VSS.t3 VSS.n80 2.50871
R955 VSS.n477 VSS.n80 4.28558
R956 VSS.n79 VSS.t3 2.50871
R957 VSS.n79 VSS.n486 4.28558
R958 VSS.t3 VSS.n78 2.50871
R959 VSS.n487 VSS.n78 4.28558
R960 VSS.n186 VSS.t3 9.3005
R961 VSS.t3 VSS.n103 2.50871
R962 VSS.n103 VSS.n185 4.28558
R963 VSS.n77 VSS.t3 2.50871
R964 VSS.n175 VSS.n77 4.28558
R965 VSS.t3 VSS.n76 2.50871
R966 VSS.n76 VSS.n174 4.28558
R967 VSS.n507 VSS.t3 9.3005
R968 VSS.n106 VSS.n165 4.28558
R969 VSS.t3 VSS.n106 2.50871
R970 VSS.t3 VSS.n75 9.3005
R971 VSS.n74 VSS.t3 2.50871
R972 VSS.n157 VSS.n74 4.28558
R973 VSS.t3 VSS.n73 2.50871
R974 VSS.n73 VSS.n156 4.28558
R975 VSS.n527 VSS.n96 4.28558
R976 VSS.n96 VSS.t3 2.50871
R977 VSS.t3 VSS.n536 9.3005
R978 VSS.t3 VSS.n72 2.50871
R979 VSS.n537 VSS.n72 4.28558
R980 VSS.n71 VSS.t3 2.50871
R981 VSS.n71 VSS.n546 4.28558
R982 VSS.t3 VSS.n95 2.50871
R983 VSS.n547 VSS.n95 4.28558
R984 VSS.n70 VSS.t3 2.50871
R985 VSS.n70 VSS.n557 4.28558
R986 VSS.t3 VSS.n69 2.50871
R987 VSS.n558 VSS.n69 4.28558
R988 VSS.n68 VSS.t1 2.50871
R989 VSS.n68 VSS.n596 4.28558
R990 VSS.t1 VSS.n94 2.50871
R991 VSS.n597 VSS.n94 4.28558
R992 VSS.n598 VSS.t1 9.3005
R993 VSS.n108 VSS.n604 4.28558
R994 VSS.t3 VSS.n67 1.5362
R995 VSS.n339 VSS.n55 4.28558
R996 VSS.n55 VSS.t3 2.50871
R997 VSS.n57 VSS.n341 4.28558
R998 VSS.t3 VSS.n57 2.50871
R999 VSS.n342 VSS.n58 4.28558
R1000 VSS.n58 VSS.t22 2.50871
R1001 VSS.n10 VSS.n107 4.28558
R1002 VSS.n10 VSS.t22 2.50871
R1003 VSS.n0 VSS.n64 2.50871
R1004 VSS.n64 VSS.n63 4.28558
R1005 VSS.n61 VSS.t1 2.50871
R1006 VSS.n61 VSS.n566 4.28558
R1007 VSS.t1 VSS.n60 2.50871
R1008 VSS.n580 VSS.n60 4.28558
R1009 VSS.n59 VSS.t1 2.50871
R1010 VSS.n59 VSS.n572 4.28558
R1011 VSS.t1 VSS.n578 9.3005
R1012 VSS.n108 VSS.t1 2.50871
R1013 VSS.n590 VSS.n0 9.3005
R1014 VSS.n12 VSS.n591 4.28558
R1015 VSS.n0 VSS.n12 2.50871
R1016 VSS.n592 VSS.n13 4.28558
R1017 VSS.n0 VSS.n13 2.50871
R1018 VSS.n14 VSS.n563 4.28558
R1019 VSS.n14 VSS.n0 2.50871
R1020 VSS.n553 VSS.n15 4.28558
R1021 VSS.n1 VSS.n15 2.50871
R1022 VSS.n16 VSS.n552 4.28558
R1023 VSS.n16 VSS.n1 2.50871
R1024 VSS.n542 VSS.n17 4.28558
R1025 VSS.n1 VSS.n17 2.50871
R1026 VSS.n18 VSS.n541 4.28558
R1027 VSS.n18 VSS.n1 2.50871
R1028 VSS.n532 VSS.n19 4.28558
R1029 VSS.n2 VSS.n19 2.50871
R1030 VSS.n20 VSS.n531 4.28558
R1031 VSS.n20 VSS.n2 2.50871
R1032 VSS.n522 VSS.n21 4.28558
R1033 VSS.n2 VSS.n21 2.50871
R1034 VSS.n22 VSS.n521 4.28558
R1035 VSS.n22 VSS.n2 2.50871
R1036 VSS.n512 VSS.n23 4.28558
R1037 VSS.n3 VSS.n23 2.50871
R1038 VSS.n24 VSS.n511 4.28558
R1039 VSS.n24 VSS.n3 2.50871
R1040 VSS.n502 VSS.n25 4.28558
R1041 VSS.n3 VSS.n25 2.50871
R1042 VSS.n26 VSS.n501 4.28558
R1043 VSS.n26 VSS.n3 2.50871
R1044 VSS.n492 VSS.n27 4.28558
R1045 VSS.n4 VSS.n27 2.50871
R1046 VSS.n28 VSS.n491 4.28558
R1047 VSS.n28 VSS.n4 2.50871
R1048 VSS.n482 VSS.n29 4.28558
R1049 VSS.n4 VSS.n29 2.50871
R1050 VSS.n30 VSS.n481 4.28558
R1051 VSS.n30 VSS.n4 2.50871
R1052 VSS.n472 VSS.n31 4.28558
R1053 VSS.n5 VSS.n31 2.50871
R1054 VSS.n32 VSS.n471 4.28558
R1055 VSS.n32 VSS.n5 2.50871
R1056 VSS.n461 VSS.n33 4.28558
R1057 VSS.n5 VSS.n33 2.50871
R1058 VSS.n34 VSS.n460 4.28558
R1059 VSS.n34 VSS.n5 2.50871
R1060 VSS.n450 VSS.n35 4.28558
R1061 VSS.n6 VSS.n35 2.50871
R1062 VSS.n36 VSS.n449 4.28558
R1063 VSS.n36 VSS.n6 2.50871
R1064 VSS.n439 VSS.n37 4.28558
R1065 VSS.n6 VSS.n37 2.50871
R1066 VSS.n38 VSS.n438 4.28558
R1067 VSS.n38 VSS.n6 2.50871
R1068 VSS.n429 VSS.n39 4.28558
R1069 VSS.n7 VSS.n39 2.50871
R1070 VSS.n40 VSS.n428 4.28558
R1071 VSS.n40 VSS.n7 2.50871
R1072 VSS.n419 VSS.n41 4.28558
R1073 VSS.n7 VSS.n41 2.50871
R1074 VSS.n42 VSS.n418 4.28558
R1075 VSS.n42 VSS.n7 2.50871
R1076 VSS.n409 VSS.n43 4.28558
R1077 VSS.n8 VSS.n43 2.50871
R1078 VSS.n44 VSS.n408 4.28558
R1079 VSS.n44 VSS.n8 2.50871
R1080 VSS.n399 VSS.n45 4.28558
R1081 VSS.n8 VSS.n45 2.50871
R1082 VSS.n46 VSS.n398 4.28558
R1083 VSS.n46 VSS.n8 2.50871
R1084 VSS.n389 VSS.n47 4.28558
R1085 VSS.n9 VSS.n47 2.50871
R1086 VSS.n48 VSS.n388 4.28558
R1087 VSS.n48 VSS.n9 2.50871
R1088 VSS.n379 VSS.n49 4.28558
R1089 VSS.n9 VSS.n49 2.50871
R1090 VSS.n50 VSS.n378 4.28558
R1091 VSS.n50 VSS.n9 2.50871
R1092 VSS.n369 VSS.n51 4.28558
R1093 VSS.t22 VSS.n51 2.50871
R1094 VSS.n52 VSS.n368 4.28558
R1095 VSS.n52 VSS.t22 2.50871
R1096 VSS.n359 VSS.n53 4.28558
R1097 VSS.t22 VSS.n53 2.50871
R1098 VSS.n54 VSS.n358 4.28558
R1099 VSS.n54 VSS.t22 2.50871
R1100 VSS.n499 VSS.t9 6.12011
R1101 VSS.n452 VSS.t14 6.12011
R1102 VSS.n603 VSS.n109 4.28558
R1103 VSS.n323 VSS.n322 4.28558
R1104 VSS.n346 VSS.n345 4.28558
R1105 VSS.n338 VSS.n322 4.28558
R1106 VSS.n346 VSS.n344 4.28558
R1107 VSS.n599 VSS.n109 4.28558
R1108 VSS.t1 VSS.n109 2.50871
R1109 VSS.t3 VSS.n322 2.50871
R1110 VSS.t22 VSS.n346 2.50871
R1111 VSS.t3 VSS.t1 1.97819
R1112 VSS.t22 VSS.t3 1.86994
R1113 VSS.n1 VSS.n0 1.86257
R1114 VSS.t1 VSS.n0 1.61041
R1115 VSS.t22 VSS.n9 1.24188
R1116 VSS.n9 VSS.n8 1.24188
R1117 VSS.n8 VSS.n7 1.24188
R1118 VSS.n7 VSS.n6 1.24188
R1119 VSS.n6 VSS.n5 1.24188
R1120 VSS.n5 VSS.n4 1.24188
R1121 VSS.n4 VSS.n3 1.24188
R1122 VSS.n3 VSS.n2 1.24188
R1123 VSS.n2 VSS.n1 1.24188
R1124 VSS VSS.t3 0.0005
C0 vout vin 5.21435f
C1 vout VDD 3.3878f
C2 VDD vin 11.0485f
C3 vout VSS 9.06948f
.ends

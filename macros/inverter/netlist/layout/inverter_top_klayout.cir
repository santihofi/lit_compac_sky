* Extracted by KLayout with SKY130 LVS runset on : 18/09/2026 14:44

.SUBCKT inverter_top VDD VSS vin1 vin2 vin3 vin4 vout1 vout2 vout3 vout4
X$1 vin1 VDD vout1 VSS inverter
X$2 vin4 VDD vout4 VSS inverter
X$3 vin3 VDD vout3 VSS inverter
X$4 vin2 VDD vout2 VSS inverter
.ENDS inverter_top

.SUBCKT inverter vin VDD vout VSS
M$1 VDD vin vout VDD sky130_fd_pr__pfet_01v8_lvt L=1 W=40 AS=6.3 AD=6.3 PS=48.3
+ PD=48.3
M$21 VDD VDD VDD VDD sky130_fd_pr__pfet_01v8_lvt L=1 W=4 AS=0.9 AD=0.9 PS=6.9
+ PD=6.9
M$23 VSS VSS VSS VSS sky130_fd_pr__nfet_01v8 L=1 W=2 AS=0.45 AD=0.45 PS=3.9
+ PD=3.9
M$25 VSS vin vout VSS sky130_fd_pr__nfet_01v8 L=1 W=20 AS=3.15 AD=3.15 PS=27.3
+ PD=27.3
.ENDS inverter

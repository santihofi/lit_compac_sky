** sch_path: /foss/designs/lit_compac_sky/verification/porting/sky_gilbert/tb/tb_gilbert_cell_mult.sch
**.subckt tb_gilbert_cell_mult
Vdd vdd GND {{vdd}}
.save i(vdd)
Vcmi vcmi GND {{vincm}}
Vref vref GND {{vref}}
I0 ibias GND {{ibias}}
I1 vdd ibias_ota {{ibias}}
Vd1 vdin1 GND {{vd1}}
E1 in1p vcmi VOL=' v(vdin1)/2 '
E2 in1n vcmi VOL=' -v(vdin1)/2 '
Vd2 vdin2 GND {{vd2}}
E4 in2p vcmi VOL=' v(vdin2)/2 '
E5 in2n vcmi VOL=' -v(vdin2)/2 '
x1 vdd vbias outp outn in1n in1p in2p in2n GND ibias vdd GND vcm_sense gt0 gt1 gt2 gt3 gt4 gilbert_cell
Cloadp outp GND {{c_load}}
Cloadn outn GND {{c_load}}
x2 vdd vbias vref vcm_sense GND ibias_ota vdd GND ota
Vgcode gcode GND {{gcode}}
Egt0 gt0 GND VOL=' v(vdd)*(1-(floor((v(gcode)+0.5)/1)-2*floor((v(gcode)+0.5)/2))) '
Egt1 gt1 GND VOL=' v(vdd)*(1-(floor((v(gcode)+0.5)/2)-2*floor((v(gcode)+0.5)/4))) '
Egt2 gt2 GND VOL=' v(vdd)*(1-(floor((v(gcode)+0.5)/4)-2*floor((v(gcode)+0.5)/8))) '
Egt3 gt3 GND VOL=' v(vdd)*(1-(floor((v(gcode)+0.5)/8)-2*floor((v(gcode)+0.5)/16))) '
Egt4 gt4 GND VOL=' v(vdd)*(1-(floor((v(gcode)+0.5)/16)-2*floor((v(gcode)+0.5)/32))) '
**** begin user architecture code

.temp {{ temp }}
.option SEED = {{ (seed|int) + 1 }}
.option method=gear

.control
save all
* op1..op21: (vd1, vd2) points; every op plot gets vout = v(outp)-v(outn)
op
let vout = v(outp)-v(outn)
let vocm = (v(outp)+v(outn))/2
alter vd1 dc=0.1
alter vd2 dc=0.1
op
let vout = v(outp)-v(outn)
alter vd1 dc=-0.1
op
let vout = v(outp)-v(outn)
alter vd2 dc=-0.1
op
let vout = v(outp)-v(outn)
alter vd1 dc=0.1
op
let vout = v(outp)-v(outn)
* feedthrough points: one input at +-100 mV, the other at 0
alter vd2 dc=0
op
let vout = v(outp)-v(outn)
alter vd1 dc=-0.1
op
let vout = v(outp)-v(outn)
alter vd1 dc=0
alter vd2 dc=0.1
op
let vout = v(outp)-v(outn)
alter vd2 dc=-0.1
op
let vout = v(outp)-v(outn)
* small-signal four-quadrant at +-10 mV (op10..op13)
alter vd1 dc=0.01
alter vd2 dc=0.01
op
let vout = v(outp)-v(outn)
alter vd1 dc=-0.01
op
let vout = v(outp)-v(outn)
alter vd2 dc=-0.01
op
let vout = v(outp)-v(outn)
alter vd1 dc=0.01
op
let vout = v(outp)-v(outn)
* in1 at +-100 mV, in2 at +-10 mV (op14..op17)
alter vd1 dc=0.1
alter vd2 dc=0.01
op
let vout = v(outp)-v(outn)
alter vd1 dc=-0.1
op
let vout = v(outp)-v(outn)
alter vd2 dc=-0.01
op
let vout = v(outp)-v(outn)
alter vd1 dc=0.1
op
let vout = v(outp)-v(outn)
* in1 at +-10 mV, in2 at +-100 mV (op18..op21)
alter vd1 dc=0.01
alter vd2 dc=0.1
op
let vout = v(outp)-v(outn)
alter vd1 dc=-0.01
op
let vout = v(outp)-v(outn)
alter vd2 dc=-0.1
op
let vout = v(outp)-v(outn)
alter vd1 dc=0.01
op
let vout = v(outp)-v(outn)
* transfer curves: vs vd1 at vd2 = +100 mV (dc1), vs vd2 at vd1 = +100 mV (dc2)
alter vd2 dc=0.1
dc vd1 -0.2 0.2 0.005
let vout_v1 = v(outp)-v(outn)
alter vd1 dc=0.1
dc vd2 -0.2 0.2 0.005
let vout_v2 = v(outp)-v(outn)
* scalars, K = vout/(v1*v2) from four-quadrant differences (offsets and feedthrough cancel)
let k100 = (op2.vout - op3.vout - op5.vout + op4.vout)/(4*0.1*0.1)
let k10 = (op10.vout - op11.vout - op13.vout + op12.vout)/(4*0.01*0.01)
let k_in1big = (op14.vout - op15.vout - op17.vout + op16.vout)/(4*0.1*0.01)
let k_in2big = (op18.vout - op19.vout - op21.vout + op20.vout)/(4*0.01*0.1)
let compr = k100/k10
let compr1 = k_in1big/k10
let compr2 = k_in2big/k10
let vout_pp = op2.vout
let vos_out = op1.vout
let vocm = op1.vocm
* feedthrough of one input, referred to the other input as an equivalent offset
let vos2_eq = (op6.vout - op7.vout)/(2*k10*0.1)
let vos1_eq = (op8.vout - op9.vout)/(2*k10*0.1)
quit
.endc

.lib /foss/pdks/sky130A/libs.tech/ngspice/sky130.lib.spice {{ corner_mos }}

**** end user architecture code
**.ends

* expanding   symbol:  lit_compac_sky/macros/gilbert_cell/schematic/xschem/gilbert_cell.sym # of pins=18
** sym_path: /foss/designs/lit_compac_sky/macros/gilbert_cell/schematic/xschem/gilbert_cell.sym
** sch_path: /foss/designs/lit_compac_sky/macros/gilbert_cell/schematic/xschem/gilbert_cell.sch
.subckt gilbert_cell vdd vbias outp outn in1n in1p in2p in2n vss ibias ntap ptap vcm gt0 gt1 gt2 gt3 gt4
*.iopin vdd
*.ipin in1n
*.opin outp
*.opin outn
*.iopin vss
*.ipin in1p
*.ipin in2n
*.ipin in2p
*.ipin vbias
*.ipin ibias
*.iopin ptap
*.opin vcm
*.iopin ntap
*.ipin gt0
*.ipin gt1
*.ipin gt2
*.ipin gt3
*.ipin gt4
XM5 qs1 net2 vss ptap sky130_fd_pr__nfet_01v8_lvt L=1.25 W=20 nf=4 ad=2.9 as=4.35 pd=21.16 ps=31.74 nrd=0.0145 nrs=0.0145 sa=0
+ sb=0 sd=0 mult=1
XM6 qs2 net1 vss ptap sky130_fd_pr__nfet_01v8_lvt L=1.25 W=20 nf=4 ad=2.9 as=4.35 pd=21.16 ps=31.74 nrd=0.0145 nrs=0.0145 sa=0
+ sb=0 sd=0 mult=1
XM7 outp in2n qs1 ptap sky130_fd_pr__nfet_01v8_lvt L=0.5 W=20 nf=4 ad=2.9 as=4.35 pd=21.16 ps=31.74 nrd=0.0145 nrs=0.0145 sa=0
+ sb=0 sd=0 mult=1
XM9 outp in2p qs2 ptap sky130_fd_pr__nfet_01v8_lvt L=0.5 W=20 nf=4 ad=2.9 as=4.35 pd=21.16 ps=31.74 nrd=0.0145 nrs=0.0145 sa=0
+ sb=0 sd=0 mult=1
XM10 outn in2n qs2 ptap sky130_fd_pr__nfet_01v8_lvt L=0.5 W=20 nf=4 ad=2.9 as=4.35 pd=21.16 ps=31.74 nrd=0.0145 nrs=0.0145 sa=0
+ sb=0 sd=0 mult=1
XM8 outn in2p qs1 ptap sky130_fd_pr__nfet_01v8_lvt L=0.5 W=20 nf=4 ad=2.9 as=4.35 pd=21.16 ps=31.74 nrd=0.0145 nrs=0.0145 sa=0
+ sb=0 sd=0 mult=1
XM11 outp vbias vdd ntap sky130_fd_pr__pfet_01v8_lvt L=1 W=32 nf=8 ad=4.64 as=5.8 pd=34.32 ps=42.9 nrd=0.0090625 nrs=0.0090625
+ sa=0 sb=0 sd=0 mult=1
XM12 outn vbias vdd ntap sky130_fd_pr__pfet_01v8_lvt L=1 W=32 nf=8 ad=4.64 as=5.8 pd=34.32 ps=42.9 nrd=0.0090625 nrs=0.0090625
+ sa=0 sb=0 sd=0 mult=1
XM1 net1 in1n vcm1 ntap sky130_fd_pr__pfet_01v8_lvt L=0.35 W=74.625 nf=12 ad=10.820625 as=12.6240625 pd=78.105 ps=91.1225
+ nrd=0.00388609715242881 nrs=0.00388609715242881 sa=0 sb=0 sd=0 mult=1
XM13 vcm1 ibias vdd ntap sky130_fd_pr__pfet_01v8_lvt L=0.65 W=40 nf=4 ad=5.8 as=8.7 pd=41.16 ps=61.74 nrd=0.00725 nrs=0.00725 sa=0
+ sb=0 sd=0 mult=8 m=8
XM3 net1 net1 vss ptap sky130_fd_pr__nfet_01v8_lvt L=1.25 W=20 nf=4 ad=2.9 as=4.35 pd=21.16 ps=31.74 nrd=0.0145 nrs=0.0145 sa=0
+ sb=0 sd=0 mult=1
XM4 net2 net2 vss ptap sky130_fd_pr__nfet_01v8_lvt L=1.25 W=20 nf=4 ad=2.9 as=4.35 pd=21.16 ps=31.74 nrd=0.0145 nrs=0.0145 sa=0
+ sb=0 sd=0 mult=1
XM2 net2 in1p vcm1 ntap sky130_fd_pr__pfet_01v8_lvt L=0.35 W=74.625 nf=12 ad=10.820625 as=12.6240625 pd=78.105 ps=91.1225
+ nrd=0.00388609715242881 nrs=0.00388609715242881 sa=0 sb=0 sd=0 mult=1
XM14 ibias ibias vdd ntap sky130_fd_pr__pfet_01v8_lvt L=0.65 W=40 nf=4 ad=5.8 as=8.7 pd=41.16 ps=61.74 nrd=0.00725 nrs=0.00725
+ sa=0 sb=0 sd=0 mult=1
Rtap_R1 vss ptap 1m
XR7 t4p outp ptap sky130_fd_pr__res_high_po_5p73 L=13.035 mult=1
XR5 outn t4n ptap sky130_fd_pr__res_high_po_5p73 L=13.035 mult=1
Rtap_R2 vdd ntap 1m
xtrim t4p t4n vcm gt0 gt1 gt2 gt3 gt4 ptap gain_trim
XMDP vcm1 vcm1 vcm1 ntap sky130_fd_pr__pfet_01v8_lvt L=0.35 W=24.875 nf=4 ad=3.606875 as=5.4103125 pd=26.035 ps=39.0525
+ nrd=0.0116582914572864 nrs=0.0116582914572864 sa=0 sb=0 sd=0 mult=1
XMDM vss vss vss ptap sky130_fd_pr__nfet_01v8_lvt L=1.25 W=10 nf=2 ad=1.45 as=2.9 pd=10.58 ps=21.16 nrd=0.029 nrs=0.029 sa=0 sb=0
+ sd=0 mult=1
XMDQ1 qs1 qs1 qs1 ptap sky130_fd_pr__nfet_01v8_lvt L=0.5 W=20 nf=4 ad=2.9 as=4.35 pd=21.16 ps=31.74 nrd=0.0145 nrs=0.0145 sa=0
+ sb=0 sd=0 mult=1
XMDQ2 qs2 qs2 qs2 ptap sky130_fd_pr__nfet_01v8_lvt L=0.5 W=20 nf=4 ad=2.9 as=4.35 pd=21.16 ps=31.74 nrd=0.0145 nrs=0.0145 sa=0
+ sb=0 sd=0 mult=1
XMDL vdd vdd vdd ntap sky130_fd_pr__pfet_01v8_lvt L=1 W=16 nf=4 ad=2.32 as=3.48 pd=17.16 ps=25.74 nrd=0.018125 nrs=0.018125 sa=0
+ sb=0 sd=0 mult=1
XMDT vdd vdd vdd ntap sky130_fd_pr__pfet_01v8_lvt L=0.65 W=20 nf=2 ad=2.9 as=5.8 pd=20.58 ps=41.16 nrd=0.0145 nrs=0.0145 sa=0 sb=0
+ sd=0 mult=1
XRD1 ntap ntap ptap sky130_fd_pr__res_high_po_5p73 L=13.035 mult=1
XRD2 ntap ntap ptap sky130_fd_pr__res_high_po_5p73 L=13.035 mult=1
.ends

* expanding   symbol:  lit_compac_sky/macros/ota/schematic/xschem/ota.sym # of pins=8
** sym_path: /foss/designs/lit_compac_sky/macros/ota/schematic/xschem/ota.sym
** sch_path: /foss/designs/lit_compac_sky/macros/ota/schematic/xschem/ota.sch
.subckt ota vdd out inn inp vss ibias1 ntap ptap
*.opin out
*.ipin inp
*.ipin ibias1
*.ipin inn
*.iopin ntap
*.iopin ptap
*.iopin vdd
*.iopin vss
XM5 vd_m5 vd_m5 vdd ntap sky130_fd_pr__pfet_01v8_lvt L=1 W=4.4 nf=2 ad=0.638 as=1.276 pd=4.98 ps=9.96 nrd=0.0659090909090909
+ nrs=0.0659090909090909 sa=0 sb=0 sd=0 mult=1
XM6 out out vdd ntap sky130_fd_pr__pfet_01v8_lvt L=1 W=4.4 nf=2 ad=0.638 as=1.276 pd=4.98 ps=9.96 nrd=0.0659090909090909
+ nrs=0.0659090909090909 sa=0 sb=0 sd=0 mult=1
XM1 vd_m5 inp sa ptap sky130_fd_pr__nfet_01v8_lvt L=1 W=16 nf=4 ad=2.32 as=3.48 pd=17.16 ps=25.74 nrd=0.018125 nrs=0.018125 sa=0
+ sb=0 sd=0 mult=1
XM2 out vref_int sb ptap sky130_fd_pr__nfet_01v8_lvt L=1 W=16 nf=4 ad=2.32 as=3.48 pd=17.16 ps=25.74 nrd=0.018125 nrs=0.018125
+ sa=0 sb=0 sd=0 mult=1
XRS1 rs1 sa ptap sky130_fd_pr__res_high_po_1p41 L=22.705 mult=1
XRS2 rs2 rs1 ptap sky130_fd_pr__res_high_po_1p41 L=22.705 mult=1
XRS3 rs3 rs2 ptap sky130_fd_pr__res_high_po_1p41 L=22.705 mult=1
XRS4 rs4 rs3 ptap sky130_fd_pr__res_high_po_1p41 L=22.705 mult=1
XRS5 rs5 rs4 ptap sky130_fd_pr__res_high_po_1p41 L=22.705 mult=1
XRS6 rs6 rs5 ptap sky130_fd_pr__res_high_po_1p41 L=22.705 mult=1
XRS7 rs7 rs6 ptap sky130_fd_pr__res_high_po_1p41 L=22.705 mult=1
XRS8 rs8 rs7 ptap sky130_fd_pr__res_high_po_1p41 L=22.705 mult=1
XRS9 rs9 rs8 ptap sky130_fd_pr__res_high_po_1p41 L=22.705 mult=1
XRS10 rs10 rs9 ptap sky130_fd_pr__res_high_po_1p41 L=22.705 mult=1
XRS11 rs11 rs10 ptap sky130_fd_pr__res_high_po_1p41 L=22.705 mult=1
XRS12 sb rs11 ptap sky130_fd_pr__res_high_po_1p41 L=22.705 mult=1
XM3 sa ibias1 vss ptap sky130_fd_pr__nfet_01v8_lvt L=2 W=16 nf=4 ad=2.32 as=3.48 pd=17.16 ps=25.74 nrd=0.018125 nrs=0.018125 sa=0
+ sb=0 sd=0 mult=1
XM3B sb ibias1 vss ptap sky130_fd_pr__nfet_01v8_lvt L=2 W=16 nf=4 ad=2.32 as=3.48 pd=17.16 ps=25.74 nrd=0.018125 nrs=0.018125 sa=0
+ sb=0 sd=0 mult=1
XM4 ibias1 ibias1 vss ptap sky130_fd_pr__nfet_01v8_lvt L=2 W=32 nf=8 ad=4.64 as=5.8 pd=34.32 ps=42.9 nrd=0.0090625 nrs=0.0090625
+ sa=0 sb=0 sd=0 mult=1
XM10 vd_m10 vd_m10 vdd ntap sky130_fd_pr__pfet_01v8_lvt L=4 W=1 nf=1 ad=0.29 as=0.29 pd=2.58 ps=2.58 nrd=0.29 nrs=0.29 sa=0 sb=0
+ sd=0 mult=1
XM11 vref_int vd_m10 vdd ntap sky130_fd_pr__pfet_01v8_lvt L=4 W=1 nf=1 ad=0.29 as=0.29 pd=2.58 ps=2.58 nrd=0.29 nrs=0.29 sa=0 sb=0
+ sd=0 mult=1
XM7 vd_m10 inn vtail_slow ptap sky130_fd_pr__nfet_01v8_lvt L=2 W=2 nf=2 ad=0.29 as=0.58 pd=2.58 ps=5.16 nrd=0.145 nrs=0.145 sa=0
+ sb=0 sd=0 mult=1
XM8 vref_int inp vtail_slow ptap sky130_fd_pr__nfet_01v8_lvt L=2 W=2 nf=2 ad=0.29 as=0.58 pd=2.58 ps=5.16 nrd=0.145 nrs=0.145 sa=0
+ sb=0 sd=0 mult=1
XM9 vtail_slow ibias1 vss ptap sky130_fd_pr__nfet_01v8_lvt L=5 W=1 nf=1 ad=0.29 as=0.29 pd=2.58 ps=2.58 nrd=0.29 nrs=0.29 sa=0
+ sb=0 sd=0 mult=1
XMC vss vref_int vss ptap sky130_fd_pr__nfet_01v8_lvt L=6 W=6 nf=1 ad=1.74 as=1.74 pd=12.58 ps=12.58 nrd=0.0483333333333333
+ nrs=0.0483333333333333 sa=0 sb=0 sd=0 mult=1
Rtap_R2 vdd ntap 1m
Rtap_R7 vss ptap 1m
XMDA sa sa sa ptap sky130_fd_pr__nfet_01v8_lvt L=1 W=16 nf=4 ad=2.32 as=3.48 pd=17.16 ps=25.74 nrd=0.018125 nrs=0.018125 sa=0 sb=0
+ sd=0 mult=1
XMDB sb sb sb ptap sky130_fd_pr__nfet_01v8_lvt L=1 W=16 nf=4 ad=2.32 as=3.48 pd=17.16 ps=25.74 nrd=0.018125 nrs=0.018125 sa=0 sb=0
+ sd=0 mult=1
XMD3 vss vss vss ptap sky130_fd_pr__nfet_01v8_lvt L=2 W=16 nf=4 ad=2.32 as=3.48 pd=17.16 ps=25.74 nrd=0.018125 nrs=0.018125 sa=0
+ sb=0 sd=0 mult=1
XMD5 vd_m5 vdd vd_m5 ntap sky130_fd_pr__pfet_01v8_lvt L=1 W=4.4 nf=2 ad=0.638 as=1.276 pd=4.98 ps=9.96 nrd=0.0659090909090909
+ nrs=0.0659090909090909 sa=0 sb=0 sd=0 mult=1
XMD7 vd_m10 vd_m10 vd_m10 ptap sky130_fd_pr__nfet_01v8_lvt L=2 W=2 nf=2 ad=0.29 as=0.58 pd=2.58 ps=5.16 nrd=0.145 nrs=0.145 sa=0
+ sb=0 sd=0 mult=1
XMD10 vd_m10 vdd vd_m10 ntap sky130_fd_pr__pfet_01v8_lvt L=4 W=1 nf=1 ad=0.29 as=0.29 pd=2.58 ps=2.58 nrd=0.29 nrs=0.29 sa=0 sb=0
+ sd=0 mult=1
XMD11 vref_int vdd vref_int ntap sky130_fd_pr__pfet_01v8_lvt L=4 W=1 nf=1 ad=0.29 as=0.29 pd=2.58 ps=2.58 nrd=0.29 nrs=0.29 sa=0
+ sb=0 sd=0 mult=1
XMD8 vref_int vss vref_int ptap sky130_fd_pr__nfet_01v8_lvt L=2 W=2 nf=2 ad=0.29 as=0.58 pd=2.58 ps=5.16 nrd=0.145 nrs=0.145 sa=0
+ sb=0 sd=0 mult=1
.ends

* expanding   symbol:  lit_compac_sky/macros/gilbert_cell/schematic/xschem/gain_trim.sym # of pins=9
** sym_path: /foss/designs/lit_compac_sky/macros/gilbert_cell/schematic/xschem/gain_trim.sym
** sch_path: /foss/designs/lit_compac_sky/macros/gilbert_cell/schematic/xschem/gain_trim.sch
.subckt gain_trim t4p t4n vcm gt0 gt1 gt2 gt3 gt4 ptap
*.iopin t4p
*.iopin t4n
*.iopin vcm
*.ipin gt0
*.ipin gt1
*.ipin gt2
*.ipin gt3
*.ipin gt4
*.iopin ptap
XRS4P0 net1 t4p ptap sky130_fd_pr__res_high_po_5p73 L=0.875 mult=2 m=2
XRS4P1 net2 net1 ptap sky130_fd_pr__res_high_po_5p73 L=0.875 mult=2 m=2
XRS4P2 net3 net2 ptap sky130_fd_pr__res_high_po_5p73 L=0.875 mult=2 m=2
XRS4P3 net4 net3 ptap sky130_fd_pr__res_high_po_5p73 L=0.875 mult=2 m=2
XRS4P4 net5 net4 ptap sky130_fd_pr__res_high_po_5p73 L=0.875 mult=2 m=2
XRS4P5 net6 net5 ptap sky130_fd_pr__res_high_po_5p73 L=0.875 mult=2 m=2
XRS4P6 net7 net6 ptap sky130_fd_pr__res_high_po_5p73 L=0.875 mult=2 m=2
XRS4P7 t3p net7 ptap sky130_fd_pr__res_high_po_5p73 L=0.875 mult=2 m=2
XRS3P0 net8 t3p ptap sky130_fd_pr__res_high_po_5p73 L=0.875 mult=2 m=2
XRS3P1 net9 net8 ptap sky130_fd_pr__res_high_po_5p73 L=0.875 mult=2 m=2
XRS3P2 net10 net9 ptap sky130_fd_pr__res_high_po_5p73 L=0.875 mult=2 m=2
XRS3P3 t2p net10 ptap sky130_fd_pr__res_high_po_5p73 L=0.875 mult=2 m=2
XRS2P0 net11 t2p ptap sky130_fd_pr__res_high_po_5p73 L=0.875 mult=2 m=2
XRS2P1 t1p net11 ptap sky130_fd_pr__res_high_po_5p73 L=0.875 mult=2 m=2
XRS1P0 t0p t1p ptap sky130_fd_pr__res_high_po_5p73 L=0.875 mult=2 m=2
XRS0P vcm t0p ptap sky130_fd_pr__res_high_po_5p73 L=0.875 mult=4 m=4
XMSW4P t3p gt4 t4p ptap sky130_fd_pr__nfet_01v8_lvt L=0.35 W=7.365 nf=1 ad=2.13585 as=2.13585 pd=15.31 ps=15.31
+ nrd=0.0393754243041412 nrs=0.0393754243041412 sa=0 sb=0 sd=0 mult=1
XMSW3P t2p gt3 t3p ptap sky130_fd_pr__nfet_01v8_lvt L=0.35 W=14.73 nf=2 ad=2.13585 as=4.2717 pd=15.31 ps=30.62
+ nrd=0.0196877121520706 nrs=0.0196877121520706 sa=0 sb=0 sd=0 mult=1
XMSW2P t1p gt2 t2p ptap sky130_fd_pr__nfet_01v8_lvt L=0.35 W=29.46 nf=4 ad=4.2717 as=6.40755 pd=30.62 ps=45.93
+ nrd=0.0098438560760353 nrs=0.0098438560760353 sa=0 sb=0 sd=0 mult=1
XMSW1P t0p gt1 t1p ptap sky130_fd_pr__nfet_01v8_lvt L=0.35 W=58.92 nf=8 ad=8.5434 as=10.67925 pd=61.24 ps=76.55
+ nrd=0.00492192803801765 nrs=0.00492192803801765 sa=0 sb=0 sd=0 mult=1
XRS4N0 net12 t4n ptap sky130_fd_pr__res_high_po_5p73 L=0.875 mult=2 m=2
XRS4N1 net13 net12 ptap sky130_fd_pr__res_high_po_5p73 L=0.875 mult=2 m=2
XRS4N2 net14 net13 ptap sky130_fd_pr__res_high_po_5p73 L=0.875 mult=2 m=2
XRS4N3 net15 net14 ptap sky130_fd_pr__res_high_po_5p73 L=0.875 mult=2 m=2
XRS4N4 net16 net15 ptap sky130_fd_pr__res_high_po_5p73 L=0.875 mult=2 m=2
XRS4N5 net17 net16 ptap sky130_fd_pr__res_high_po_5p73 L=0.875 mult=2 m=2
XRS4N6 net18 net17 ptap sky130_fd_pr__res_high_po_5p73 L=0.875 mult=2 m=2
XRS4N7 t3n net18 ptap sky130_fd_pr__res_high_po_5p73 L=0.875 mult=2 m=2
XRS3N0 net19 t3n ptap sky130_fd_pr__res_high_po_5p73 L=0.875 mult=2 m=2
XRS3N1 net20 net19 ptap sky130_fd_pr__res_high_po_5p73 L=0.875 mult=2 m=2
XRS3N2 net21 net20 ptap sky130_fd_pr__res_high_po_5p73 L=0.875 mult=2 m=2
XRS3N3 t2n net21 ptap sky130_fd_pr__res_high_po_5p73 L=0.875 mult=2 m=2
XRS2N0 net22 t2n ptap sky130_fd_pr__res_high_po_5p73 L=0.875 mult=2 m=2
XRS2N1 t1n net22 ptap sky130_fd_pr__res_high_po_5p73 L=0.875 mult=2 m=2
XRS1N0 t0n t1n ptap sky130_fd_pr__res_high_po_5p73 L=0.875 mult=2 m=2
XRS0N vcm t0n ptap sky130_fd_pr__res_high_po_5p73 L=0.875 mult=4 m=4
XMSW4N t4n gt4 t3n ptap sky130_fd_pr__nfet_01v8_lvt L=0.35 W=7.365 nf=1 ad=2.13585 as=2.13585 pd=15.31 ps=15.31
+ nrd=0.0393754243041412 nrs=0.0393754243041412 sa=0 sb=0 sd=0 mult=1
XMSW3N t3n gt3 t2n ptap sky130_fd_pr__nfet_01v8_lvt L=0.35 W=14.73 nf=2 ad=2.13585 as=4.2717 pd=15.31 ps=30.62
+ nrd=0.0196877121520706 nrs=0.0196877121520706 sa=0 sb=0 sd=0 mult=1
XMSW2N t2n gt2 t1n ptap sky130_fd_pr__nfet_01v8_lvt L=0.35 W=29.46 nf=4 ad=4.2717 as=6.40755 pd=30.62 ps=45.93
+ nrd=0.0098438560760353 nrs=0.0098438560760353 sa=0 sb=0 sd=0 mult=1
XMSW1N t1n gt1 t0n ptap sky130_fd_pr__nfet_01v8_lvt L=0.35 W=58.92 nf=8 ad=8.5434 as=10.67925 pd=61.24 ps=76.55
+ nrd=0.00492192803801765 nrs=0.00492192803801765 sa=0 sb=0 sd=0 mult=1
XMSW0 t0p gt0 t0n ptap sky130_fd_pr__nfet_01v8_lvt L=0.35 W=58.92 nf=8 ad=8.5434 as=10.67925 pd=61.24 ps=76.55
+ nrd=0.00492192803801765 nrs=0.00492192803801765 sa=0 sb=0 sd=0 mult=1
XRDP ptap ptap ptap sky130_fd_pr__res_high_po_5p73 L=0.875 mult=6 m=6
XRDN ptap ptap ptap sky130_fd_pr__res_high_po_5p73 L=0.875 mult=6 m=6
XRDS ptap ptap ptap sky130_fd_pr__res_high_po_5p73 L=10.76 mult=8 m=8
XMDSP t4p t4p t4p ptap sky130_fd_pr__nfet_01v8_lvt L=0.35 W=7.365 nf=1 ad=2.13585 as=2.13585 pd=15.31 ps=15.31
+ nrd=0.0393754243041412 nrs=0.0393754243041412 sa=0 sb=0 sd=0 mult=1
XMDSN t4n t4n t4n ptap sky130_fd_pr__nfet_01v8_lvt L=0.35 W=7.365 nf=1 ad=2.13585 as=2.13585 pd=15.31 ps=15.31
+ nrd=0.0393754243041412 nrs=0.0393754243041412 sa=0 sb=0 sd=0 mult=1
.ends

.GLOBAL GND
.end
